* NGSPICE file created from slot4_wrapper.ext - technology: ihp-sg13g2

.subckt slot4_wrapper s4_an[0] s4_an_0_esd vbias dig_in[23] dig_in[22] dig_in[21]
+ dig_in[20] dig_in[19] dig_in[18] dig_in[17] dig_in[16] dig_in[15] dig_in[14] dig_in[13]
+ dig_in[12] dig_in[11] dig_in[10] dig_in[9] dig_in[8] dig_in[7] dig_in[6] dig_in[5]
+ dig_in[4] dig_in[3] dig_in[2] dig_in[1] dig_in[0] dig_out[11] dig_out[10] dig_out[9]
+ dig_out[8] dig_out[7] dig_out[6] dig_out[5] dig_out[4] dig_out[3] dig_out[2] dig_out[1]
+ dig_out[0] ibias0 ibias1 analog_bus3 analog_bus2 analog_bus1 enable clk reset analog_bus0
+ ibias s4_an vss_1v2 vdd_1v2 vss_3v3 vdd_3v3 vss1v2 vdd1v2 vss_1v2_uq0
X0 wind_comp_0.comparator_0.dynamic_pcell_0.DRN_NET_IH wind_comp_0.comparator_0.dynamic_pcell_0.DRN_NET_GJ_GATE_GH wind_comp_0.sg13g2_and2_2$1_0.VSS.t1 wind_comp_0.sg13g2_and2_2$1_0.VSS.t2 sg13_lv_nmos ad=55.5f pd=0.74u as=55.5f ps=0.74u w=0.15u l=3u
X1 wind_comp_0.sg13g2_and2_2$1_0.VDD.t193 wind_comp_0.sg13g2_and2_2$1_0.VDD.t192 wind_comp_0.comparator_0.dynamic_pcell_0.DRN_NET_GJ_GATE_GH wind_comp_0.comparator_0.dynamic_pcell_0.VDD sg13_lv_pmos ad=0.5928p pd=3.5u as=0.5928p ps=3.5u w=3.12u l=0.5u
X2 wind_comp_0.comparator_1.dynamic_pcell$2_0.DRN_NET_LM_GATE_KL wind_comp_0.sg13g2_and2_2$1_0.VDD.t226 wind_comp_0.sg13g2_and2_2$1_0.VDD.t224 wind_comp_0.comparator_1.dynamic_pcell$7_0.VDD sg13_lv_pmos ad=95f pd=0.88u as=95f ps=0.88u w=0.5u l=0.5u
X3 wind_comp_0.sg13g2_and2_2$1_0.VSS.t65 wind_comp_0.sg13g2_and2_2$1_0.VSS.t63 wind_comp_0.sg13g2_and2_2$1_0.VSS.t65 wind_comp_0.sg13g2_and2_2$1_0.VSS.t64 sg13_lv_nmos ad=55.5f pd=0.74u as=0 ps=0 w=0.15u l=0.5u
X4 wind_comp_0.comparator_1.dynamic_pcell$1_0.P_GATE wind_comp_0.comparator_1.dynamic_pcell$7_0.DRN_NET_CF_GATE_CD wind_comp_0.sg13g2_and2_2$1_0.VDD.t236 wind_comp_0.comparator_1.dynamic_pcell$7_0.VDD sg13_lv_pmos ad=66.49999f pd=0.73u as=66.49999f ps=0.73u w=0.35u l=1u
X5 wind_comp_0.sg13g2_and2_2$1_0.VSS.t329 a_51539_28086# analog_bus1 wind_comp_0.sg13g2_and2_2$1_0.VSS.t328 sg13_lv_nmos ad=0.2812p pd=2.24u as=0.1406p ps=1.12u w=0.74u l=0.13u
X6 wind_comp_0.comparator_0.sg13cmos5l_inv_16_0.A wind_comp_0.comparator_0.dynamic_pcell_0.DRN_NET_IH wind_comp_0.sg13g2_and2_2$1_0.VSS.t264 wind_comp_0.sg13g2_and2_2$1_0.VSS.t265 sg13_lv_nmos ad=0.1406p pd=1.12u as=0.1406p ps=1.12u w=0.74u l=0.13u
X7 wind_comp_0.sg13g2_and2_2$1_0.VSS.t45 wind_comp_0.sg13g2_and2_2$1_0.VSS.t43 wind_comp_0.sg13g2_and2_2$1_0.VSS.t41 wind_comp_0.sg13g2_and2_2$1_0.VSS.t24 sg13_lv_nmos ad=0.95p pd=5.38u as=0 ps=0 w=5u l=0.5u
X8 wind_comp_0.sg13g2_and2_2$1_0.VDD.t85 wind_comp_0.comparator_1.sg13cmos5l_inv_16_0.A wind_comp_0.sg13g2_and2_2$1_0.B wind_comp_0.comparator_1.dynamic_pcell$7_0.VDD sg13_lv_pmos ad=0.2128p pd=1.5u as=0.2128p ps=1.5u w=1.12u l=0.13u
X9 wind_comp_0.sg13g2_and2_2$1_0.VSS.t327 wind_comp_0.sg13g2_and2_2$1_0.B a_51633_28086# wind_comp_0.sg13g2_and2_2$1_0.VSS.t413 sg13_lv_nmos ad=0.1331p pd=1.12u as=0.1216p ps=1.02u w=0.64u l=0.13u
X10 wind_comp_0.comparator_0.sg13cmos5l_inv_16_0.A wind_comp_0.comparator_0.dynamic_pcell_0.DRN_NET_IH wind_comp_0.sg13g2_and2_2$1_0.VDD.t23 wind_comp_0.comparator_0.dynamic_pcell_0.VDD sg13_lv_pmos ad=0.2128p pd=1.5u as=0.2128p ps=1.5u w=1.12u l=0.13u
X11 wind_comp_0.sg13g2_and2_2$1_0.VDD.t81 wind_comp_0.comparator_1.sg13cmos5l_inv_16_0.A wind_comp_0.sg13g2_and2_2$1_0.B wind_comp_0.comparator_1.dynamic_pcell$7_0.VDD sg13_lv_pmos ad=0.2128p pd=1.5u as=0.2128p ps=1.5u w=1.12u l=0.13u
X12 wind_comp_0.sg13g2_and2_2$1_0.VDD.t160 wind_comp_0.sg13g2_and2_2$1_0.VDD.t164 wind_comp_0.sg13g2_and2_2$1_0.VDD.t165 wind_comp_0.comparator_1.dynamic_pcell$7_0.VDD sg13_lv_pmos ad=0.119p pd=1.38u as=0 ps=0 w=0.35u l=0.5u
X13 wind_comp_0.sg13g2_and2_2$1_0.VDD.t163 wind_comp_0.sg13g2_and2_2$1_0.VDD.t161 wind_comp_0.sg13g2_and2_2$1_0.VDD.t105 wind_comp_0.comparator_0.dynamic_pcell_0.VDD sg13_lv_pmos ad=66.49999f pd=0.73u as=0 ps=0 w=0.35u l=0.5u
X14 wind_comp_0.sg13g2_and2_2$1_0.VSS.t156 wind_comp_0.sg13g2_and2_2$1_0.VSS.t153 wind_comp_0.sg13g2_and2_2$1_0.VSS.t155 wind_comp_0.sg13g2_and2_2$1_0.VSS.t154 sg13_lv_nmos ad=0.1082p pd=1.34u as=0 ps=0 w=0.26u l=0.5u
X15 wind_comp_0.comparator_1.nmos_0.Gate enable.t2 wind_comp_0.sg13g2_and2_2$1_0.VDD.t101 wind_comp_0.comparator_1.dynamic_pcell$7_0.VDD sg13_lv_pmos ad=0.3808p pd=2.92u as=0.3808p ps=2.92u w=1.12u l=0.13u
X16 wind_comp_0.comparator_0.dynamic_pcell$7_0.DRN_NET_BE_GATE_AB wind_comp_0.comparator_0.dynamic_pcell$7_0.DRN_NET_BE_GATE_AB wind_comp_0.sg13g2_and2_2$1_0.VDD.t0 wind_comp_0.comparator_0.dynamic_pcell_0.VDD sg13_lv_pmos ad=0.119p pd=1.38u as=66.49999f ps=0.73u w=0.35u l=1u
X17 wind_comp_0.comparator_1.sg13cmos5l_inv_16_0.A wind_comp_0.comparator_1.dynamic_pcell_0.DRN_NET_IH wind_comp_0.sg13g2_and2_2$1_0.VDD.t47 wind_comp_0.comparator_1.dynamic_pcell$7_0.VDD sg13_lv_pmos ad=0.2128p pd=1.5u as=0.2128p ps=1.5u w=1.12u l=0.13u
X18 wind_comp_0.comparator_1.sg13cmos5l_inv_16_0.A wind_comp_0.comparator_1.dynamic_pcell_0.DRN_NET_IH wind_comp_0.sg13g2_and2_2$1_0.VDD.t36 wind_comp_0.comparator_1.dynamic_pcell$7_0.VDD sg13_lv_pmos ad=0.2128p pd=1.5u as=0.3808p ps=2.92u w=1.12u l=0.13u
X19 wind_comp_0.sg13g2_and2_2$1_0.VDD.t229 wind_comp_0.sg13g2_and2_2$1_0.VDD.t228 wind_comp_0.comparator_1.dynamic_pcell_0.SRC_NET_IJ wind_comp_0.comparator_1.dynamic_pcell$7_0.VDD sg13_lv_pmos ad=95f pd=0.88u as=95f ps=0.88u w=0.5u l=0.5u
X20 wind_comp_0.sg13g2_and2_2$1_0.VDD.t65 wind_comp_0.comparator_0.sg13cmos5l_inv_16_0.A wind_comp_0.sg13g2_and2_2$1_0.A wind_comp_0.comparator_0.dynamic_pcell_0.VDD sg13_lv_pmos ad=0.2128p pd=1.5u as=0.2128p ps=1.5u w=1.12u l=0.13u
X21 wind_comp_0.comparator_1.dynamic_pcell$2_0.DRN_NET_LM_GATE_KL enable.t8 wind_comp_0.sg13g2_and2_2$1_0.VDD.t99 wind_comp_0.comparator_1.dynamic_pcell$7_0.VDD sg13_lv_pmos ad=0.1005p pd=1.34u as=55.5f ps=0.74u w=0.15u l=0.13u
X22 wind_comp_0.sg13g2_and2_2$1_0.VDD.t61 wind_comp_0.comparator_0.sg13cmos5l_inv_16_0.A wind_comp_0.sg13g2_and2_2$1_0.A wind_comp_0.comparator_0.dynamic_pcell_0.VDD sg13_lv_pmos ad=0.2128p pd=1.5u as=0.2128p ps=1.5u w=1.12u l=0.13u
X23 wind_comp_0.comparator_0.dynamic_pcell_0.SRC_NET_IJ wind_comp_0.sg13g2_and2_2$1_0.VDD.t132 wind_comp_0.sg13g2_and2_2$1_0.VDD.t131 wind_comp_0.comparator_0.dynamic_pcell_0.VDD sg13_lv_pmos ad=95f pd=0.88u as=95f ps=0.88u w=0.5u l=0.5u
X24 wind_comp_0.comparator_0.sg13cmos5l_inv_16_0.A wind_comp_0.comparator_0.dynamic_pcell_0.DRN_NET_IH wind_comp_0.sg13g2_and2_2$1_0.VDD.t17 wind_comp_0.comparator_0.dynamic_pcell_0.VDD sg13_lv_pmos ad=0.2128p pd=1.5u as=0.2128p ps=1.5u w=1.12u l=0.13u
X25 wind_comp_0.sg13g2_and2_2$1_0.VSS.t166 wind_comp_0.sg13g2_and2_2$1_0.VSS.t164 wind_comp_0.sg13g2_and2_2$1_0.VSS.t165 wind_comp_0.sg13g2_and2_2$1_0.VSS.t154 sg13_lv_nmos ad=0.1082p pd=1.34u as=0 ps=0 w=0.26u l=0.5u
X26 wind_comp_0.sg13g2_and2_2$1_0.VSS.t98 wind_comp_0.sg13g2_and2_2$1_0.VSS.t101 wind_comp_0.comparator_1.dynamic_pcell$7_0.DRN_NET_CF_GATE_CD wind_comp_0.sg13g2_and2_2$1_0.VSS.t102 sg13_lv_nmos ad=63.19999f pd=0.74u as=63.19999f ps=0.74u w=0.26u l=0.5u
X27 wind_comp_0.sg13g2_and2_2$1_0.VSS.t319 wind_comp_0.comparator_1.dynamic_pcell_0.DRN_NET_IH wind_comp_0.comparator_1.sg13cmos5l_inv_16_0.A wind_comp_0.sg13g2_and2_2$1_0.VSS.t318 sg13_lv_nmos ad=0.1406p pd=1.12u as=0.1406p ps=1.12u w=0.74u l=0.13u
X28 wind_comp_0.sg13g2_and2_2$1_0.VDD.t25 wind_comp_0.comparator_0.dynamic_pcell_0.DRN_NET_IH wind_comp_0.comparator_0.sg13cmos5l_inv_16_0.A wind_comp_0.comparator_0.dynamic_pcell_0.VDD sg13_lv_pmos ad=0.3808p pd=2.92u as=0.2128p ps=1.5u w=1.12u l=0.13u
X29 wind_comp_0.sg13g2_and2_2$1_0.VSS.t313 wind_comp_0.comparator_1.dynamic_pcell_0.DRN_NET_IH wind_comp_0.comparator_1.sg13cmos5l_inv_16_0.A wind_comp_0.sg13g2_and2_2$1_0.VSS.t312 sg13_lv_nmos ad=0.1406p pd=1.12u as=0.1406p ps=1.12u w=0.74u l=0.13u
X30 wind_comp_0.comparator_0.nmos$2_0.Drain wind_comp_0.comparator_0.nmos$2_0.Drain wind_comp_0.sg13g2_and2_2$1_0.VSS.t289 wind_comp_0.sg13g2_and2_2$1_0.VSS.t285 sg13_lv_nmos ad=0.95p pd=5.38u as=0.95p ps=5.38u w=5u l=3u
X31 wind_comp_0.comparator_0.dynamic_pcell$2_0.O_DRN wind_comp_0.comparator_0.nmos$2_0.Drain wind_comp_0.sg13g2_and2_2$1_0.VSS.t50 wind_comp_0.sg13g2_and2_2$1_0.VSS.t283 sg13_lv_nmos ad=0.95p pd=5.38u as=0.95p ps=5.38u w=5u l=3u
X32 wind_comp_0.sg13g2_and2_2$1_0.A wind_comp_0.comparator_0.sg13cmos5l_inv_16_0.A wind_comp_0.sg13g2_and2_2$1_0.VSS.t352 wind_comp_0.sg13g2_and2_2$1_0.VSS.t353 sg13_lv_nmos ad=0.1406p pd=1.12u as=0.1406p ps=1.12u w=0.74u l=0.13u
X33 wind_comp_0.sg13g2_and2_2$1_0.VDD.t168 wind_comp_0.sg13g2_and2_2$1_0.VDD.t166 wind_comp_0.sg13g2_and2_2$1_0.VDD.t158 wind_comp_0.comparator_1.dynamic_pcell$7_0.VDD sg13_lv_pmos ad=66.49999f pd=0.73u as=0 ps=0 w=0.35u l=0.5u
X34 wind_comp_0.sg13g2_and2_2$1_0.VDD.t21 wind_comp_0.comparator_0.dynamic_pcell_0.DRN_NET_IH wind_comp_0.comparator_0.sg13cmos5l_inv_16_0.A wind_comp_0.comparator_0.dynamic_pcell_0.VDD sg13_lv_pmos ad=0.2128p pd=1.5u as=0.2128p ps=1.5u w=1.12u l=0.13u
X35 wind_comp_0.sg13g2_and2_2$1_0.VDD.t33 wind_comp_0.sg13g2_and2_2$1_0.VDD.t217 wind_comp_0.sg13g2_and2_2$1_0.VDD.t215 wind_comp_0.comparator_1.dynamic_pcell$7_0.VDD sg13_lv_pmos ad=95f pd=0.88u as=0 ps=0 w=0.5u l=0.5u
X36 wind_comp_0.sg13g2_and2_2$1_0.VSS.t307 wind_comp_0.comparator_1.dynamic_pcell_0.DRN_NET_IH wind_comp_0.comparator_1.sg13cmos5l_inv_16_0.A wind_comp_0.sg13g2_and2_2$1_0.VSS.t297 sg13_lv_nmos ad=0.1406p pd=1.12u as=0.1406p ps=1.12u w=0.74u l=0.13u
X37 wind_comp_0.comparator_0.dynamic_pcell$1_0.DRN_NET_PQ_GATE_Q wind_comp_0.comparator_0.dynamic_pcell$1_0.DRN_NET_PQ_GATE_Q wind_comp_0.sg13g2_and2_2$1_0.VSS.t276 wind_comp_0.sg13g2_and2_2$1_0.VSS.t275 sg13_lv_nmos ad=63.19999f pd=0.74u as=63.19999f ps=0.74u w=0.26u l=10u
X38 wind_comp_0.sg13g2_and2_2$1_0.B wind_comp_0.comparator_1.sg13cmos5l_inv_16_0.A wind_comp_0.sg13g2_and2_2$1_0.VDD.t77 wind_comp_0.comparator_1.dynamic_pcell$7_0.VDD sg13_lv_pmos ad=0.2128p pd=1.5u as=0.2128p ps=1.5u w=1.12u l=0.13u
X39 wind_comp_0.sg13g2_and2_2$1_0.VSS.t393 wind_comp_0.comparator_1.nmos_0.Gate wind_comp_0.comparator_1.dynamic_pcell_0.DRN_NET_GJ_GATE_GH wind_comp_0.sg13g2_and2_2$1_0.VSS.t392 sg13_lv_nmos ad=55.5f pd=0.74u as=0.1005p ps=1.34u w=0.15u l=0.13u
X40 wind_comp_0.sg13g2_and2_2$1_0.VSS.t261 wind_comp_0.comparator_0.dynamic_pcell_0.DRN_NET_IH wind_comp_0.comparator_0.sg13cmos5l_inv_16_0.A wind_comp_0.sg13g2_and2_2$1_0.VSS.t260 sg13_lv_nmos ad=0.1406p pd=1.12u as=0.1406p ps=1.12u w=0.74u l=0.13u
X41 wind_comp_0.sg13g2_and2_2$1_0.VSS.t284 wind_comp_0.comparator_0.nmos$2_0.Drain wind_comp_0.comparator_0.nmos$2_0.Drain wind_comp_0.sg13g2_and2_2$1_0.VSS.t283 sg13_lv_nmos ad=0.95p pd=5.38u as=0.95p ps=5.38u w=5u l=3u
X42 wind_comp_0.sg13g2_and2_2$1_0.VSS.t298 wind_comp_0.comparator_1.dynamic_pcell$1_0.P_GATE wind_comp_0.comparator_1.dynamic_pcell$1_0.DRN_NET_PQ_GATE_Q wind_comp_0.sg13g2_and2_2$1_0.VSS.t299 sg13_lv_nmos ad=63.19999f pd=0.74u as=63.19999f ps=0.74u w=0.26u l=10u
X43 wind_comp_0.comparator_1.dynamic_pcell_0.SRC_NET_IJ wind_comp_0.comparator_1.dynamic_pcell$2_0.DRN_NET_LM_GATE_KL wind_comp_0.sg13g2_and2_2$1_0.VDD.t30 wind_comp_0.comparator_1.dynamic_pcell$7_0.VDD sg13_lv_pmos ad=95f pd=0.88u as=95f ps=0.88u w=0.5u l=3u
X44 wind_comp_0.sg13g2_and2_2$1_0.VSS.t255 wind_comp_0.comparator_0.dynamic_pcell_0.DRN_NET_IH wind_comp_0.comparator_0.sg13cmos5l_inv_16_0.A wind_comp_0.sg13g2_and2_2$1_0.VSS.t254 sg13_lv_nmos ad=0.1406p pd=1.12u as=0.1406p ps=1.12u w=0.74u l=0.13u
X45 wind_comp_0.sg13g2_and2_2$1_0.VDD.t54 wind_comp_0.comparator_0.dynamic_pcell$2_0.DRN_NET_LM_GATE_KL wind_comp_0.comparator_0.dynamic_pcell$2_0.DRN_NET_LM_GATE_KL wind_comp_0.comparator_0.dynamic_pcell_0.VDD sg13_lv_pmos ad=95f pd=0.88u as=95f ps=0.88u w=0.5u l=3u
X46 wind_comp_0.comparator_1.dynamic_pcell_0.DRN_NET_GJ_GATE_GH wind_comp_0.comparator_1.dynamic_pcell$1_0.P_GATE wind_comp_0.comparator_1.dynamic_pcell_0.SRC_NET_IJ wind_comp_0.comparator_1.dynamic_pcell$7_0.VDD sg13_lv_pmos ad=0.5928p pd=3.5u as=0.5928p ps=3.5u w=3.12u l=1u
X47 wind_comp_0.sg13g2_and2_2$1_0.VDD.t136 wind_comp_0.sg13g2_and2_2$1_0.VDD.t134 wind_comp_0.sg13g2_and2_2$1_0.VDD.t135 wind_comp_0.comparator_0.dynamic_pcell_0.VDD sg13_lv_pmos ad=1.0608p pd=6.92u as=0 ps=0 w=3.12u l=0.5u
X48 wind_comp_0.comparator_1.dynamic_pcell$1_0.P_GATE wind_comp_0.sg13g2_and2_2$1_0.VSS.t215 wind_comp_0.sg13g2_and2_2$1_0.VSS.t178 wind_comp_0.sg13g2_and2_2$1_0.VSS.t196 sg13_lv_nmos ad=63.19999f pd=0.74u as=63.19999f ps=0.74u w=0.26u l=0.5u
X49 wind_comp_0.comparator_1.dynamic_pcell_0.DRN_NET_IH wind_comp_0.comparator_1.dynamic_pcell$1_0.DRN_NET_PQ_GATE_Q wind_comp_0.comparator_1.dynamic_pcell_0.SRC_NET_IJ wind_comp_0.comparator_1.dynamic_pcell$7_0.VDD sg13_lv_pmos ad=0.5928p pd=3.5u as=0.5928p ps=3.5u w=3.12u l=1u
X50 wind_comp_0.sg13g2_and2_2$1_0.VDD.t189 wind_comp_0.sg13g2_and2_2$1_0.VDD.t187 wind_comp_0.sg13g2_and2_2$1_0.VDD.t188 wind_comp_0.comparator_0.dynamic_pcell_0.VDD sg13_lv_pmos ad=1.0608p pd=6.92u as=0 ps=0 w=3.12u l=0.5u
X51 wind_comp_0.sg13g2_and2_2$1_0.VSS.t190 wind_comp_0.sg13g2_and2_2$1_0.VSS.t191 wind_comp_0.sg13g2_and2_2$1_0.VSS.t190 wind_comp_0.sg13g2_and2_2$1_0.VSS.t163 sg13_lv_nmos ad=63.19999f pd=0.74u as=0 ps=0 w=0.26u l=0.5u
X52 wind_comp_0.comparator_0.dynamic_pcell$7_0.DRN_NET_BE_GATE_AB wind_comp_0.sg13g2_and2_2$1_0.VSS.t90 wind_comp_0.sg13g2_and2_2$1_0.VSS.t89 wind_comp_0.sg13g2_and2_2$1_0.VSS.t82 sg13_lv_nmos ad=63.19999f pd=0.74u as=63.19999f ps=0.74u w=0.26u l=0.5u
X53 wind_comp_0.sg13g2_and2_2$1_0.VSS.t388 wind_comp_0.comparator_1.sg13cmos5l_inv_16_0.A wind_comp_0.sg13g2_and2_2$1_0.B wind_comp_0.sg13g2_and2_2$1_0.VSS.t387 sg13_lv_nmos ad=0.1406p pd=1.12u as=0.1406p ps=1.12u w=0.74u l=0.13u
X54 wind_comp_0.sg13g2_and2_2$1_0.VSS.t149 wind_comp_0.sg13g2_and2_2$1_0.VSS.t148 wind_comp_0.comparator_0.nmos$2_0.Drain wind_comp_0.sg13g2_and2_2$1_0.VSS.t21 sg13_lv_nmos ad=0.95p pd=5.38u as=0.95p ps=5.38u w=5u l=0.5u
X55 wind_comp_0.sg13g2_and2_2$1_0.VDD.t52 wind_comp_0.sg13g2_and2_2$1_0.B a_51539_28086# wind_comp_0.sg13g2_and2_2$1_0.VDD.t4 sg13_lv_pmos ad=0.1918p pd=1.5u as=0.1596p ps=1.22u w=0.84u l=0.13u
X56 wind_comp_0.sg13g2_and2_2$1_0.VDD.t34 wind_comp_0.sg13g2_and2_2$1_0.VDD.t219 wind_comp_0.sg13g2_and2_2$1_0.VDD.t220 wind_comp_0.comparator_1.dynamic_pcell$7_0.VDD sg13_lv_pmos ad=95f pd=0.88u as=0 ps=0 w=0.5u l=0.5u
X57 wind_comp_0.sg13g2_and2_2$1_0.VSS.t301 wind_comp_0.comparator_1.dynamic_pcell$1_0.P_GATE wind_comp_0.comparator_1.dynamic_pcell$1_0.P_GATE wind_comp_0.sg13g2_and2_2$1_0.VSS.t299 sg13_lv_nmos ad=63.19999f pd=0.74u as=63.19999f ps=0.74u w=0.26u l=10u
X58 wind_comp_0.sg13g2_and2_2$1_0.VDD.t1 wind_comp_0.comparator_0.dynamic_pcell$7_0.DRN_NET_BE_GATE_AB wind_comp_0.comparator_0.dynamic_pcell$7_0.DRN_NET_BE_GATE_AB wind_comp_0.comparator_0.dynamic_pcell_0.VDD sg13_lv_pmos ad=66.49999f pd=0.73u as=0.119p ps=1.38u w=0.35u l=1u
X59 wind_comp_0.sg13g2_and2_2$1_0.VSS.t355 wind_comp_0.comparator_0.sg13cmos5l_inv_16_0.A wind_comp_0.sg13g2_and2_2$1_0.A wind_comp_0.sg13g2_and2_2$1_0.VSS.t354 sg13_lv_nmos ad=0.1406p pd=1.12u as=0.1406p ps=1.12u w=0.74u l=0.13u
X60 wind_comp_0.comparator_0.dynamic_pcell_0.DRN_NET_GJ_GATE_GH wind_comp_0.comparator_0.nmos_0.Gate wind_comp_0.sg13g2_and2_2$1_0.VSS.t247 wind_comp_0.sg13g2_and2_2$1_0.VSS.t246 sg13_lv_nmos ad=0.1005p pd=1.34u as=55.5f ps=0.74u w=0.15u l=0.13u
X61 wind_comp_0.sg13g2_and2_2$1_0.VDD.t95 enable.t13 wind_comp_0.comparator_0.dynamic_pcell$2_0.DRN_NET_LM_GATE_KL wind_comp_0.comparator_0.dynamic_pcell_0.VDD sg13_lv_pmos ad=55.5f pd=0.74u as=0.1005p ps=1.34u w=0.15u l=0.13u
X62 wind_comp_0.sg13g2_and2_2$1_0.VDD.t56 wind_comp_0.sg13g2_and2_2$1_0.VDD.t124 wind_comp_0.sg13g2_and2_2$1_0.VDD.t123 wind_comp_0.comparator_0.dynamic_pcell_0.VDD sg13_lv_pmos ad=95f pd=0.88u as=0 ps=0 w=0.5u l=0.5u
X63 wind_comp_0.sg13g2_and2_2$1_0.VSS.t349 wind_comp_0.comparator_0.sg13cmos5l_inv_16_0.A wind_comp_0.sg13g2_and2_2$1_0.A wind_comp_0.sg13g2_and2_2$1_0.VSS.t348 sg13_lv_nmos ad=0.1406p pd=1.12u as=0.1406p ps=1.12u w=0.74u l=0.13u
X64 wind_comp_0.sg13g2_and2_2$1_0.VSS.t124 wind_comp_0.sg13g2_and2_2$1_0.VSS.t122 wind_comp_0.sg13g2_and2_2$1_0.VSS.t123 wind_comp_0.sg13g2_and2_2$1_0.VSS.t112 sg13_lv_nmos ad=0.1005p pd=1.34u as=0 ps=0 w=0.15u l=0.5u
X65 wind_comp_0.comparator_1.dynamic_pcell$1_0.DRN_NET_PQ_GATE_Q wind_comp_0.sg13g2_and2_2$1_0.VDD.t172 wind_comp_0.sg13g2_and2_2$1_0.VDD.t170 wind_comp_0.comparator_1.dynamic_pcell$7_0.VDD sg13_lv_pmos ad=66.49999f pd=0.73u as=66.49999f ps=0.73u w=0.35u l=0.5u
X66 wind_comp_0.comparator_1.sg13cmos5l_inv_16_0.A wind_comp_0.comparator_1.dynamic_pcell_0.DRN_NET_IH wind_comp_0.sg13g2_and2_2$1_0.VDD.t43 wind_comp_0.comparator_1.dynamic_pcell$7_0.VDD sg13_lv_pmos ad=0.2128p pd=1.5u as=0.2128p ps=1.5u w=1.12u l=0.13u
X67 wind_comp_0.sg13g2_and2_2$1_0.VSS.t278 wind_comp_0.comparator_0.dynamic_pcell$1_0.P_GATE wind_comp_0.comparator_0.dynamic_pcell$1_0.P_GATE wind_comp_0.sg13g2_and2_2$1_0.VSS.t268 sg13_lv_nmos ad=63.19999f pd=0.74u as=63.19999f ps=0.74u w=0.26u l=10u
X68 wind_comp_0.sg13g2_and2_2$1_0.VDD.t186 wind_comp_0.sg13g2_and2_2$1_0.VDD.t184 wind_comp_0.sg13g2_and2_2$1_0.VDD.t156 wind_comp_0.comparator_1.dynamic_pcell$7_0.VDD sg13_lv_pmos ad=0.5928p pd=3.5u as=0 ps=0 w=3.12u l=0.5u
X69 wind_comp_0.sg13g2_and2_2$1_0.VDD.t202 wind_comp_0.sg13g2_and2_2$1_0.VDD.t203 wind_comp_0.sg13g2_and2_2$1_0.VDD.t204 wind_comp_0.comparator_1.dynamic_pcell$7_0.VDD sg13_lv_pmos ad=0.5928p pd=3.5u as=0 ps=0 w=3.12u l=0.5u
X70 wind_comp_0.comparator_1.sg13cmos5l_inv_16_0.A wind_comp_0.comparator_1.dynamic_pcell_0.DRN_NET_IH wind_comp_0.sg13g2_and2_2$1_0.VDD.t39 wind_comp_0.comparator_1.dynamic_pcell$7_0.VDD sg13_lv_pmos ad=0.2128p pd=1.5u as=0.2128p ps=1.5u w=1.12u l=0.13u
X71 wind_comp_0.sg13g2_and2_2$1_0.VSS.t365 wind_comp_0.comparator_1.nmos$2_0.Drain wind_comp_0.comparator_1.nmos$2_0.Drain wind_comp_0.sg13g2_and2_2$1_0.VSS.t359 sg13_lv_nmos ad=0.95p pd=5.38u as=0.95p ps=5.38u w=5u l=3u
X72 wind_comp_0.comparator_0.sg13cmos5l_inv_16_0.A wind_comp_0.comparator_0.dynamic_pcell_0.DRN_NET_IH wind_comp_0.sg13g2_and2_2$1_0.VSS.t250 wind_comp_0.sg13g2_and2_2$1_0.VSS.t249 sg13_lv_nmos ad=0.1406p pd=1.12u as=0.2516p ps=2.16u w=0.74u l=0.13u
X73 wind_comp_0.comparator_0.nmos$2_0.Drain enable.t1 ibias wind_comp_0.sg13g2_and2_2$1_0.VSS.t408 sg13_lv_nmos ad=55.5f pd=0.74u as=55.5f ps=0.74u w=0.15u l=0.13u
X74 wind_comp_0.comparator_0.sg13cmos5l_inv_16_0.A wind_comp_0.comparator_0.dynamic_pcell_0.DRN_NET_IH wind_comp_0.sg13g2_and2_2$1_0.VDD.t13 wind_comp_0.comparator_0.dynamic_pcell_0.VDD sg13_lv_pmos ad=0.2128p pd=1.5u as=0.2128p ps=1.5u w=1.12u l=0.13u
X75 wind_comp_0.sg13g2_and2_2$1_0.VDD.t34 wind_comp_0.comparator_1.dynamic_pcell$2_0.DRN_NET_LM_GATE_KL wind_comp_0.comparator_1.dynamic_pcell_0.SRC_NET_IJ wind_comp_0.comparator_1.dynamic_pcell$7_0.VDD sg13_lv_pmos ad=95f pd=0.88u as=95f ps=0.88u w=0.5u l=3u
X76 wind_comp_0.sg13g2_and2_2$1_0.VDD.t152 wind_comp_0.sg13g2_and2_2$1_0.VDD.t150 wind_comp_0.sg13g2_and2_2$1_0.VDD.t151 wind_comp_0.comparator_0.dynamic_pcell_0.VDD sg13_lv_pmos ad=0.119p pd=1.38u as=0 ps=0 w=0.35u l=0.5u
X77 wind_comp_0.sg13g2_and2_2$1_0.VDD.t107 wind_comp_0.sg13g2_and2_2$1_0.VDD.t115 wind_comp_0.sg13g2_and2_2$1_0.VDD.t116 wind_comp_0.comparator_0.dynamic_pcell_0.VDD sg13_lv_pmos ad=95f pd=0.88u as=0 ps=0 w=0.5u l=0.5u
X78 wind_comp_0.sg13g2_and2_2$1_0.B wind_comp_0.comparator_1.sg13cmos5l_inv_16_0.A wind_comp_0.sg13g2_and2_2$1_0.VDD.t89 wind_comp_0.comparator_1.dynamic_pcell$7_0.VDD sg13_lv_pmos ad=0.2128p pd=1.5u as=0.2128p ps=1.5u w=1.12u l=0.13u
X79 wind_comp_0.sg13g2_and2_2$1_0.VSS.t42 wind_comp_0.comparator_0.nmos$2_0.Drain wind_comp_0.comparator_0.dynamic_pcell$2_0.O_DRN wind_comp_0.sg13g2_and2_2$1_0.VSS.t285 sg13_lv_nmos ad=0.95p pd=5.38u as=0.95p ps=5.38u w=5u l=3u
X80 wind_comp_0.sg13g2_and2_2$1_0.VSS.t222 wind_comp_0.sg13g2_and2_2$1_0.VSS.t221 wind_comp_0.sg13g2_and2_2$1_0.VSS.t222 wind_comp_0.sg13g2_and2_2$1_0.VSS.t201 sg13_lv_nmos ad=63.19999f pd=0.74u as=0 ps=0 w=0.26u l=0.5u
X81 wind_comp_0.sg13g2_and2_2$1_0.B wind_comp_0.comparator_1.sg13cmos5l_inv_16_0.A wind_comp_0.sg13g2_and2_2$1_0.VDD.t85 wind_comp_0.comparator_1.dynamic_pcell$7_0.VDD sg13_lv_pmos ad=0.2128p pd=1.5u as=0.2128p ps=1.5u w=1.12u l=0.13u
X82 wind_comp_0.sg13g2_and2_2$1_0.VSS.t117 wind_comp_0.sg13g2_and2_2$1_0.VSS.t120 wind_comp_0.sg13g2_and2_2$1_0.VSS.t117 wind_comp_0.sg13g2_and2_2$1_0.VSS.t121 sg13_lv_nmos ad=55.5f pd=0.74u as=0 ps=0 w=0.15u l=0.5u
X83 wind_comp_0.comparator_0.dynamic_pcell$7_0.DRN_NET_BE_GATE_AB enable.t11 wind_comp_0.sg13g2_and2_2$1_0.VDD.t97 wind_comp_0.comparator_0.dynamic_pcell_0.VDD sg13_lv_pmos ad=0.1005p pd=1.34u as=0.1005p ps=1.34u w=0.15u l=0.13u
X84 wind_comp_0.sg13g2_and2_2$1_0.VSS.t245 wind_comp_0.sg13g2_and2_2$1_0.VSS.t243 wind_comp_0.sg13g2_and2_2$1_0.VSS.t240 wind_comp_0.sg13g2_and2_2$1_0.VSS.t32 sg13_lv_nmos ad=0.95p pd=5.38u as=0 ps=0 w=5u l=0.5u
X85 wind_comp_0.sg13g2_and2_2$1_0.A wind_comp_0.comparator_0.sg13cmos5l_inv_16_0.A wind_comp_0.sg13g2_and2_2$1_0.VDD.t73 wind_comp_0.comparator_0.dynamic_pcell_0.VDD sg13_lv_pmos ad=0.2128p pd=1.5u as=0.2128p ps=1.5u w=1.12u l=0.13u
X86 wind_comp_0.comparator_1.dynamic_pcell$7_0.DRN_NET_BE_GATE_AB wind_comp_0.sg13g2_and2_2$1_0.VSS.t99 wind_comp_0.sg13g2_and2_2$1_0.VSS.t17 wind_comp_0.sg13g2_and2_2$1_0.VSS.t100 sg13_lv_nmos ad=63.19999f pd=0.74u as=63.19999f ps=0.74u w=0.26u l=0.5u
X87 wind_comp_0.sg13g2_and2_2$1_0.VDD.t41 wind_comp_0.comparator_1.dynamic_pcell_0.DRN_NET_IH wind_comp_0.comparator_1.sg13cmos5l_inv_16_0.A wind_comp_0.comparator_1.dynamic_pcell$7_0.VDD sg13_lv_pmos ad=0.2128p pd=1.5u as=0.2128p ps=1.5u w=1.12u l=0.13u
X88 wind_comp_0.sg13g2_and2_2$1_0.A wind_comp_0.comparator_0.sg13cmos5l_inv_16_0.A wind_comp_0.sg13g2_and2_2$1_0.VDD.t69 wind_comp_0.comparator_0.dynamic_pcell_0.VDD sg13_lv_pmos ad=0.2128p pd=1.5u as=0.2128p ps=1.5u w=1.12u l=0.13u
X89 wind_comp_0.sg13g2_and2_2$1_0.VSS.t182 wind_comp_0.sg13g2_and2_2$1_0.VSS.t181 wind_comp_0.comparator_0.dynamic_pcell$1_0.P_GATE wind_comp_0.sg13g2_and2_2$1_0.VSS.t160 sg13_lv_nmos ad=63.19999f pd=0.74u as=63.19999f ps=0.74u w=0.26u l=0.5u
X90 wind_comp_0.sg13g2_and2_2$1_0.VSS.t145 wind_comp_0.sg13g2_and2_2$1_0.VSS.t143 wind_comp_0.sg13g2_and2_2$1_0.VSS.t144 wind_comp_0.sg13g2_and2_2$1_0.VSS.t8 sg13_lv_nmos ad=1.7p pd=10.68u as=0 ps=0 w=5u l=0.5u
X91 wind_comp_0.comparator_0.dynamic_pcell_0.DRN_NET_GJ_GATE_GH wind_comp_0.sg13g2_and2_2$1_0.VSS.t54 wind_comp_0.sg13g2_and2_2$1_0.VSS.t56 wind_comp_0.sg13g2_and2_2$1_0.VSS.t55 sg13_lv_nmos ad=55.5f pd=0.74u as=55.5f ps=0.74u w=0.15u l=0.5u
X92 wind_comp_0.sg13g2_and2_2$1_0.VSS.t3 wind_comp_0.comparator_0.dynamic_pcell_0.DRN_NET_GJ_GATE_GH wind_comp_0.comparator_0.dynamic_pcell_0.DRN_NET_IH wind_comp_0.sg13g2_and2_2$1_0.VSS.t0 sg13_lv_nmos ad=55.5f pd=0.74u as=55.5f ps=0.74u w=0.15u l=3u
X93 wind_comp_0.sg13g2_and2_2$1_0.VDD.t15 wind_comp_0.comparator_0.dynamic_pcell_0.DRN_NET_IH wind_comp_0.comparator_0.sg13cmos5l_inv_16_0.A wind_comp_0.comparator_0.dynamic_pcell_0.VDD sg13_lv_pmos ad=0.2128p pd=1.5u as=0.2128p ps=1.5u w=1.12u l=0.13u
X94 wind_comp_0.sg13g2_and2_2$1_0.VSS.t382 wind_comp_0.comparator_1.sg13cmos5l_inv_16_0.A wind_comp_0.sg13g2_and2_2$1_0.B wind_comp_0.sg13g2_and2_2$1_0.VSS.t381 sg13_lv_nmos ad=0.1406p pd=1.12u as=0.1406p ps=1.12u w=0.74u l=0.13u
X95 wind_comp_0.comparator_0.dynamic_pcell$1_0.P_GATE wind_comp_0.sg13g2_and2_2$1_0.VSS.t179 wind_comp_0.sg13g2_and2_2$1_0.VSS.t174 wind_comp_0.sg13g2_and2_2$1_0.VSS.t158 sg13_lv_nmos ad=63.19999f pd=0.74u as=63.19999f ps=0.74u w=0.26u l=0.5u
X96 wind_comp_0.comparator_0.sg13cmos5l_inv_16_0.A wind_comp_0.comparator_0.dynamic_pcell_0.DRN_NET_IH wind_comp_0.sg13g2_and2_2$1_0.VSS.t270 wind_comp_0.sg13g2_and2_2$1_0.VSS.t2 sg13_lv_nmos ad=0.1406p pd=1.12u as=0.1406p ps=1.12u w=0.74u l=0.13u
X97 wind_comp_0.sg13g2_and2_2$1_0.VSS.t108 wind_comp_0.sg13g2_and2_2$1_0.VSS.t109 wind_comp_0.sg13g2_and2_2$1_0.VSS.t108 wind_comp_0.sg13g2_and2_2$1_0.VSS.t97 sg13_lv_nmos ad=63.19999f pd=0.74u as=0 ps=0 w=0.26u l=0.5u
X98 wind_comp_0.sg13g2_and2_2$1_0.VDD.t11 wind_comp_0.comparator_0.dynamic_pcell_0.DRN_NET_IH wind_comp_0.comparator_0.sg13cmos5l_inv_16_0.A wind_comp_0.comparator_0.dynamic_pcell_0.VDD sg13_lv_pmos ad=0.2128p pd=1.5u as=0.2128p ps=1.5u w=1.12u l=0.13u
X99 wind_comp_0.sg13g2_and2_2$1_0.VSS.t376 wind_comp_0.comparator_1.sg13cmos5l_inv_16_0.A wind_comp_0.sg13g2_and2_2$1_0.B wind_comp_0.sg13g2_and2_2$1_0.VSS.t375 sg13_lv_nmos ad=0.1406p pd=1.12u as=0.1406p ps=1.12u w=0.74u l=0.13u
X100 wind_comp_0.sg13g2_and2_2$1_0.VSS.t42 wind_comp_0.sg13g2_and2_2$1_0.VSS.t40 wind_comp_0.sg13g2_and2_2$1_0.VSS.t41 wind_comp_0.sg13g2_and2_2$1_0.VSS.t21 sg13_lv_nmos ad=0.95p pd=5.38u as=0 ps=0 w=5u l=0.5u
X101 wind_comp_0.comparator_0.dynamic_pcell$2_0.O_DRN analog_bus2 wind_comp_0.comparator_0.dynamic_pcell$7_0.DRN_NET_CF_GATE_CD wind_comp_0.sg13g2_and2_2$1_0.VSS.t395 sg13_lv_nmos ad=63.19999f pd=0.74u as=63.19999f ps=0.74u w=0.26u l=3u
X102 wind_comp_0.sg13g2_and2_2$1_0.VSS.t238 wind_comp_0.sg13g2_and2_2$1_0.VSS.t236 wind_comp_0.sg13g2_and2_2$1_0.VSS.t237 wind_comp_0.sg13g2_and2_2$1_0.VSS.t12 sg13_lv_nmos ad=1.7p pd=10.68u as=0 ps=0 w=5u l=0.5u
X103 wind_comp_0.sg13g2_and2_2$1_0.VSS.t229 wind_comp_0.sg13g2_and2_2$1_0.VSS.t227 wind_comp_0.sg13g2_and2_2$1_0.VSS.t214 wind_comp_0.sg13g2_and2_2$1_0.VSS.t30 sg13_lv_nmos ad=0.95p pd=5.38u as=0 ps=0 w=5u l=0.5u
X104 wind_comp_0.comparator_1.sg13cmos5l_inv_16_0.A wind_comp_0.comparator_1.dynamic_pcell_0.DRN_NET_IH wind_comp_0.sg13g2_and2_2$1_0.VSS.t319 wind_comp_0.sg13g2_and2_2$1_0.VSS.t320 sg13_lv_nmos ad=0.1406p pd=1.12u as=0.1406p ps=1.12u w=0.74u l=0.13u
X105 wind_comp_0.comparator_1.sg13cmos5l_inv_16_0.A wind_comp_0.comparator_1.dynamic_pcell_0.DRN_NET_IH wind_comp_0.sg13g2_and2_2$1_0.VSS.t304 wind_comp_0.sg13g2_and2_2$1_0.VSS.t303 sg13_lv_nmos ad=0.1406p pd=1.12u as=0.2516p ps=2.16u w=0.74u l=0.13u
X106 wind_comp_0.sg13g2_and2_2$1_0.VSS.t343 wind_comp_0.comparator_0.sg13cmos5l_inv_16_0.A wind_comp_0.sg13g2_and2_2$1_0.A wind_comp_0.sg13g2_and2_2$1_0.VSS.t342 sg13_lv_nmos ad=0.1406p pd=1.12u as=0.1406p ps=1.12u w=0.74u l=0.13u
X107 wind_comp_0.sg13g2_and2_2$1_0.VDD.t234 wind_comp_0.comparator_1.dynamic_pcell$7_0.DRN_NET_CF_GATE_CD wind_comp_0.comparator_1.dynamic_pcell$1_0.P_GATE wind_comp_0.comparator_1.dynamic_pcell$7_0.VDD sg13_lv_pmos ad=66.49999f pd=0.73u as=66.49999f ps=0.73u w=0.35u l=1u
X108 wind_comp_0.sg13g2_and2_2$1_0.VSS.t337 wind_comp_0.comparator_0.sg13cmos5l_inv_16_0.A wind_comp_0.sg13g2_and2_2$1_0.A wind_comp_0.sg13g2_and2_2$1_0.VSS.t336 sg13_lv_nmos ad=0.1406p pd=1.12u as=0.1406p ps=1.12u w=0.74u l=0.13u
X109 wind_comp_0.comparator_1.dynamic_pcell$2_0.DRN_NET_LM_GATE_KL wind_comp_0.sg13g2_and2_2$1_0.VSS.t29 wind_comp_0.sg13g2_and2_2$1_0.VSS.t14 wind_comp_0.sg13g2_and2_2$1_0.VSS.t30 sg13_lv_nmos ad=0.95p pd=5.38u as=0.95p ps=5.38u w=5u l=0.5u
X110 ibias enable.t0 wind_comp_0.comparator_1.nmos$2_0.Drain wind_comp_0.sg13g2_and2_2$1_0.VSS.t411 sg13_lv_nmos ad=55.5f pd=0.74u as=55.5f ps=0.74u w=0.15u l=0.13u
X111 wind_comp_0.sg13g2_and2_2$1_0.VDD.t128 wind_comp_0.sg13g2_and2_2$1_0.VDD.t126 wind_comp_0.sg13g2_and2_2$1_0.VDD.t114 wind_comp_0.comparator_0.dynamic_pcell_0.VDD sg13_lv_pmos ad=95f pd=0.88u as=0 ps=0 w=0.5u l=0.5u
X112 wind_comp_0.comparator_1.dynamic_pcell_0.DRN_NET_GJ_GATE_GH wind_comp_0.sg13g2_and2_2$1_0.VDD.t199 wind_comp_0.sg13g2_and2_2$1_0.VDD.t197 wind_comp_0.comparator_1.dynamic_pcell$7_0.VDD sg13_lv_pmos ad=0.5928p pd=3.5u as=0.5928p ps=3.5u w=3.12u l=0.5u
X113 wind_comp_0.comparator_1.dynamic_pcell_0.DRN_NET_IH wind_comp_0.sg13g2_and2_2$1_0.VDD.t182 wind_comp_0.sg13g2_and2_2$1_0.VDD.t180 wind_comp_0.comparator_1.dynamic_pcell$7_0.VDD sg13_lv_pmos ad=0.5928p pd=3.5u as=0.5928p ps=3.5u w=3.12u l=0.5u
X114 wind_comp_0.comparator_0.sg13cmos5l_inv_16_0.A wind_comp_0.comparator_0.dynamic_pcell_0.DRN_NET_IH wind_comp_0.sg13g2_and2_2$1_0.VSS.t261 wind_comp_0.sg13g2_and2_2$1_0.VSS.t262 sg13_lv_nmos ad=0.1406p pd=1.12u as=0.1406p ps=1.12u w=0.74u l=0.13u
X115 wind_comp_0.comparator_1.dynamic_pcell_0.SRC_NET_IJ wind_comp_0.sg13g2_and2_2$1_0.VDD.t210 wind_comp_0.sg13g2_and2_2$1_0.VDD.t206 wind_comp_0.comparator_1.dynamic_pcell$7_0.VDD sg13_lv_pmos ad=95f pd=0.88u as=95f ps=0.88u w=0.5u l=0.5u
X116 wind_comp_0.comparator_1.dynamic_pcell$2_0.O_DRN wind_comp_0.comparator_1.nmos$2_0.Drain wind_comp_0.sg13g2_and2_2$1_0.VSS.t136 wind_comp_0.sg13g2_and2_2$1_0.VSS.t359 sg13_lv_nmos ad=0.95p pd=5.38u as=0.95p ps=5.38u w=5u l=3u
X117 wind_comp_0.comparator_0.dynamic_pcell$1_0.DRN_NET_PQ_GATE_Q wind_comp_0.comparator_0.dynamic_pcell$1_0.P_GATE wind_comp_0.sg13g2_and2_2$1_0.VSS.t274 wind_comp_0.sg13g2_and2_2$1_0.VSS.t275 sg13_lv_nmos ad=63.19999f pd=0.74u as=63.19999f ps=0.74u w=0.26u l=10u
X118 wind_comp_0.sg13g2_and2_2$1_0.VSS.t273 wind_comp_0.comparator_0.dynamic_pcell_0.DRN_NET_IH wind_comp_0.comparator_0.sg13cmos5l_inv_16_0.A wind_comp_0.sg13g2_and2_2$1_0.VSS.t272 sg13_lv_nmos ad=0.2516p pd=2.16u as=0.1406p ps=1.12u w=0.74u l=0.13u
X119 wind_comp_0.sg13g2_and2_2$1_0.VSS.t232 wind_comp_0.sg13g2_and2_2$1_0.VSS.t230 wind_comp_0.sg13g2_and2_2$1_0.VSS.t231 wind_comp_0.sg13g2_and2_2$1_0.VSS.t36 sg13_lv_nmos ad=0.95p pd=5.38u as=0 ps=0 w=5u l=0.5u
X120 wind_comp_0.sg13g2_and2_2$1_0.VSS.t17 wind_comp_0.sg13g2_and2_2$1_0.VSS.t15 wind_comp_0.sg13g2_and2_2$1_0.VSS.t17 wind_comp_0.sg13g2_and2_2$1_0.VSS.t16 sg13_lv_nmos ad=0.1082p pd=1.34u as=0 ps=0 w=0.26u l=0.5u
X121 wind_comp_0.sg13g2_and2_2$1_0.VSS.t267 wind_comp_0.comparator_0.dynamic_pcell_0.DRN_NET_IH wind_comp_0.comparator_0.sg13cmos5l_inv_16_0.A wind_comp_0.sg13g2_and2_2$1_0.VSS.t266 sg13_lv_nmos ad=0.1406p pd=1.12u as=0.1406p ps=1.12u w=0.74u l=0.13u
X122 wind_comp_0.sg13g2_and2_2$1_0.B wind_comp_0.comparator_1.sg13cmos5l_inv_16_0.A wind_comp_0.sg13g2_and2_2$1_0.VSS.t370 wind_comp_0.sg13g2_and2_2$1_0.VSS.t371 sg13_lv_nmos ad=0.1406p pd=1.12u as=0.1406p ps=1.12u w=0.74u l=0.13u
X123 wind_comp_0.comparator_0.dynamic_pcell$1_0.DRN_NET_PQ_GATE_Q wind_comp_0.sg13g2_and2_2$1_0.VDD.t144 wind_comp_0.sg13g2_and2_2$1_0.VDD.t143 wind_comp_0.comparator_0.dynamic_pcell_0.VDD sg13_lv_pmos ad=66.49999f pd=0.73u as=66.49999f ps=0.73u w=0.35u l=0.5u
X124 wind_comp_0.sg13g2_and2_2$1_0.VSS.t218 wind_comp_0.sg13g2_and2_2$1_0.VSS.t217 wind_comp_0.comparator_1.dynamic_pcell$1_0.P_GATE wind_comp_0.sg13g2_and2_2$1_0.VSS.t198 sg13_lv_nmos ad=63.19999f pd=0.74u as=63.19999f ps=0.74u w=0.26u l=0.5u
X125 wind_comp_0.sg13g2_and2_2$1_0.VSS.t161 wind_comp_0.sg13g2_and2_2$1_0.VSS.t162 wind_comp_0.sg13g2_and2_2$1_0.VSS.t161 wind_comp_0.sg13g2_and2_2$1_0.VSS.t163 sg13_lv_nmos ad=63.19999f pd=0.74u as=0 ps=0 w=0.26u l=0.5u
X126 wind_comp_0.sg13g2_and2_2$1_0.VSS.t68 wind_comp_0.sg13g2_and2_2$1_0.VSS.t66 wind_comp_0.comparator_0.dynamic_pcell_0.DRN_NET_IH wind_comp_0.sg13g2_and2_2$1_0.VSS.t67 sg13_lv_nmos ad=55.5f pd=0.74u as=55.5f ps=0.74u w=0.15u l=0.5u
X127 wind_comp_0.sg13g2_and2_2$1_0.VSS.t47 wind_comp_0.sg13g2_and2_2$1_0.VSS.t49 wind_comp_0.sg13g2_and2_2$1_0.VSS.t50 wind_comp_0.sg13g2_and2_2$1_0.VSS.t19 sg13_lv_nmos ad=0.95p pd=5.38u as=0 ps=0 w=5u l=0.5u
X128 wind_comp_0.sg13g2_and2_2$1_0.VSS.t33 wind_comp_0.sg13g2_and2_2$1_0.VSS.t35 wind_comp_0.comparator_1.nmos$2_0.Drain wind_comp_0.sg13g2_and2_2$1_0.VSS.t36 sg13_lv_nmos ad=0.95p pd=5.38u as=0.95p ps=5.38u w=5u l=0.5u
X129 wind_comp_0.sg13g2_and2_2$1_0.B wind_comp_0.comparator_1.sg13cmos5l_inv_16_0.A wind_comp_0.sg13g2_and2_2$1_0.VDD.t81 wind_comp_0.comparator_1.dynamic_pcell$7_0.VDD sg13_lv_pmos ad=0.2128p pd=1.5u as=0.2128p ps=1.5u w=1.12u l=0.13u
X130 wind_comp_0.comparator_0.dynamic_pcell_0.DRN_NET_GJ_GATE_GH wind_comp_0.comparator_0.dynamic_pcell_0.DRN_NET_GJ_GATE_GH wind_comp_0.sg13g2_and2_2$1_0.VSS.t3 wind_comp_0.sg13g2_and2_2$1_0.VSS.t2 sg13_lv_nmos ad=55.5f pd=0.74u as=55.5f ps=0.74u w=0.15u l=3u
X131 wind_comp_0.sg13g2_and2_2$1_0.VDD.t236 wind_comp_0.comparator_1.dynamic_pcell$7_0.DRN_NET_CF_GATE_CD wind_comp_0.comparator_1.dynamic_pcell$7_0.DRN_NET_CF_GATE_CD wind_comp_0.comparator_1.dynamic_pcell$7_0.VDD sg13_lv_pmos ad=66.49999f pd=0.73u as=0.119p ps=1.38u w=0.35u l=1u
X132 wind_comp_0.comparator_0.dynamic_pcell$1_0.P_GATE wind_comp_0.comparator_0.dynamic_pcell$1_0.P_GATE wind_comp_0.sg13g2_and2_2$1_0.VSS.t277 wind_comp_0.sg13g2_and2_2$1_0.VSS.t275 sg13_lv_nmos ad=63.19999f pd=0.74u as=63.19999f ps=0.74u w=0.26u l=10u
X133 wind_comp_0.comparator_1.dynamic_pcell$1_0.DRN_NET_PQ_GATE_Q wind_comp_0.sg13g2_and2_2$1_0.VSS.t223 wind_comp_0.sg13g2_and2_2$1_0.VSS.t211 wind_comp_0.sg13g2_and2_2$1_0.VSS.t196 sg13_lv_nmos ad=63.19999f pd=0.74u as=63.19999f ps=0.74u w=0.26u l=0.5u
X134 wind_comp_0.sg13g2_and2_2$1_0.VDD.t209 wind_comp_0.sg13g2_and2_2$1_0.VDD.t208 wind_comp_0.comparator_1.dynamic_pcell$2_0.DRN_NET_LM_GATE_KL wind_comp_0.comparator_1.dynamic_pcell$7_0.VDD sg13_lv_pmos ad=95f pd=0.88u as=95f ps=0.88u w=0.5u l=0.5u
X135 wind_comp_0.sg13g2_and2_2$1_0.VDD.t49 wind_comp_0.comparator_1.dynamic_pcell_0.DRN_NET_IH wind_comp_0.comparator_1.sg13cmos5l_inv_16_0.A wind_comp_0.comparator_1.dynamic_pcell$7_0.VDD sg13_lv_pmos ad=0.2128p pd=1.5u as=0.2128p ps=1.5u w=1.12u l=0.13u
X136 wind_comp_0.sg13g2_and2_2$1_0.VDD.t37 wind_comp_0.comparator_1.dynamic_pcell_0.DRN_NET_IH wind_comp_0.comparator_1.sg13cmos5l_inv_16_0.A wind_comp_0.comparator_1.dynamic_pcell$7_0.VDD sg13_lv_pmos ad=0.2128p pd=1.5u as=0.2128p ps=1.5u w=1.12u l=0.13u
X137 wind_comp_0.comparator_1.dynamic_pcell$7_0.DRN_NET_CF_GATE_CD wind_comp_0.comparator_1.dynamic_pcell$7_0.DRN_NET_CF_GATE_CD wind_comp_0.sg13g2_and2_2$1_0.VDD.t234 wind_comp_0.comparator_1.dynamic_pcell$7_0.VDD sg13_lv_pmos ad=0.119p pd=1.38u as=66.49999f ps=0.73u w=0.35u l=1u
X138 wind_comp_0.sg13g2_and2_2$1_0.VSS.t142 wind_comp_0.sg13g2_and2_2$1_0.VSS.t140 wind_comp_0.sg13g2_and2_2$1_0.VSS.t138 wind_comp_0.sg13g2_and2_2$1_0.VSS.t32 sg13_lv_nmos ad=0.95p pd=5.38u as=0 ps=0 w=5u l=0.5u
X139 wind_comp_0.sg13g2_and2_2$1_0.A wind_comp_0.comparator_0.sg13cmos5l_inv_16_0.A wind_comp_0.sg13g2_and2_2$1_0.VDD.t65 wind_comp_0.comparator_0.dynamic_pcell_0.VDD sg13_lv_pmos ad=0.2128p pd=1.5u as=0.2128p ps=1.5u w=1.12u l=0.13u
X140 wind_comp_0.comparator_0.nmos$2_0.Drain wind_comp_0.sg13g2_and2_2$1_0.VSS.t18 wind_comp_0.sg13g2_and2_2$1_0.VSS.t9 wind_comp_0.sg13g2_and2_2$1_0.VSS.t19 sg13_lv_nmos ad=0.95p pd=5.38u as=0.95p ps=5.38u w=5u l=0.5u
X141 wind_comp_0.comparator_0.dynamic_pcell$7_0.DRN_NET_BE_GATE_AB s4_an wind_comp_0.comparator_0.dynamic_pcell$2_0.O_DRN wind_comp_0.sg13g2_and2_2$1_0.VSS.t396 sg13_lv_nmos ad=63.19999f pd=0.74u as=63.19999f ps=0.74u w=0.26u l=3u
X142 wind_comp_0.sg13g2_and2_2$1_0.A wind_comp_0.comparator_0.sg13cmos5l_inv_16_0.A wind_comp_0.sg13g2_and2_2$1_0.VDD.t61 wind_comp_0.comparator_0.dynamic_pcell_0.VDD sg13_lv_pmos ad=0.2128p pd=1.5u as=0.2128p ps=1.5u w=1.12u l=0.13u
X143 wind_comp_0.comparator_0.dynamic_pcell$2_0.DRN_NET_LM_GATE_KL wind_comp_0.sg13g2_and2_2$1_0.VDD.t111 wind_comp_0.sg13g2_and2_2$1_0.VDD.t109 wind_comp_0.comparator_0.dynamic_pcell_0.VDD sg13_lv_pmos ad=95f pd=0.88u as=95f ps=0.88u w=0.5u l=0.5u
X144 wind_comp_0.sg13g2_and2_2$1_0.VSS.t39 wind_comp_0.sg13g2_and2_2$1_0.VSS.t37 wind_comp_0.sg13g2_and2_2$1_0.VSS.t28 wind_comp_0.sg13g2_and2_2$1_0.VSS.t8 sg13_lv_nmos ad=1.7p pd=10.68u as=0 ps=0 w=5u l=0.5u
X145 wind_comp_0.comparator_0.dynamic_pcell$7_0.DRN_NET_CF_GATE_CD enable.t12 wind_comp_0.sg13g2_and2_2$1_0.VDD.t95 wind_comp_0.comparator_0.dynamic_pcell_0.VDD sg13_lv_pmos ad=0.1005p pd=1.34u as=55.5f ps=0.74u w=0.15u l=0.13u
X146 wind_comp_0.sg13g2_and2_2$1_0.VSS.t170 wind_comp_0.sg13g2_and2_2$1_0.VSS.t171 wind_comp_0.sg13g2_and2_2$1_0.VSS.t170 wind_comp_0.sg13g2_and2_2$1_0.VSS.t163 sg13_lv_nmos ad=63.19999f pd=0.74u as=0 ps=0 w=0.26u l=0.5u
X147 wind_comp_0.comparator_0.dynamic_pcell_0.SRC_NET_IJ wind_comp_0.comparator_0.dynamic_pcell$1_0.P_GATE wind_comp_0.comparator_0.dynamic_pcell_0.DRN_NET_GJ_GATE_GH wind_comp_0.comparator_0.dynamic_pcell_0.VDD sg13_lv_pmos ad=0.5928p pd=3.5u as=0.5928p ps=3.5u w=3.12u l=1u
X148 wind_comp_0.comparator_1.dynamic_pcell$1_0.P_GATE wind_comp_0.comparator_1.dynamic_pcell$1_0.P_GATE wind_comp_0.sg13g2_and2_2$1_0.VSS.t302 wind_comp_0.sg13g2_and2_2$1_0.VSS.t297 sg13_lv_nmos ad=63.19999f pd=0.74u as=63.19999f ps=0.74u w=0.26u l=10u
X149 wind_comp_0.comparator_0.dynamic_pcell_0.SRC_NET_IJ wind_comp_0.comparator_0.dynamic_pcell$1_0.DRN_NET_PQ_GATE_Q wind_comp_0.comparator_0.dynamic_pcell_0.DRN_NET_IH wind_comp_0.comparator_0.dynamic_pcell_0.VDD sg13_lv_pmos ad=0.5928p pd=3.5u as=0.5928p ps=3.5u w=3.12u l=1u
X150 wind_comp_0.sg13g2_and2_2$1_0.VSS.t292 wind_comp_0.comparator_1.dynamic_pcell_0.DRN_NET_GJ_GATE_GH wind_comp_0.comparator_1.dynamic_pcell_0.DRN_NET_IH wind_comp_0.sg13g2_and2_2$1_0.VSS.t293 sg13_lv_nmos ad=55.5f pd=0.74u as=55.5f ps=0.74u w=0.15u l=3u
X151 wind_comp_0.comparator_1.dynamic_pcell$1_0.DRN_NET_PQ_GATE_Q wind_comp_0.comparator_1.dynamic_pcell$7_0.DRN_NET_BE_GATE_AB wind_comp_0.sg13g2_and2_2$1_0.VDD.t26 wind_comp_0.comparator_1.dynamic_pcell$7_0.VDD sg13_lv_pmos ad=66.49999f pd=0.73u as=66.49999f ps=0.73u w=0.35u l=1u
X152 wind_comp_0.sg13g2_and2_2$1_0.VDD.t19 wind_comp_0.comparator_0.dynamic_pcell_0.DRN_NET_IH wind_comp_0.comparator_0.sg13cmos5l_inv_16_0.A wind_comp_0.comparator_0.dynamic_pcell_0.VDD sg13_lv_pmos ad=0.2128p pd=1.5u as=0.2128p ps=1.5u w=1.12u l=0.13u
X153 wind_comp_0.sg13g2_and2_2$1_0.VSS.t232 wind_comp_0.comparator_1.nmos$2_0.Drain wind_comp_0.comparator_1.dynamic_pcell$2_0.O_DRN wind_comp_0.sg13g2_and2_2$1_0.VSS.t361 sg13_lv_nmos ad=0.95p pd=5.38u as=0.95p ps=5.38u w=5u l=3u
X154 wind_comp_0.sg13g2_and2_2$1_0.VSS.t276 wind_comp_0.comparator_0.dynamic_pcell$1_0.P_GATE wind_comp_0.comparator_0.dynamic_pcell$1_0.DRN_NET_PQ_GATE_Q wind_comp_0.sg13g2_and2_2$1_0.VSS.t268 sg13_lv_nmos ad=63.19999f pd=0.74u as=63.19999f ps=0.74u w=0.26u l=10u
X155 wind_comp_0.sg13g2_and2_2$1_0.VSS.t133 wind_comp_0.sg13g2_and2_2$1_0.VSS.t131 wind_comp_0.sg13g2_and2_2$1_0.VSS.t132 wind_comp_0.sg13g2_and2_2$1_0.VSS.t12 sg13_lv_nmos ad=1.7p pd=10.68u as=0 ps=0 w=5u l=0.5u
X156 wind_comp_0.comparator_1.sg13cmos5l_inv_16_0.A wind_comp_0.comparator_1.dynamic_pcell_0.DRN_NET_IH wind_comp_0.sg13g2_and2_2$1_0.VSS.t313 wind_comp_0.sg13g2_and2_2$1_0.VSS.t314 sg13_lv_nmos ad=0.1406p pd=1.12u as=0.1406p ps=1.12u w=0.74u l=0.13u
X157 analog_bus1 a_51539_28086# wind_comp_0.sg13g2_and2_2$1_0.VDD.t52 wind_comp_0.sg13g2_and2_2$1_0.VDD.t4 sg13_lv_pmos ad=0.2128p pd=1.5u as=0.1918p ps=1.5u w=1.12u l=0.13u
X158 wind_comp_0.sg13g2_and2_2$1_0.VDD.t98 enable.t10 wind_comp_0.comparator_1.dynamic_pcell$7_0.DRN_NET_BE_GATE_AB wind_comp_0.comparator_1.dynamic_pcell$7_0.VDD sg13_lv_pmos ad=0.1005p pd=1.34u as=0.1005p ps=1.34u w=0.15u l=0.13u
X159 wind_comp_0.sg13g2_and2_2$1_0.VDD.t83 wind_comp_0.comparator_1.sg13cmos5l_inv_16_0.A wind_comp_0.sg13g2_and2_2$1_0.B wind_comp_0.comparator_1.dynamic_pcell$7_0.VDD sg13_lv_pmos ad=0.2128p pd=1.5u as=0.2128p ps=1.5u w=1.12u l=0.13u
X160 wind_comp_0.sg13g2_and2_2$1_0.VSS.t93 wind_comp_0.sg13g2_and2_2$1_0.VSS.t94 wind_comp_0.comparator_0.dynamic_pcell$7_0.DRN_NET_CF_GATE_CD wind_comp_0.sg13g2_and2_2$1_0.VSS.t84 sg13_lv_nmos ad=63.19999f pd=0.74u as=63.19999f ps=0.74u w=0.26u l=0.5u
X161 wind_comp_0.comparator_0.sg13cmos5l_inv_16_0.A wind_comp_0.comparator_0.dynamic_pcell_0.DRN_NET_IH wind_comp_0.sg13g2_and2_2$1_0.VDD.t21 wind_comp_0.comparator_0.dynamic_pcell_0.VDD sg13_lv_pmos ad=0.2128p pd=1.5u as=0.2128p ps=1.5u w=1.12u l=0.13u
X162 wind_comp_0.sg13g2_and2_2$1_0.VDD.t147 wind_comp_0.sg13g2_and2_2$1_0.VDD.t148 wind_comp_0.sg13g2_and2_2$1_0.VDD.t149 wind_comp_0.comparator_0.dynamic_pcell_0.VDD sg13_lv_pmos ad=66.49999f pd=0.73u as=0 ps=0 w=0.35u l=0.5u
X163 wind_comp_0.comparator_1.nmos$2_0.Drain wind_comp_0.comparator_1.nmos$2_0.Drain wind_comp_0.sg13g2_and2_2$1_0.VSS.t360 wind_comp_0.sg13g2_and2_2$1_0.VSS.t361 sg13_lv_nmos ad=0.95p pd=5.38u as=0.95p ps=5.38u w=5u l=3u
X164 wind_comp_0.comparator_1.sg13cmos5l_inv_16_0.A wind_comp_0.comparator_1.dynamic_pcell_0.DRN_NET_IH wind_comp_0.sg13g2_and2_2$1_0.VSS.t307 wind_comp_0.sg13g2_and2_2$1_0.VSS.t308 sg13_lv_nmos ad=0.1406p pd=1.12u as=0.1406p ps=1.12u w=0.74u l=0.13u
X165 wind_comp_0.comparator_0.dynamic_pcell$2_0.DRN_NET_LM_GATE_KL wind_comp_0.comparator_0.dynamic_pcell$2_0.DRN_NET_LM_GATE_KL wind_comp_0.sg13g2_and2_2$1_0.VDD.t58 wind_comp_0.comparator_0.dynamic_pcell_0.VDD sg13_lv_pmos ad=95f pd=0.88u as=95f ps=0.88u w=0.5u l=3u
X166 wind_comp_0.sg13g2_and2_2$1_0.VDD.t79 wind_comp_0.comparator_1.sg13cmos5l_inv_16_0.A wind_comp_0.sg13g2_and2_2$1_0.B wind_comp_0.comparator_1.dynamic_pcell$7_0.VDD sg13_lv_pmos ad=0.2128p pd=1.5u as=0.2128p ps=1.5u w=1.12u l=0.13u
X167 ibias enable.t1 wind_comp_0.comparator_0.nmos$2_0.Drain wind_comp_0.sg13g2_and2_2$1_0.VSS.t409 sg13_lv_nmos ad=0.1005p pd=1.34u as=55.5f ps=0.74u w=0.15u l=0.13u
X168 wind_comp_0.comparator_1.dynamic_pcell$2_0.O_DRN s4_an wind_comp_0.comparator_1.dynamic_pcell$7_0.DRN_NET_CF_GATE_CD wind_comp_0.sg13g2_and2_2$1_0.VSS.t398 sg13_lv_nmos ad=63.19999f pd=0.74u as=63.19999f ps=0.74u w=0.26u l=3u
X169 wind_comp_0.sg13g2_and2_2$1_0.VDD.t175 wind_comp_0.sg13g2_and2_2$1_0.VDD.t174 wind_comp_0.comparator_1.dynamic_pcell$1_0.P_GATE wind_comp_0.comparator_1.dynamic_pcell$7_0.VDD sg13_lv_pmos ad=66.49999f pd=0.73u as=66.49999f ps=0.73u w=0.35u l=0.5u
X170 wind_comp_0.comparator_1.dynamic_pcell$2_0.DRN_NET_LM_GATE_KL wind_comp_0.comparator_1.dynamic_pcell$2_0.DRN_NET_LM_GATE_KL wind_comp_0.sg13g2_and2_2$1_0.VDD.t31 wind_comp_0.comparator_1.dynamic_pcell$7_0.VDD sg13_lv_pmos ad=95f pd=0.88u as=95f ps=0.88u w=0.5u l=3u
X171 wind_comp_0.sg13g2_and2_2$1_0.VDD.t156 wind_comp_0.sg13g2_and2_2$1_0.VDD.t155 wind_comp_0.comparator_1.dynamic_pcell_0.DRN_NET_GJ_GATE_GH wind_comp_0.comparator_1.dynamic_pcell$7_0.VDD sg13_lv_pmos ad=0.5928p pd=3.5u as=0.5928p ps=3.5u w=3.12u l=0.5u
X172 wind_comp_0.sg13g2_and2_2$1_0.VDD.t202 wind_comp_0.sg13g2_and2_2$1_0.VDD.t201 wind_comp_0.comparator_1.dynamic_pcell_0.DRN_NET_IH wind_comp_0.comparator_1.dynamic_pcell$7_0.VDD sg13_lv_pmos ad=0.5928p pd=3.5u as=0.5928p ps=3.5u w=3.12u l=0.5u
X173 wind_comp_0.sg13g2_and2_2$1_0.VDD.t63 wind_comp_0.comparator_0.sg13cmos5l_inv_16_0.A wind_comp_0.sg13g2_and2_2$1_0.A wind_comp_0.comparator_0.dynamic_pcell_0.VDD sg13_lv_pmos ad=0.2128p pd=1.5u as=0.2128p ps=1.5u w=1.12u l=0.13u
X174 wind_comp_0.comparator_0.sg13cmos5l_inv_16_0.A wind_comp_0.comparator_0.dynamic_pcell_0.DRN_NET_IH wind_comp_0.sg13g2_and2_2$1_0.VSS.t255 wind_comp_0.sg13g2_and2_2$1_0.VSS.t256 sg13_lv_nmos ad=0.1406p pd=1.12u as=0.1406p ps=1.12u w=0.74u l=0.13u
X175 wind_comp_0.sg13g2_and2_2$1_0.VSS.t199 wind_comp_0.sg13g2_and2_2$1_0.VSS.t200 wind_comp_0.sg13g2_and2_2$1_0.VSS.t199 wind_comp_0.sg13g2_and2_2$1_0.VSS.t201 sg13_lv_nmos ad=63.19999f pd=0.74u as=0 ps=0 w=0.26u l=0.5u
X176 wind_comp_0.sg13g2_and2_2$1_0.B wind_comp_0.comparator_1.sg13cmos5l_inv_16_0.A wind_comp_0.sg13g2_and2_2$1_0.VSS.t388 wind_comp_0.sg13g2_and2_2$1_0.VSS.t389 sg13_lv_nmos ad=0.1406p pd=1.12u as=0.1406p ps=1.12u w=0.74u l=0.13u
X177 wind_comp_0.sg13g2_and2_2$1_0.VSS.t85 wind_comp_0.sg13g2_and2_2$1_0.VSS.t86 wind_comp_0.sg13g2_and2_2$1_0.VSS.t85 wind_comp_0.sg13g2_and2_2$1_0.VSS.t87 sg13_lv_nmos ad=63.19999f pd=0.74u as=0 ps=0 w=0.26u l=0.5u
X178 wind_comp_0.sg13g2_and2_2$1_0.B wind_comp_0.comparator_1.sg13cmos5l_inv_16_0.A wind_comp_0.sg13g2_and2_2$1_0.VSS.t382 wind_comp_0.sg13g2_and2_2$1_0.VSS.t383 sg13_lv_nmos ad=0.1406p pd=1.12u as=0.1406p ps=1.12u w=0.74u l=0.13u
X179 wind_comp_0.sg13g2_and2_2$1_0.VDD.t107 wind_comp_0.sg13g2_and2_2$1_0.VDD.t106 wind_comp_0.comparator_0.dynamic_pcell$2_0.DRN_NET_LM_GATE_KL wind_comp_0.comparator_0.dynamic_pcell_0.VDD sg13_lv_pmos ad=95f pd=0.88u as=95f ps=0.88u w=0.5u l=0.5u
X180 wind_comp_0.sg13g2_and2_2$1_0.VDD.t8 wind_comp_0.comparator_0.dynamic_pcell$7_0.DRN_NET_CF_GATE_CD wind_comp_0.comparator_0.dynamic_pcell$1_0.P_GATE wind_comp_0.comparator_0.dynamic_pcell_0.VDD sg13_lv_pmos ad=66.49999f pd=0.73u as=66.49999f ps=0.73u w=0.35u l=1u
X181 wind_comp_0.sg13g2_and2_2$1_0.A wind_comp_0.comparator_0.sg13cmos5l_inv_16_0.A wind_comp_0.sg13g2_and2_2$1_0.VSS.t355 wind_comp_0.sg13g2_and2_2$1_0.VSS.t356 sg13_lv_nmos ad=0.1406p pd=1.12u as=0.1406p ps=1.12u w=0.74u l=0.13u
X182 wind_comp_0.comparator_1.dynamic_pcell_0.SRC_NET_IJ wind_comp_0.comparator_1.dynamic_pcell$1_0.P_GATE wind_comp_0.comparator_1.dynamic_pcell_0.DRN_NET_GJ_GATE_GH wind_comp_0.comparator_1.dynamic_pcell$7_0.VDD sg13_lv_pmos ad=0.5928p pd=3.5u as=0.5928p ps=3.5u w=3.12u l=1u
X183 wind_comp_0.comparator_1.dynamic_pcell_0.SRC_NET_IJ wind_comp_0.comparator_1.dynamic_pcell$1_0.DRN_NET_PQ_GATE_Q wind_comp_0.comparator_1.dynamic_pcell_0.DRN_NET_IH wind_comp_0.comparator_1.dynamic_pcell$7_0.VDD sg13_lv_pmos ad=0.5928p pd=3.5u as=0.5928p ps=3.5u w=3.12u l=1u
X184 wind_comp_0.sg13g2_and2_2$1_0.VSS.t178 wind_comp_0.sg13g2_and2_2$1_0.VSS.t176 wind_comp_0.sg13g2_and2_2$1_0.VSS.t178 wind_comp_0.sg13g2_and2_2$1_0.VSS.t177 sg13_lv_nmos ad=0.1082p pd=1.34u as=0 ps=0 w=0.26u l=0.5u
X185 wind_comp_0.sg13g2_and2_2$1_0.VSS.t190 wind_comp_0.sg13g2_and2_2$1_0.VSS.t189 wind_comp_0.comparator_0.dynamic_pcell$1_0.DRN_NET_PQ_GATE_Q wind_comp_0.sg13g2_and2_2$1_0.VSS.t160 sg13_lv_nmos ad=63.19999f pd=0.74u as=63.19999f ps=0.74u w=0.26u l=0.5u
X186 wind_comp_0.sg13g2_and2_2$1_0.VSS.t310 wind_comp_0.comparator_1.dynamic_pcell_0.DRN_NET_IH wind_comp_0.comparator_1.sg13cmos5l_inv_16_0.A wind_comp_0.sg13g2_and2_2$1_0.VSS.t309 sg13_lv_nmos ad=0.1406p pd=1.12u as=0.1406p ps=1.12u w=0.74u l=0.13u
X187 wind_comp_0.sg13g2_and2_2$1_0.VSS.t207 wind_comp_0.sg13g2_and2_2$1_0.VSS.t208 wind_comp_0.sg13g2_and2_2$1_0.VSS.t207 wind_comp_0.sg13g2_and2_2$1_0.VSS.t201 sg13_lv_nmos ad=63.19999f pd=0.74u as=0 ps=0 w=0.26u l=0.5u
X188 wind_comp_0.sg13g2_and2_2$1_0.A wind_comp_0.comparator_0.sg13cmos5l_inv_16_0.A wind_comp_0.sg13g2_and2_2$1_0.VSS.t349 wind_comp_0.sg13g2_and2_2$1_0.VSS.t350 sg13_lv_nmos ad=0.1406p pd=1.12u as=0.1406p ps=1.12u w=0.74u l=0.13u
X189 wind_comp_0.comparator_1.dynamic_pcell_0.DRN_NET_IH wind_comp_0.sg13g2_and2_2$1_0.VSS.t118 wind_comp_0.sg13g2_and2_2$1_0.VSS.t113 wind_comp_0.sg13g2_and2_2$1_0.VSS.t119 sg13_lv_nmos ad=55.5f pd=0.74u as=55.5f ps=0.74u w=0.15u l=0.5u
X190 wind_comp_0.comparator_1.dynamic_pcell_0.DRN_NET_GJ_GATE_GH wind_comp_0.comparator_1.dynamic_pcell_0.DRN_NET_GJ_GATE_GH wind_comp_0.sg13g2_and2_2$1_0.VSS.t292 wind_comp_0.sg13g2_and2_2$1_0.VSS.t291 sg13_lv_nmos ad=55.5f pd=0.74u as=55.5f ps=0.74u w=0.15u l=3u
X191 wind_comp_0.sg13g2_and2_2$1_0.VSS.t89 wind_comp_0.sg13g2_and2_2$1_0.VSS.t88 wind_comp_0.sg13g2_and2_2$1_0.VSS.t89 wind_comp_0.sg13g2_and2_2$1_0.VSS.t79 sg13_lv_nmos ad=0.1082p pd=1.34u as=0 ps=0 w=0.26u l=0.5u
X192 wind_comp_0.sg13g2_and2_2$1_0.VDD.t45 wind_comp_0.comparator_1.dynamic_pcell_0.DRN_NET_IH wind_comp_0.comparator_1.sg13cmos5l_inv_16_0.A wind_comp_0.comparator_1.dynamic_pcell$7_0.VDD sg13_lv_pmos ad=0.2128p pd=1.5u as=0.2128p ps=1.5u w=1.12u l=0.13u
X193 wind_comp_0.sg13g2_and2_2$1_0.VSS.t59 wind_comp_0.sg13g2_and2_2$1_0.VSS.t57 wind_comp_0.sg13g2_and2_2$1_0.VSS.t53 wind_comp_0.sg13g2_and2_2$1_0.VSS.t24 sg13_lv_nmos ad=0.95p pd=5.38u as=0 ps=0 w=5u l=0.5u
X194 wind_comp_0.comparator_0.dynamic_pcell$1_0.DRN_NET_PQ_GATE_Q wind_comp_0.sg13g2_and2_2$1_0.VSS.t187 wind_comp_0.sg13g2_and2_2$1_0.VSS.t186 wind_comp_0.sg13g2_and2_2$1_0.VSS.t158 sg13_lv_nmos ad=63.19999f pd=0.74u as=63.19999f ps=0.74u w=0.26u l=0.5u
X195 wind_comp_0.sg13g2_and2_2$1_0.VSS.t258 wind_comp_0.comparator_0.dynamic_pcell_0.DRN_NET_IH wind_comp_0.comparator_0.sg13cmos5l_inv_16_0.A wind_comp_0.sg13g2_and2_2$1_0.VSS.t257 sg13_lv_nmos ad=0.1406p pd=1.12u as=0.1406p ps=1.12u w=0.74u l=0.13u
X196 wind_comp_0.sg13g2_and2_2$1_0.VSS.t289 wind_comp_0.comparator_0.nmos$2_0.Drain wind_comp_0.comparator_0.dynamic_pcell$2_0.DRN_NET_LM_GATE_KL wind_comp_0.sg13g2_and2_2$1_0.VSS.t283 sg13_lv_nmos ad=0.95p pd=5.38u as=0.95p ps=5.38u w=5u l=3u
X197 wind_comp_0.sg13g2_and2_2$1_0.VSS.t252 wind_comp_0.comparator_0.dynamic_pcell_0.DRN_NET_IH wind_comp_0.comparator_0.sg13cmos5l_inv_16_0.A wind_comp_0.sg13g2_and2_2$1_0.VSS.t251 sg13_lv_nmos ad=0.1406p pd=1.12u as=0.1406p ps=1.12u w=0.74u l=0.13u
X198 wind_comp_0.sg13g2_and2_2$1_0.VDD.t103 wind_comp_0.sg13g2_and2_2$1_0.VDD.t139 wind_comp_0.sg13g2_and2_2$1_0.VDD.t140 wind_comp_0.comparator_0.dynamic_pcell_0.VDD sg13_lv_pmos ad=0.5928p pd=3.5u as=0 ps=0 w=3.12u l=0.5u
X199 wind_comp_0.sg13g2_and2_2$1_0.VDD.t193 wind_comp_0.sg13g2_and2_2$1_0.VDD.t194 wind_comp_0.sg13g2_and2_2$1_0.VDD.t195 wind_comp_0.comparator_0.dynamic_pcell_0.VDD sg13_lv_pmos ad=0.5928p pd=3.5u as=0 ps=0 w=3.12u l=0.5u
X200 wind_comp_0.sg13g2_and2_2$1_0.VDD.t30 wind_comp_0.comparator_1.dynamic_pcell$2_0.DRN_NET_LM_GATE_KL wind_comp_0.comparator_1.dynamic_pcell$2_0.DRN_NET_LM_GATE_KL wind_comp_0.comparator_1.dynamic_pcell$7_0.VDD sg13_lv_pmos ad=95f pd=0.88u as=95f ps=0.88u w=0.5u l=3u
X201 wind_comp_0.sg13g2_and2_2$1_0.B wind_comp_0.comparator_1.sg13cmos5l_inv_16_0.A wind_comp_0.sg13g2_and2_2$1_0.VDD.t76 wind_comp_0.comparator_1.dynamic_pcell$7_0.VDD sg13_lv_pmos ad=0.2128p pd=1.5u as=0.3808p ps=2.92u w=1.12u l=0.13u
X202 wind_comp_0.sg13g2_and2_2$1_0.VSS.t22 wind_comp_0.sg13g2_and2_2$1_0.VSS.t23 wind_comp_0.sg13g2_and2_2$1_0.VSS.t25 wind_comp_0.sg13g2_and2_2$1_0.VSS.t24 sg13_lv_nmos ad=0.95p pd=5.38u as=0 ps=0 w=5u l=0.5u
X203 wind_comp_0.sg13g2_and2_2$1_0.VDD.t57 wind_comp_0.comparator_0.dynamic_pcell$2_0.DRN_NET_LM_GATE_KL wind_comp_0.comparator_0.dynamic_pcell_0.SRC_NET_IJ wind_comp_0.comparator_0.dynamic_pcell_0.VDD sg13_lv_pmos ad=95f pd=0.88u as=95f ps=0.88u w=0.5u l=3u
X204 wind_comp_0.comparator_1.dynamic_pcell$7_0.DRN_NET_BE_GATE_AB analog_bus0 wind_comp_0.comparator_1.dynamic_pcell$2_0.O_DRN wind_comp_0.sg13g2_and2_2$1_0.VSS.t397 sg13_lv_nmos ad=63.19999f pd=0.74u as=63.19999f ps=0.74u w=0.26u l=3u
X205 wind_comp_0.sg13g2_and2_2$1_0.VDD.t118 wind_comp_0.sg13g2_and2_2$1_0.VDD.t119 wind_comp_0.sg13g2_and2_2$1_0.VDD.t120 wind_comp_0.comparator_0.dynamic_pcell_0.VDD sg13_lv_pmos ad=95f pd=0.88u as=0 ps=0 w=0.5u l=0.5u
X206 wind_comp_0.comparator_1.nmos$2_0.Drain enable.t0 ibias wind_comp_0.sg13g2_and2_2$1_0.VSS.t412 sg13_lv_nmos ad=0.1005p pd=1.34u as=55.5f ps=0.74u w=0.15u l=0.13u
X207 wind_comp_0.sg13g2_and2_2$1_0.VDD.t6 wind_comp_0.comparator_0.dynamic_pcell$7_0.DRN_NET_CF_GATE_CD wind_comp_0.comparator_0.dynamic_pcell$7_0.DRN_NET_CF_GATE_CD wind_comp_0.comparator_0.dynamic_pcell_0.VDD sg13_lv_pmos ad=66.49999f pd=0.73u as=0.119p ps=1.38u w=0.35u l=1u
X208 wind_comp_0.sg13g2_and2_2$1_0.VDD.t91 wind_comp_0.comparator_1.sg13cmos5l_inv_16_0.A wind_comp_0.sg13g2_and2_2$1_0.B wind_comp_0.comparator_1.dynamic_pcell$7_0.VDD sg13_lv_pmos ad=0.4368p pd=3.02u as=0.2128p ps=1.5u w=1.12u l=0.13u
X209 wind_comp_0.sg13g2_and2_2$1_0.VDD.t87 wind_comp_0.comparator_1.sg13cmos5l_inv_16_0.A wind_comp_0.sg13g2_and2_2$1_0.B wind_comp_0.comparator_1.dynamic_pcell$7_0.VDD sg13_lv_pmos ad=0.2128p pd=1.5u as=0.2128p ps=1.5u w=1.12u l=0.13u
X210 wind_comp_0.sg13g2_and2_2$1_0.VDD.t105 wind_comp_0.sg13g2_and2_2$1_0.VDD.t104 wind_comp_0.comparator_0.dynamic_pcell$1_0.DRN_NET_PQ_GATE_Q wind_comp_0.comparator_0.dynamic_pcell_0.VDD sg13_lv_pmos ad=66.49999f pd=0.73u as=66.49999f ps=0.73u w=0.35u l=0.5u
X211 wind_comp_0.comparator_1.dynamic_pcell$1_0.P_GATE wind_comp_0.sg13g2_and2_2$1_0.VDD.t159 wind_comp_0.sg13g2_and2_2$1_0.VDD.t160 wind_comp_0.comparator_1.dynamic_pcell$7_0.VDD sg13_lv_pmos ad=66.49999f pd=0.73u as=66.49999f ps=0.73u w=0.35u l=0.5u
X212 wind_comp_0.comparator_1.sg13cmos5l_inv_16_0.A wind_comp_0.comparator_1.dynamic_pcell_0.DRN_NET_IH wind_comp_0.sg13g2_and2_2$1_0.VDD.t45 wind_comp_0.comparator_1.dynamic_pcell$7_0.VDD sg13_lv_pmos ad=0.2128p pd=1.5u as=0.2128p ps=1.5u w=1.12u l=0.13u
X213 wind_comp_0.sg13g2_and2_2$1_0.VDD.t75 wind_comp_0.comparator_0.sg13cmos5l_inv_16_0.A wind_comp_0.sg13g2_and2_2$1_0.A wind_comp_0.comparator_0.dynamic_pcell_0.VDD sg13_lv_pmos ad=0.3808p pd=2.92u as=0.2128p ps=1.5u w=1.12u l=0.13u
X214 wind_comp_0.comparator_1.sg13cmos5l_inv_16_0.A wind_comp_0.comparator_1.dynamic_pcell_0.DRN_NET_IH wind_comp_0.sg13g2_and2_2$1_0.VDD.t41 wind_comp_0.comparator_1.dynamic_pcell$7_0.VDD sg13_lv_pmos ad=0.2128p pd=1.5u as=0.2128p ps=1.5u w=1.12u l=0.13u
X215 wind_comp_0.sg13g2_and2_2$1_0.VDD.t71 wind_comp_0.comparator_0.sg13cmos5l_inv_16_0.A wind_comp_0.sg13g2_and2_2$1_0.A wind_comp_0.comparator_0.dynamic_pcell_0.VDD sg13_lv_pmos ad=0.2128p pd=1.5u as=0.2128p ps=1.5u w=1.12u l=0.13u
X216 wind_comp_0.sg13g2_and2_2$1_0.VDD.t232 wind_comp_0.sg13g2_and2_2$1_0.VDD.t230 wind_comp_0.sg13g2_and2_2$1_0.VDD.t229 wind_comp_0.comparator_1.dynamic_pcell$7_0.VDD sg13_lv_pmos ad=95f pd=0.88u as=0 ps=0 w=0.5u l=0.5u
X217 wind_comp_0.sg13g2_and2_2$1_0.VDD.t57 wind_comp_0.sg13g2_and2_2$1_0.VDD.t113 wind_comp_0.sg13g2_and2_2$1_0.VDD.t114 wind_comp_0.comparator_0.dynamic_pcell_0.VDD sg13_lv_pmos ad=95f pd=0.88u as=0 ps=0 w=0.5u l=0.5u
X218 wind_comp_0.comparator_1.sg13cmos5l_inv_16_0.A wind_comp_0.comparator_1.dynamic_pcell_0.DRN_NET_IH wind_comp_0.sg13g2_and2_2$1_0.VDD.t37 wind_comp_0.comparator_1.dynamic_pcell$7_0.VDD sg13_lv_pmos ad=0.2128p pd=1.5u as=0.2128p ps=1.5u w=1.12u l=0.13u
X219 wind_comp_0.comparator_0.dynamic_pcell$1_0.DRN_NET_PQ_GATE_Q wind_comp_0.comparator_0.dynamic_pcell$7_0.DRN_NET_BE_GATE_AB wind_comp_0.sg13g2_and2_2$1_0.VDD.t1 wind_comp_0.comparator_0.dynamic_pcell_0.VDD sg13_lv_pmos ad=66.49999f pd=0.73u as=66.49999f ps=0.73u w=0.35u l=1u
X220 wind_comp_0.sg13g2_and2_2$1_0.VSS.t222 wind_comp_0.sg13g2_and2_2$1_0.VSS.t225 wind_comp_0.comparator_1.dynamic_pcell$1_0.DRN_NET_PQ_GATE_Q wind_comp_0.sg13g2_and2_2$1_0.VSS.t198 sg13_lv_nmos ad=63.19999f pd=0.74u as=63.19999f ps=0.74u w=0.26u l=0.5u
X221 wind_comp_0.sg13g2_and2_2$1_0.VDD.t131 wind_comp_0.sg13g2_and2_2$1_0.VDD.t129 wind_comp_0.sg13g2_and2_2$1_0.VDD.t130 wind_comp_0.comparator_0.dynamic_pcell_0.VDD sg13_lv_pmos ad=0.17p pd=1.68u as=0 ps=0 w=0.5u l=0.5u
X222 wind_comp_0.sg13g2_and2_2$1_0.VSS.t117 wind_comp_0.sg13g2_and2_2$1_0.VSS.t115 wind_comp_0.comparator_1.dynamic_pcell_0.DRN_NET_GJ_GATE_GH wind_comp_0.sg13g2_and2_2$1_0.VSS.t116 sg13_lv_nmos ad=55.5f pd=0.74u as=55.5f ps=0.74u w=0.15u l=0.5u
X223 wind_comp_0.comparator_1.dynamic_pcell$1_0.DRN_NET_PQ_GATE_Q wind_comp_0.sg13g2_and2_2$1_0.VSS.t195 wind_comp_0.sg13g2_and2_2$1_0.VSS.t194 wind_comp_0.sg13g2_and2_2$1_0.VSS.t196 sg13_lv_nmos ad=63.19999f pd=0.74u as=63.19999f ps=0.74u w=0.26u l=0.5u
X224 wind_comp_0.comparator_0.sg13cmos5l_inv_16_0.A wind_comp_0.comparator_0.dynamic_pcell_0.DRN_NET_IH wind_comp_0.sg13g2_and2_2$1_0.VDD.t15 wind_comp_0.comparator_0.dynamic_pcell_0.VDD sg13_lv_pmos ad=0.2128p pd=1.5u as=0.2128p ps=1.5u w=1.12u l=0.13u
X225 wind_comp_0.sg13g2_and2_2$1_0.VSS.t128 wind_comp_0.sg13g2_and2_2$1_0.VSS.t129 wind_comp_0.sg13g2_and2_2$1_0.VSS.t128 wind_comp_0.sg13g2_and2_2$1_0.VSS.t121 sg13_lv_nmos ad=55.5f pd=0.74u as=0 ps=0 w=0.15u l=0.5u
X226 wind_comp_0.comparator_1.nmos$2_0.Drain wind_comp_0.comparator_1.nmos_0.Gate wind_comp_0.sg13g2_and2_2$1_0.VSS.t393 wind_comp_0.sg13g2_and2_2$1_0.VSS.t394 sg13_lv_nmos ad=0.1005p pd=1.34u as=55.5f ps=0.74u w=0.15u l=0.13u
X227 wind_comp_0.comparator_0.sg13cmos5l_inv_16_0.A wind_comp_0.comparator_0.dynamic_pcell_0.DRN_NET_IH wind_comp_0.sg13g2_and2_2$1_0.VDD.t11 wind_comp_0.comparator_0.dynamic_pcell_0.VDD sg13_lv_pmos ad=0.2128p pd=1.5u as=0.2128p ps=1.5u w=1.12u l=0.13u
X228 wind_comp_0.sg13g2_and2_2$1_0.B wind_comp_0.comparator_1.sg13cmos5l_inv_16_0.A wind_comp_0.sg13g2_and2_2$1_0.VSS.t376 wind_comp_0.sg13g2_and2_2$1_0.VSS.t377 sg13_lv_nmos ad=0.1406p pd=1.12u as=0.1406p ps=1.12u w=0.74u l=0.13u
X229 wind_comp_0.sg13g2_and2_2$1_0.VDD.t99 enable.t9 wind_comp_0.comparator_1.dynamic_pcell$7_0.DRN_NET_CF_GATE_CD wind_comp_0.comparator_1.dynamic_pcell$7_0.VDD sg13_lv_pmos ad=55.5f pd=0.74u as=0.1005p ps=1.34u w=0.15u l=0.13u
X230 wind_comp_0.sg13g2_and2_2$1_0.VDD.t143 wind_comp_0.sg13g2_and2_2$1_0.VDD.t141 wind_comp_0.sg13g2_and2_2$1_0.VDD.t142 wind_comp_0.comparator_0.dynamic_pcell_0.VDD sg13_lv_pmos ad=0.119p pd=1.38u as=0 ps=0 w=0.35u l=0.5u
X231 wind_comp_0.sg13g2_and2_2$1_0.VSS.t62 wind_comp_0.sg13g2_and2_2$1_0.VSS.t60 wind_comp_0.sg13g2_and2_2$1_0.VSS.t56 wind_comp_0.sg13g2_and2_2$1_0.VSS.t61 sg13_lv_nmos ad=0.1005p pd=1.34u as=0 ps=0 w=0.15u l=0.5u
X232 wind_comp_0.sg13g2_and2_2$1_0.VDD.t225 wind_comp_0.sg13g2_and2_2$1_0.VDD.t223 wind_comp_0.sg13g2_and2_2$1_0.VDD.t224 wind_comp_0.comparator_1.dynamic_pcell$7_0.VDD sg13_lv_pmos ad=0.17p pd=1.68u as=0 ps=0 w=0.5u l=0.5u
X233 wind_comp_0.sg13g2_and2_2$1_0.VSS.t322 wind_comp_0.comparator_1.dynamic_pcell_0.DRN_NET_IH wind_comp_0.comparator_1.sg13cmos5l_inv_16_0.A wind_comp_0.sg13g2_and2_2$1_0.VSS.t321 sg13_lv_nmos ad=0.1406p pd=1.12u as=0.1406p ps=1.12u w=0.74u l=0.13u
X234 wind_comp_0.sg13g2_and2_2$1_0.VSS.t305 wind_comp_0.comparator_1.dynamic_pcell_0.DRN_NET_IH wind_comp_0.comparator_1.sg13cmos5l_inv_16_0.A wind_comp_0.sg13g2_and2_2$1_0.VSS.t293 sg13_lv_nmos ad=0.1406p pd=1.12u as=0.1406p ps=1.12u w=0.74u l=0.13u
X235 wind_comp_0.sg13g2_and2_2$1_0.A wind_comp_0.comparator_0.sg13cmos5l_inv_16_0.A wind_comp_0.sg13g2_and2_2$1_0.VSS.t343 wind_comp_0.sg13g2_and2_2$1_0.VSS.t344 sg13_lv_nmos ad=0.1406p pd=1.12u as=0.1406p ps=1.12u w=0.74u l=0.13u
X236 wind_comp_0.sg13g2_and2_2$1_0.B wind_comp_0.comparator_1.sg13cmos5l_inv_16_0.A wind_comp_0.sg13g2_and2_2$1_0.VDD.t87 wind_comp_0.comparator_1.dynamic_pcell$7_0.VDD sg13_lv_pmos ad=0.2128p pd=1.5u as=0.2128p ps=1.5u w=1.12u l=0.13u
X237 wind_comp_0.comparator_0.dynamic_pcell_0.DRN_NET_IH wind_comp_0.sg13g2_and2_2$1_0.VSS.t76 wind_comp_0.sg13g2_and2_2$1_0.VSS.t74 wind_comp_0.sg13g2_and2_2$1_0.VSS.t55 sg13_lv_nmos ad=55.5f pd=0.74u as=55.5f ps=0.74u w=0.15u l=0.5u
X238 wind_comp_0.comparator_1.dynamic_pcell_0.SRC_NET_IJ wind_comp_0.comparator_1.dynamic_pcell$2_0.DRN_NET_LM_GATE_KL wind_comp_0.sg13g2_and2_2$1_0.VDD.t33 wind_comp_0.comparator_1.dynamic_pcell$7_0.VDD sg13_lv_pmos ad=95f pd=0.88u as=95f ps=0.88u w=0.5u l=3u
X239 wind_comp_0.sg13g2_and2_2$1_0.VSS.t175 wind_comp_0.sg13g2_and2_2$1_0.VSS.t173 wind_comp_0.sg13g2_and2_2$1_0.VSS.t174 wind_comp_0.sg13g2_and2_2$1_0.VSS.t154 sg13_lv_nmos ad=0.1082p pd=1.34u as=0 ps=0 w=0.26u l=0.5u
X240 wind_comp_0.sg13g2_and2_2$1_0.A wind_comp_0.comparator_0.sg13cmos5l_inv_16_0.A wind_comp_0.sg13g2_and2_2$1_0.VSS.t337 wind_comp_0.sg13g2_and2_2$1_0.VSS.t338 sg13_lv_nmos ad=0.1406p pd=1.12u as=0.1406p ps=1.12u w=0.74u l=0.13u
X241 wind_comp_0.sg13g2_and2_2$1_0.VSS.t108 wind_comp_0.sg13g2_and2_2$1_0.VSS.t107 wind_comp_0.comparator_1.dynamic_pcell$7_0.DRN_NET_BE_GATE_AB wind_comp_0.sg13g2_and2_2$1_0.VSS.t102 sg13_lv_nmos ad=63.19999f pd=0.74u as=63.19999f ps=0.74u w=0.26u l=0.5u
X242 wind_comp_0.comparator_1.dynamic_pcell$1_0.P_GATE wind_comp_0.sg13g2_and2_2$1_0.VSS.t204 wind_comp_0.sg13g2_and2_2$1_0.VSS.t203 wind_comp_0.sg13g2_and2_2$1_0.VSS.t196 sg13_lv_nmos ad=63.19999f pd=0.74u as=63.19999f ps=0.74u w=0.26u l=0.5u
X243 wind_comp_0.comparator_1.dynamic_pcell$1_0.DRN_NET_PQ_GATE_Q wind_comp_0.comparator_1.dynamic_pcell$1_0.P_GATE wind_comp_0.sg13g2_and2_2$1_0.VSS.t300 wind_comp_0.sg13g2_and2_2$1_0.VSS.t297 sg13_lv_nmos ad=63.19999f pd=0.74u as=63.19999f ps=0.74u w=0.26u l=10u
X244 wind_comp_0.sg13g2_and2_2$1_0.VSS.t274 wind_comp_0.comparator_0.dynamic_pcell$1_0.DRN_NET_PQ_GATE_Q wind_comp_0.comparator_0.dynamic_pcell$1_0.DRN_NET_PQ_GATE_Q wind_comp_0.sg13g2_and2_2$1_0.VSS.t268 sg13_lv_nmos ad=63.19999f pd=0.74u as=63.19999f ps=0.74u w=0.26u l=10u
X245 wind_comp_0.comparator_0.dynamic_pcell$7_0.DRN_NET_CF_GATE_CD wind_comp_0.sg13g2_and2_2$1_0.VSS.t81 wind_comp_0.sg13g2_and2_2$1_0.VSS.t80 wind_comp_0.sg13g2_and2_2$1_0.VSS.t82 sg13_lv_nmos ad=63.19999f pd=0.74u as=63.19999f ps=0.74u w=0.26u l=0.5u
X246 wind_comp_0.sg13g2_and2_2$1_0.VSS.t264 wind_comp_0.comparator_0.dynamic_pcell_0.DRN_NET_IH wind_comp_0.comparator_0.sg13cmos5l_inv_16_0.A wind_comp_0.sg13g2_and2_2$1_0.VSS.t263 sg13_lv_nmos ad=0.1406p pd=1.12u as=0.1406p ps=1.12u w=0.74u l=0.13u
X247 wind_comp_0.comparator_0.dynamic_pcell$2_0.O_DRN wind_comp_0.comparator_0.nmos$2_0.Drain wind_comp_0.sg13g2_and2_2$1_0.VSS.t27 wind_comp_0.sg13g2_and2_2$1_0.VSS.t283 sg13_lv_nmos ad=0.95p pd=5.38u as=0.95p ps=5.38u w=5u l=3u
X248 wind_comp_0.sg13g2_and2_2$1_0.VSS.t379 wind_comp_0.comparator_1.sg13cmos5l_inv_16_0.A wind_comp_0.sg13g2_and2_2$1_0.B wind_comp_0.sg13g2_and2_2$1_0.VSS.t378 sg13_lv_nmos ad=0.1406p pd=1.12u as=0.1406p ps=1.12u w=0.74u l=0.13u
X249 wind_comp_0.comparator_0.sg13cmos5l_inv_16_0.A wind_comp_0.comparator_0.dynamic_pcell_0.DRN_NET_IH wind_comp_0.sg13g2_and2_2$1_0.VSS.t267 wind_comp_0.sg13g2_and2_2$1_0.VSS.t268 sg13_lv_nmos ad=0.1406p pd=1.12u as=0.1406p ps=1.12u w=0.74u l=0.13u
X250 wind_comp_0.sg13g2_and2_2$1_0.VSS.t404 enable.t5 wind_comp_0.comparator_0.nmos_0.Gate wind_comp_0.sg13g2_and2_2$1_0.VSS.t403 sg13_lv_nmos ad=0.2516p pd=2.16u as=0.2516p ps=2.16u w=0.74u l=0.13u
X251 enable.t7 wind_comp_0.comparator_0.dynamic_pcell_0.VDD dpantenna l=1.34u w=1.05u
X252 wind_comp_0.sg13g2_and2_2$1_0.VDD.t220 wind_comp_0.sg13g2_and2_2$1_0.VDD.t221 wind_comp_0.sg13g2_and2_2$1_0.VDD.t222 wind_comp_0.comparator_1.dynamic_pcell$7_0.VDD sg13_lv_pmos ad=95f pd=0.88u as=0 ps=0 w=0.5u l=0.5u
X253 wind_comp_0.sg13g2_and2_2$1_0.VSS.t277 wind_comp_0.comparator_0.dynamic_pcell$1_0.DRN_NET_PQ_GATE_Q wind_comp_0.comparator_0.dynamic_pcell$1_0.P_GATE wind_comp_0.sg13g2_and2_2$1_0.VSS.t268 sg13_lv_nmos ad=63.19999f pd=0.74u as=63.19999f ps=0.74u w=0.26u l=10u
X254 wind_comp_0.sg13g2_and2_2$1_0.VSS.t373 wind_comp_0.comparator_1.sg13cmos5l_inv_16_0.A wind_comp_0.sg13g2_and2_2$1_0.B wind_comp_0.sg13g2_and2_2$1_0.VSS.t372 sg13_lv_nmos ad=0.1406p pd=1.12u as=0.1406p ps=1.12u w=0.74u l=0.13u
X255 wind_comp_0.sg13g2_and2_2$1_0.VDD.t123 wind_comp_0.sg13g2_and2_2$1_0.VDD.t121 wind_comp_0.sg13g2_and2_2$1_0.VDD.t122 wind_comp_0.comparator_0.dynamic_pcell_0.VDD sg13_lv_pmos ad=0.17p pd=1.68u as=0 ps=0 w=0.5u l=0.5u
X256 wind_comp_0.sg13g2_and2_2$1_0.VSS.t68 wind_comp_0.sg13g2_and2_2$1_0.VSS.t71 wind_comp_0.sg13g2_and2_2$1_0.VSS.t68 wind_comp_0.sg13g2_and2_2$1_0.VSS.t64 sg13_lv_nmos ad=55.5f pd=0.74u as=0 ps=0 w=0.15u l=0.5u
X257 wind_comp_0.sg13g2_and2_2$1_0.VSS.t340 wind_comp_0.comparator_0.sg13cmos5l_inv_16_0.A wind_comp_0.sg13g2_and2_2$1_0.A wind_comp_0.sg13g2_and2_2$1_0.VSS.t339 sg13_lv_nmos ad=0.1406p pd=1.12u as=0.1406p ps=1.12u w=0.74u l=0.13u
X258 wind_comp_0.sg13g2_and2_2$1_0.VDD.t171 wind_comp_0.sg13g2_and2_2$1_0.VDD.t169 wind_comp_0.sg13g2_and2_2$1_0.VDD.t170 wind_comp_0.comparator_1.dynamic_pcell$7_0.VDD sg13_lv_pmos ad=0.119p pd=1.38u as=0 ps=0 w=0.35u l=0.5u
X259 wind_comp_0.comparator_1.sg13cmos5l_inv_16_0.A wind_comp_0.comparator_1.dynamic_pcell_0.DRN_NET_IH wind_comp_0.sg13g2_and2_2$1_0.VDD.t49 wind_comp_0.comparator_1.dynamic_pcell$7_0.VDD sg13_lv_pmos ad=0.2128p pd=1.5u as=0.2128p ps=1.5u w=1.12u l=0.13u
X260 wind_comp_0.sg13g2_and2_2$1_0.VDD.t67 wind_comp_0.comparator_0.sg13cmos5l_inv_16_0.A wind_comp_0.sg13g2_and2_2$1_0.A wind_comp_0.comparator_0.dynamic_pcell_0.VDD sg13_lv_pmos ad=0.2128p pd=1.5u as=0.2128p ps=1.5u w=1.12u l=0.13u
X261 wind_comp_0.comparator_0.dynamic_pcell$7_0.DRN_NET_CF_GATE_CD wind_comp_0.comparator_0.dynamic_pcell$7_0.DRN_NET_CF_GATE_CD wind_comp_0.sg13g2_and2_2$1_0.VDD.t8 wind_comp_0.comparator_0.dynamic_pcell_0.VDD sg13_lv_pmos ad=0.119p pd=1.38u as=66.49999f ps=0.73u w=0.35u l=1u
X262 wind_comp_0.sg13g2_and2_2$1_0.VSS.t302 wind_comp_0.comparator_1.dynamic_pcell$1_0.DRN_NET_PQ_GATE_Q wind_comp_0.comparator_1.dynamic_pcell$1_0.P_GATE wind_comp_0.sg13g2_and2_2$1_0.VSS.t299 sg13_lv_nmos ad=63.19999f pd=0.74u as=63.19999f ps=0.74u w=0.26u l=10u
X263 wind_comp_0.sg13g2_and2_2$1_0.VSS.t161 wind_comp_0.sg13g2_and2_2$1_0.VSS.t159 wind_comp_0.comparator_0.dynamic_pcell$1_0.DRN_NET_PQ_GATE_Q wind_comp_0.sg13g2_and2_2$1_0.VSS.t160 sg13_lv_nmos ad=63.19999f pd=0.74u as=63.19999f ps=0.74u w=0.26u l=0.5u
X264 wind_comp_0.comparator_1.nmos$2_0.Drain wind_comp_0.sg13g2_and2_2$1_0.VSS.t241 wind_comp_0.sg13g2_and2_2$1_0.VSS.t238 wind_comp_0.sg13g2_and2_2$1_0.VSS.t30 sg13_lv_nmos ad=0.95p pd=5.38u as=0.95p ps=5.38u w=5u l=0.5u
X265 wind_comp_0.sg13g2_and2_2$1_0.VDD.t216 wind_comp_0.sg13g2_and2_2$1_0.VDD.t214 wind_comp_0.sg13g2_and2_2$1_0.VDD.t215 wind_comp_0.comparator_1.dynamic_pcell$7_0.VDD sg13_lv_pmos ad=0.17p pd=1.68u as=0 ps=0 w=0.5u l=0.5u
X266 wind_comp_0.sg13g2_and2_2$1_0.VSS.t52 wind_comp_0.comparator_0.nmos$2_0.Drain wind_comp_0.comparator_0.dynamic_pcell$2_0.O_DRN wind_comp_0.sg13g2_and2_2$1_0.VSS.t285 sg13_lv_nmos ad=0.95p pd=5.38u as=0.95p ps=5.38u w=5u l=3u
X267 wind_comp_0.sg13g2_and2_2$1_0.VSS.t247 wind_comp_0.comparator_0.nmos_0.Gate wind_comp_0.comparator_0.nmos$2_0.Drain wind_comp_0.sg13g2_and2_2$1_0.VSS.t248 sg13_lv_nmos ad=55.5f pd=0.74u as=0.1005p ps=1.34u w=0.15u l=0.13u
X268 wind_comp_0.sg13g2_and2_2$1_0.VSS.t65 wind_comp_0.sg13g2_and2_2$1_0.VSS.t69 wind_comp_0.comparator_0.dynamic_pcell_0.DRN_NET_GJ_GATE_GH wind_comp_0.sg13g2_and2_2$1_0.VSS.t67 sg13_lv_nmos ad=55.5f pd=0.74u as=55.5f ps=0.74u w=0.15u l=0.5u
X269 enable.t6 wind_comp_0.comparator_1.dynamic_pcell$7_0.VDD dpantenna l=1.34u w=1.05u
X270 wind_comp_0.sg13g2_and2_2$1_0.VSS.t211 wind_comp_0.sg13g2_and2_2$1_0.VSS.t210 wind_comp_0.sg13g2_and2_2$1_0.VSS.t211 wind_comp_0.sg13g2_and2_2$1_0.VSS.t177 sg13_lv_nmos ad=0.1082p pd=1.34u as=0 ps=0 w=0.26u l=0.5u
X271 wind_comp_0.comparator_0.dynamic_pcell$1_0.DRN_NET_PQ_GATE_Q wind_comp_0.sg13g2_and2_2$1_0.VSS.t157 wind_comp_0.sg13g2_and2_2$1_0.VSS.t155 wind_comp_0.sg13g2_and2_2$1_0.VSS.t158 sg13_lv_nmos ad=63.19999f pd=0.74u as=63.19999f ps=0.74u w=0.26u l=0.5u
X272 wind_comp_0.comparator_0.dynamic_pcell_0.DRN_NET_IH wind_comp_0.comparator_0.dynamic_pcell$1_0.DRN_NET_PQ_GATE_Q wind_comp_0.comparator_0.dynamic_pcell_0.SRC_NET_IJ wind_comp_0.comparator_0.dynamic_pcell_0.VDD sg13_lv_pmos ad=0.5928p pd=3.5u as=0.5928p ps=3.5u w=3.12u l=1u
X273 analog_bus1 a_51539_28086# wind_comp_0.sg13g2_and2_2$1_0.VSS.t327 wind_comp_0.sg13g2_and2_2$1_0.VSS.t326 sg13_lv_nmos ad=0.1406p pd=1.12u as=0.1331p ps=1.12u w=0.74u l=0.13u
X274 wind_comp_0.comparator_0.dynamic_pcell_0.DRN_NET_GJ_GATE_GH wind_comp_0.comparator_0.dynamic_pcell$1_0.P_GATE wind_comp_0.comparator_0.dynamic_pcell_0.SRC_NET_IJ wind_comp_0.comparator_0.dynamic_pcell_0.VDD sg13_lv_pmos ad=0.5928p pd=3.5u as=0.5928p ps=3.5u w=3.12u l=1u
X275 wind_comp_0.sg13g2_and2_2$1_0.VDD.t77 wind_comp_0.comparator_1.sg13cmos5l_inv_16_0.A wind_comp_0.sg13g2_and2_2$1_0.B wind_comp_0.comparator_1.dynamic_pcell$7_0.VDD sg13_lv_pmos ad=0.2128p pd=1.5u as=0.2128p ps=1.5u w=1.12u l=0.13u
X276 wind_comp_0.comparator_0.dynamic_pcell$2_0.DRN_NET_LM_GATE_KL wind_comp_0.comparator_0.nmos$2_0.Drain wind_comp_0.sg13g2_and2_2$1_0.VSS.t284 wind_comp_0.sg13g2_and2_2$1_0.VSS.t285 sg13_lv_nmos ad=0.95p pd=5.38u as=0.95p ps=5.38u w=5u l=3u
X277 wind_comp_0.sg13g2_and2_2$1_0.VSS.t316 wind_comp_0.comparator_1.dynamic_pcell_0.DRN_NET_IH wind_comp_0.comparator_1.sg13cmos5l_inv_16_0.A wind_comp_0.sg13g2_and2_2$1_0.VSS.t315 sg13_lv_nmos ad=0.1406p pd=1.12u as=0.1406p ps=1.12u w=0.74u l=0.13u
X278 wind_comp_0.sg13g2_and2_2$1_0.VSS.t399 enable.t4 dantenna l=0.78u w=0.78u
X279 wind_comp_0.sg13g2_and2_2$1_0.VDD.t53 a_51539_28086# analog_bus1 wind_comp_0.sg13g2_and2_2$1_0.VDD.t4 sg13_lv_pmos ad=0.4256p pd=3u as=0.2128p ps=1.5u w=1.12u l=0.13u
X280 wind_comp_0.sg13g2_and2_2$1_0.B wind_comp_0.comparator_1.sg13cmos5l_inv_16_0.A wind_comp_0.sg13g2_and2_2$1_0.VDD.t83 wind_comp_0.comparator_1.dynamic_pcell$7_0.VDD sg13_lv_pmos ad=0.2128p pd=1.5u as=0.2128p ps=1.5u w=1.12u l=0.13u
X281 wind_comp_0.comparator_0.dynamic_pcell_0.SRC_NET_IJ wind_comp_0.comparator_0.dynamic_pcell$2_0.DRN_NET_LM_GATE_KL wind_comp_0.sg13g2_and2_2$1_0.VDD.t54 wind_comp_0.comparator_0.dynamic_pcell_0.VDD sg13_lv_pmos ad=95f pd=0.88u as=95f ps=0.88u w=0.5u l=3u
X282 wind_comp_0.sg13g2_and2_2$1_0.VSS.t170 wind_comp_0.sg13g2_and2_2$1_0.VSS.t169 wind_comp_0.comparator_0.dynamic_pcell$1_0.P_GATE wind_comp_0.sg13g2_and2_2$1_0.VSS.t160 sg13_lv_nmos ad=63.19999f pd=0.74u as=63.19999f ps=0.74u w=0.26u l=0.5u
X283 a_51633_28086# wind_comp_0.sg13g2_and2_2$1_0.A a_51539_28086# wind_comp_0.sg13g2_and2_2$1_0.VSS.t6 sg13_lv_nmos ad=0.1216p pd=1.02u as=0.2176p ps=1.96u w=0.64u l=0.13u
X284 wind_comp_0.sg13g2_and2_2$1_0.VDD.t23 wind_comp_0.comparator_0.dynamic_pcell_0.DRN_NET_IH wind_comp_0.comparator_0.sg13cmos5l_inv_16_0.A wind_comp_0.comparator_0.dynamic_pcell_0.VDD sg13_lv_pmos ad=0.2128p pd=1.5u as=0.2128p ps=1.5u w=1.12u l=0.13u
X285 wind_comp_0.sg13g2_and2_2$1_0.VDD.t178 wind_comp_0.sg13g2_and2_2$1_0.VDD.t176 wind_comp_0.sg13g2_and2_2$1_0.VDD.t175 wind_comp_0.comparator_1.dynamic_pcell$7_0.VDD sg13_lv_pmos ad=66.49999f pd=0.73u as=0 ps=0 w=0.35u l=0.5u
X286 wind_comp_0.sg13g2_and2_2$1_0.B wind_comp_0.comparator_1.sg13cmos5l_inv_16_0.A wind_comp_0.sg13g2_and2_2$1_0.VDD.t79 wind_comp_0.comparator_1.dynamic_pcell$7_0.VDD sg13_lv_pmos ad=0.2128p pd=1.5u as=0.2128p ps=1.5u w=1.12u l=0.13u
X287 wind_comp_0.sg13g2_and2_2$1_0.VDD.t26 wind_comp_0.comparator_1.dynamic_pcell$7_0.DRN_NET_BE_GATE_AB wind_comp_0.comparator_1.dynamic_pcell$7_0.DRN_NET_BE_GATE_AB wind_comp_0.comparator_1.dynamic_pcell$7_0.VDD sg13_lv_pmos ad=66.49999f pd=0.73u as=0.119p ps=1.38u w=0.35u l=1u
X288 wind_comp_0.sg13g2_and2_2$1_0.VDD.t94 enable.t5 wind_comp_0.comparator_0.nmos_0.Gate wind_comp_0.comparator_0.dynamic_pcell_0.VDD sg13_lv_pmos ad=0.3808p pd=2.92u as=0.3808p ps=2.92u w=1.12u l=0.13u
X289 ibias enable.t1 wind_comp_0.comparator_0.nmos$2_0.Drain wind_comp_0.sg13g2_and2_2$1_0.VSS.t407 sg13_lv_nmos ad=55.5f pd=0.74u as=0.1005p ps=1.34u w=0.15u l=0.13u
X290 wind_comp_0.sg13g2_and2_2$1_0.VDD.t51 wind_comp_0.comparator_1.dynamic_pcell_0.DRN_NET_IH wind_comp_0.comparator_1.sg13cmos5l_inv_16_0.A wind_comp_0.comparator_1.dynamic_pcell$7_0.VDD sg13_lv_pmos ad=0.4368p pd=3.02u as=0.2128p ps=1.5u w=1.12u l=0.13u
X291 wind_comp_0.sg13g2_and2_2$1_0.VSS.t240 wind_comp_0.sg13g2_and2_2$1_0.VSS.t239 wind_comp_0.comparator_1.dynamic_pcell$2_0.DRN_NET_LM_GATE_KL wind_comp_0.sg13g2_and2_2$1_0.VSS.t36 sg13_lv_nmos ad=0.95p pd=5.38u as=0.95p ps=5.38u w=5u l=0.5u
X292 wind_comp_0.sg13g2_and2_2$1_0.A wind_comp_0.comparator_0.sg13cmos5l_inv_16_0.A wind_comp_0.sg13g2_and2_2$1_0.VDD.t67 wind_comp_0.comparator_0.dynamic_pcell_0.VDD sg13_lv_pmos ad=0.2128p pd=1.5u as=0.2128p ps=1.5u w=1.12u l=0.13u
X293 wind_comp_0.sg13g2_and2_2$1_0.VSS.t294 wind_comp_0.comparator_1.dynamic_pcell_0.DRN_NET_GJ_GATE_GH wind_comp_0.comparator_1.dynamic_pcell_0.DRN_NET_GJ_GATE_GH wind_comp_0.sg13g2_and2_2$1_0.VSS.t293 sg13_lv_nmos ad=55.5f pd=0.74u as=55.5f ps=0.74u w=0.15u l=3u
X294 wind_comp_0.sg13g2_and2_2$1_0.VSS.t53 wind_comp_0.sg13g2_and2_2$1_0.VSS.t51 wind_comp_0.sg13g2_and2_2$1_0.VSS.t52 wind_comp_0.sg13g2_and2_2$1_0.VSS.t21 sg13_lv_nmos ad=0.95p pd=5.38u as=0 ps=0 w=5u l=0.5u
X295 wind_comp_0.comparator_0.dynamic_pcell$1_0.P_GATE wind_comp_0.sg13g2_and2_2$1_0.VSS.t167 wind_comp_0.sg13g2_and2_2$1_0.VSS.t165 wind_comp_0.sg13g2_and2_2$1_0.VSS.t158 sg13_lv_nmos ad=63.19999f pd=0.74u as=63.19999f ps=0.74u w=0.26u l=0.5u
X296 wind_comp_0.sg13g2_and2_2$1_0.B wind_comp_0.comparator_1.sg13cmos5l_inv_16_0.A wind_comp_0.sg13g2_and2_2$1_0.VSS.t368 wind_comp_0.sg13g2_and2_2$1_0.VSS.t367 sg13_lv_nmos ad=0.1406p pd=1.12u as=0.2516p ps=2.16u w=0.74u l=0.13u
X297 wind_comp_0.sg13g2_and2_2$1_0.A wind_comp_0.comparator_0.sg13cmos5l_inv_16_0.A wind_comp_0.sg13g2_and2_2$1_0.VDD.t63 wind_comp_0.comparator_0.dynamic_pcell_0.VDD sg13_lv_pmos ad=0.2128p pd=1.5u as=0.2128p ps=1.5u w=1.12u l=0.13u
X298 wind_comp_0.sg13g2_and2_2$1_0.VSS.t98 wind_comp_0.sg13g2_and2_2$1_0.VSS.t96 wind_comp_0.sg13g2_and2_2$1_0.VSS.t98 wind_comp_0.sg13g2_and2_2$1_0.VSS.t97 sg13_lv_nmos ad=63.19999f pd=0.74u as=0 ps=0 w=0.26u l=0.5u
X299 wind_comp_0.comparator_0.dynamic_pcell$2_0.DRN_NET_LM_GATE_KL wind_comp_0.sg13g2_and2_2$1_0.VSS.t146 wind_comp_0.sg13g2_and2_2$1_0.VSS.t144 wind_comp_0.sg13g2_and2_2$1_0.VSS.t19 sg13_lv_nmos ad=0.95p pd=5.38u as=0.95p ps=5.38u w=5u l=0.5u
X300 wind_comp_0.sg13g2_and2_2$1_0.A wind_comp_0.comparator_0.sg13cmos5l_inv_16_0.A wind_comp_0.sg13g2_and2_2$1_0.VDD.t60 wind_comp_0.comparator_0.dynamic_pcell_0.VDD sg13_lv_pmos ad=0.2128p pd=1.5u as=0.4368p ps=3.02u w=1.12u l=0.13u
X301 wind_comp_0.sg13g2_and2_2$1_0.VSS.t22 wind_comp_0.sg13g2_and2_2$1_0.VSS.t20 wind_comp_0.comparator_0.dynamic_pcell$2_0.DRN_NET_LM_GATE_KL wind_comp_0.sg13g2_and2_2$1_0.VSS.t21 sg13_lv_nmos ad=0.95p pd=5.38u as=0.95p ps=5.38u w=5u l=0.5u
X302 wind_comp_0.sg13g2_and2_2$1_0.VSS.t391 wind_comp_0.comparator_1.sg13cmos5l_inv_16_0.A wind_comp_0.sg13g2_and2_2$1_0.B wind_comp_0.sg13g2_and2_2$1_0.VSS.t390 sg13_lv_nmos ad=0.2516p pd=2.16u as=0.1406p ps=1.12u w=0.74u l=0.13u
X303 wind_comp_0.comparator_1.dynamic_pcell$7_0.DRN_NET_CF_GATE_CD wind_comp_0.sg13g2_and2_2$1_0.VSS.t105 wind_comp_0.sg13g2_and2_2$1_0.VSS.t104 wind_comp_0.sg13g2_and2_2$1_0.VSS.t100 sg13_lv_nmos ad=63.19999f pd=0.74u as=63.19999f ps=0.74u w=0.26u l=0.5u
X304 wind_comp_0.sg13g2_and2_2$1_0.VSS.t401 enable.t3 dantenna l=0.78u w=0.78u
X305 wind_comp_0.sg13g2_and2_2$1_0.VDD.t118 wind_comp_0.sg13g2_and2_2$1_0.VDD.t117 wind_comp_0.comparator_0.dynamic_pcell_0.SRC_NET_IJ wind_comp_0.comparator_0.dynamic_pcell_0.VDD sg13_lv_pmos ad=95f pd=0.88u as=95f ps=0.88u w=0.5u l=0.5u
X306 wind_comp_0.sg13g2_and2_2$1_0.VSS.t385 wind_comp_0.comparator_1.sg13cmos5l_inv_16_0.A wind_comp_0.sg13g2_and2_2$1_0.B wind_comp_0.sg13g2_and2_2$1_0.VSS.t384 sg13_lv_nmos ad=0.1406p pd=1.12u as=0.1406p ps=1.12u w=0.74u l=0.13u
X307 wind_comp_0.comparator_1.sg13cmos5l_inv_16_0.A wind_comp_0.comparator_1.dynamic_pcell_0.DRN_NET_IH wind_comp_0.sg13g2_and2_2$1_0.VSS.t316 wind_comp_0.sg13g2_and2_2$1_0.VSS.t317 sg13_lv_nmos ad=0.1406p pd=1.12u as=0.1406p ps=1.12u w=0.74u l=0.13u
X308 wind_comp_0.sg13g2_and2_2$1_0.VSS.t358 wind_comp_0.comparator_0.sg13cmos5l_inv_16_0.A wind_comp_0.sg13g2_and2_2$1_0.A wind_comp_0.sg13g2_and2_2$1_0.VSS.t357 sg13_lv_nmos ad=0.2516p pd=2.16u as=0.1406p ps=1.12u w=0.74u l=0.13u
X309 wind_comp_0.sg13g2_and2_2$1_0.VSS.t199 wind_comp_0.sg13g2_and2_2$1_0.VSS.t197 wind_comp_0.comparator_1.dynamic_pcell$1_0.DRN_NET_PQ_GATE_Q wind_comp_0.sg13g2_and2_2$1_0.VSS.t198 sg13_lv_nmos ad=63.19999f pd=0.74u as=63.19999f ps=0.74u w=0.26u l=0.5u
X310 wind_comp_0.comparator_1.dynamic_pcell$2_0.O_DRN wind_comp_0.comparator_1.nmos$2_0.Drain wind_comp_0.sg13g2_and2_2$1_0.VSS.t229 wind_comp_0.sg13g2_and2_2$1_0.VSS.t359 sg13_lv_nmos ad=0.95p pd=5.38u as=0.95p ps=5.38u w=5u l=3u
X311 wind_comp_0.comparator_1.sg13cmos5l_inv_16_0.A wind_comp_0.comparator_1.dynamic_pcell_0.DRN_NET_IH wind_comp_0.sg13g2_and2_2$1_0.VSS.t310 wind_comp_0.sg13g2_and2_2$1_0.VSS.t311 sg13_lv_nmos ad=0.1406p pd=1.12u as=0.1406p ps=1.12u w=0.74u l=0.13u
X312 wind_comp_0.sg13g2_and2_2$1_0.VSS.t352 wind_comp_0.comparator_0.sg13cmos5l_inv_16_0.A wind_comp_0.sg13g2_and2_2$1_0.A wind_comp_0.sg13g2_and2_2$1_0.VSS.t351 sg13_lv_nmos ad=0.1406p pd=1.12u as=0.1406p ps=1.12u w=0.74u l=0.13u
X313 wind_comp_0.comparator_0.sg13cmos5l_inv_16_0.A wind_comp_0.comparator_0.dynamic_pcell_0.DRN_NET_IH wind_comp_0.sg13g2_and2_2$1_0.VDD.t19 wind_comp_0.comparator_0.dynamic_pcell_0.VDD sg13_lv_pmos ad=0.2128p pd=1.5u as=0.2128p ps=1.5u w=1.12u l=0.13u
X314 wind_comp_0.comparator_1.sg13cmos5l_inv_16_0.A wind_comp_0.comparator_1.dynamic_pcell_0.DRN_NET_IH wind_comp_0.sg13g2_and2_2$1_0.VSS.t305 wind_comp_0.sg13g2_and2_2$1_0.VSS.t306 sg13_lv_nmos ad=0.1406p pd=1.12u as=0.1406p ps=1.12u w=0.74u l=0.13u
X315 wind_comp_0.sg13g2_and2_2$1_0.VDD.t158 wind_comp_0.sg13g2_and2_2$1_0.VDD.t157 wind_comp_0.comparator_1.dynamic_pcell$1_0.DRN_NET_PQ_GATE_Q wind_comp_0.comparator_1.dynamic_pcell$7_0.VDD sg13_lv_pmos ad=66.49999f pd=0.73u as=66.49999f ps=0.73u w=0.35u l=0.5u
X316 wind_comp_0.comparator_0.dynamic_pcell$2_0.O_DRN s4_an wind_comp_0.comparator_0.dynamic_pcell$7_0.DRN_NET_BE_GATE_AB wind_comp_0.sg13g2_and2_2$1_0.VSS.t395 sg13_lv_nmos ad=63.19999f pd=0.74u as=63.19999f ps=0.74u w=0.26u l=3u
X317 wind_comp_0.comparator_1.dynamic_pcell$2_0.DRN_NET_LM_GATE_KL wind_comp_0.comparator_1.nmos$2_0.Drain wind_comp_0.sg13g2_and2_2$1_0.VSS.t365 wind_comp_0.sg13g2_and2_2$1_0.VSS.t361 sg13_lv_nmos ad=0.95p pd=5.38u as=0.95p ps=5.38u w=5u l=3u
X318 wind_comp_0.sg13g2_and2_2$1_0.VSS.t360 wind_comp_0.comparator_1.nmos$2_0.Drain wind_comp_0.comparator_1.dynamic_pcell$2_0.DRN_NET_LM_GATE_KL wind_comp_0.sg13g2_and2_2$1_0.VSS.t359 sg13_lv_nmos ad=0.95p pd=5.38u as=0.95p ps=5.38u w=5u l=3u
X319 wind_comp_0.comparator_0.sg13cmos5l_inv_16_0.A wind_comp_0.comparator_0.dynamic_pcell_0.DRN_NET_IH wind_comp_0.sg13g2_and2_2$1_0.VSS.t258 wind_comp_0.sg13g2_and2_2$1_0.VSS.t259 sg13_lv_nmos ad=0.1406p pd=1.12u as=0.1406p ps=1.12u w=0.74u l=0.13u
X320 wind_comp_0.sg13g2_and2_2$1_0.VDD.t181 wind_comp_0.sg13g2_and2_2$1_0.VDD.t179 wind_comp_0.sg13g2_and2_2$1_0.VDD.t180 wind_comp_0.comparator_1.dynamic_pcell$7_0.VDD sg13_lv_pmos ad=1.0608p pd=6.92u as=0 ps=0 w=3.12u l=0.5u
X321 wind_comp_0.sg13g2_and2_2$1_0.VDD.t198 wind_comp_0.sg13g2_and2_2$1_0.VDD.t196 wind_comp_0.sg13g2_and2_2$1_0.VDD.t197 wind_comp_0.comparator_1.dynamic_pcell$7_0.VDD sg13_lv_pmos ad=1.0608p pd=6.92u as=0 ps=0 w=3.12u l=0.5u
X322 wind_comp_0.comparator_0.sg13cmos5l_inv_16_0.A wind_comp_0.comparator_0.dynamic_pcell_0.DRN_NET_IH wind_comp_0.sg13g2_and2_2$1_0.VSS.t252 wind_comp_0.sg13g2_and2_2$1_0.VSS.t253 sg13_lv_nmos ad=0.1406p pd=1.12u as=0.1406p ps=1.12u w=0.74u l=0.13u
X323 wind_comp_0.sg13g2_and2_2$1_0.VDD.t31 wind_comp_0.comparator_1.dynamic_pcell$2_0.DRN_NET_LM_GATE_KL wind_comp_0.comparator_1.dynamic_pcell_0.SRC_NET_IJ wind_comp_0.comparator_1.dynamic_pcell$7_0.VDD sg13_lv_pmos ad=95f pd=0.88u as=95f ps=0.88u w=0.5u l=3u
X324 wind_comp_0.sg13g2_and2_2$1_0.VSS.t207 wind_comp_0.sg13g2_and2_2$1_0.VSS.t206 wind_comp_0.comparator_1.dynamic_pcell$1_0.P_GATE wind_comp_0.sg13g2_and2_2$1_0.VSS.t198 sg13_lv_nmos ad=63.19999f pd=0.74u as=63.19999f ps=0.74u w=0.26u l=0.5u
X325 wind_comp_0.sg13g2_and2_2$1_0.VSS.t114 wind_comp_0.sg13g2_and2_2$1_0.VSS.t111 wind_comp_0.sg13g2_and2_2$1_0.VSS.t113 wind_comp_0.sg13g2_and2_2$1_0.VSS.t112 sg13_lv_nmos ad=0.1005p pd=1.34u as=0 ps=0 w=0.15u l=0.5u
X326 wind_comp_0.sg13g2_and2_2$1_0.VSS.t136 wind_comp_0.sg13g2_and2_2$1_0.VSS.t134 wind_comp_0.sg13g2_and2_2$1_0.VSS.t132 wind_comp_0.sg13g2_and2_2$1_0.VSS.t30 sg13_lv_nmos ad=0.95p pd=5.38u as=0 ps=0 w=5u l=0.5u
X327 wind_comp_0.sg13g2_and2_2$1_0.VDD.t58 wind_comp_0.comparator_0.dynamic_pcell$2_0.DRN_NET_LM_GATE_KL wind_comp_0.comparator_0.dynamic_pcell_0.SRC_NET_IJ wind_comp_0.comparator_0.dynamic_pcell_0.VDD sg13_lv_pmos ad=95f pd=0.88u as=95f ps=0.88u w=0.5u l=3u
X328 wind_comp_0.comparator_1.dynamic_pcell$1_0.DRN_NET_PQ_GATE_Q wind_comp_0.comparator_1.dynamic_pcell$1_0.DRN_NET_PQ_GATE_Q wind_comp_0.sg13g2_and2_2$1_0.VSS.t298 wind_comp_0.sg13g2_and2_2$1_0.VSS.t297 sg13_lv_nmos ad=63.19999f pd=0.74u as=63.19999f ps=0.74u w=0.26u l=10u
X329 wind_comp_0.comparator_1.dynamic_pcell_0.DRN_NET_GJ_GATE_GH wind_comp_0.sg13g2_and2_2$1_0.VSS.t125 wind_comp_0.sg13g2_and2_2$1_0.VSS.t123 wind_comp_0.sg13g2_and2_2$1_0.VSS.t119 sg13_lv_nmos ad=55.5f pd=0.74u as=55.5f ps=0.74u w=0.15u l=0.5u
X330 wind_comp_0.comparator_1.dynamic_pcell_0.DRN_NET_IH wind_comp_0.comparator_1.dynamic_pcell_0.DRN_NET_GJ_GATE_GH wind_comp_0.sg13g2_and2_2$1_0.VSS.t294 wind_comp_0.sg13g2_and2_2$1_0.VSS.t291 sg13_lv_nmos ad=55.5f pd=0.74u as=55.5f ps=0.74u w=0.15u l=3u
X331 wind_comp_0.sg13g2_and2_2$1_0.VSS.t235 wind_comp_0.sg13g2_and2_2$1_0.VSS.t233 wind_comp_0.sg13g2_and2_2$1_0.VSS.t231 wind_comp_0.sg13g2_and2_2$1_0.VSS.t32 sg13_lv_nmos ad=0.95p pd=5.38u as=0 ps=0 w=5u l=0.5u
X332 wind_comp_0.sg13g2_and2_2$1_0.VSS.t186 wind_comp_0.sg13g2_and2_2$1_0.VSS.t185 wind_comp_0.sg13g2_and2_2$1_0.VSS.t186 wind_comp_0.sg13g2_and2_2$1_0.VSS.t154 sg13_lv_nmos ad=0.1082p pd=1.34u as=0 ps=0 w=0.26u l=0.5u
X333 wind_comp_0.sg13g2_and2_2$1_0.B wind_comp_0.comparator_1.sg13cmos5l_inv_16_0.A wind_comp_0.sg13g2_and2_2$1_0.VSS.t385 wind_comp_0.sg13g2_and2_2$1_0.VSS.t386 sg13_lv_nmos ad=0.1406p pd=1.12u as=0.1406p ps=1.12u w=0.74u l=0.13u
X334 wind_comp_0.comparator_1.nmos$2_0.Drain enable.t0 ibias wind_comp_0.sg13g2_and2_2$1_0.VSS.t410 sg13_lv_nmos ad=55.5f pd=0.74u as=0.1005p ps=1.34u w=0.15u l=0.13u
X335 a_51539_28086# wind_comp_0.sg13g2_and2_2$1_0.A wind_comp_0.sg13g2_and2_2$1_0.VDD.t5 wind_comp_0.sg13g2_and2_2$1_0.VDD.t4 sg13_lv_pmos ad=0.1596p pd=1.22u as=0.2856p ps=2.36u w=0.84u l=0.13u
X336 wind_comp_0.sg13g2_and2_2$1_0.VDD.t0 wind_comp_0.comparator_0.dynamic_pcell$7_0.DRN_NET_BE_GATE_AB wind_comp_0.comparator_0.dynamic_pcell$1_0.DRN_NET_PQ_GATE_Q wind_comp_0.comparator_0.dynamic_pcell_0.VDD sg13_lv_pmos ad=66.49999f pd=0.73u as=66.49999f ps=0.73u w=0.35u l=1u
X337 wind_comp_0.sg13g2_and2_2$1_0.VSS.t48 wind_comp_0.sg13g2_and2_2$1_0.VSS.t46 wind_comp_0.sg13g2_and2_2$1_0.VSS.t47 wind_comp_0.sg13g2_and2_2$1_0.VSS.t8 sg13_lv_nmos ad=1.7p pd=10.68u as=0 ps=0 w=5u l=0.5u
X338 wind_comp_0.sg13g2_and2_2$1_0.VSS.t34 wind_comp_0.sg13g2_and2_2$1_0.VSS.t31 wind_comp_0.sg13g2_and2_2$1_0.VSS.t33 wind_comp_0.sg13g2_and2_2$1_0.VSS.t32 sg13_lv_nmos ad=0.95p pd=5.38u as=0 ps=0 w=5u l=0.5u
X339 wind_comp_0.sg13g2_and2_2$1_0.VDD.t47 wind_comp_0.comparator_1.dynamic_pcell_0.DRN_NET_IH wind_comp_0.comparator_1.sg13cmos5l_inv_16_0.A wind_comp_0.comparator_1.dynamic_pcell$7_0.VDD sg13_lv_pmos ad=0.2128p pd=1.5u as=0.2128p ps=1.5u w=1.12u l=0.13u
X340 wind_comp_0.sg13g2_and2_2$1_0.VSS.t104 wind_comp_0.sg13g2_and2_2$1_0.VSS.t103 wind_comp_0.sg13g2_and2_2$1_0.VSS.t104 wind_comp_0.sg13g2_and2_2$1_0.VSS.t16 sg13_lv_nmos ad=0.1082p pd=1.34u as=0 ps=0 w=0.26u l=0.5u
X341 wind_comp_0.comparator_1.dynamic_pcell$1_0.P_GATE wind_comp_0.comparator_1.dynamic_pcell$1_0.DRN_NET_PQ_GATE_Q wind_comp_0.sg13g2_and2_2$1_0.VSS.t301 wind_comp_0.sg13g2_and2_2$1_0.VSS.t297 sg13_lv_nmos ad=63.19999f pd=0.74u as=63.19999f ps=0.74u w=0.26u l=10u
X342 wind_comp_0.sg13g2_and2_2$1_0.VDD.t209 wind_comp_0.sg13g2_and2_2$1_0.VDD.t212 wind_comp_0.sg13g2_and2_2$1_0.VDD.t213 wind_comp_0.comparator_1.dynamic_pcell$7_0.VDD sg13_lv_pmos ad=95f pd=0.88u as=0 ps=0 w=0.5u l=0.5u
X343 wind_comp_0.sg13g2_and2_2$1_0.VSS.t139 wind_comp_0.sg13g2_and2_2$1_0.VSS.t137 wind_comp_0.sg13g2_and2_2$1_0.VSS.t138 wind_comp_0.sg13g2_and2_2$1_0.VSS.t36 sg13_lv_nmos ad=0.95p pd=5.38u as=0 ps=0 w=5u l=0.5u
X344 wind_comp_0.sg13g2_and2_2$1_0.VDD.t43 wind_comp_0.comparator_1.dynamic_pcell_0.DRN_NET_IH wind_comp_0.comparator_1.sg13cmos5l_inv_16_0.A wind_comp_0.comparator_1.dynamic_pcell$7_0.VDD sg13_lv_pmos ad=0.2128p pd=1.5u as=0.2128p ps=1.5u w=1.12u l=0.13u
X345 wind_comp_0.sg13g2_and2_2$1_0.A wind_comp_0.comparator_0.sg13cmos5l_inv_16_0.A wind_comp_0.sg13g2_and2_2$1_0.VDD.t71 wind_comp_0.comparator_0.dynamic_pcell_0.VDD sg13_lv_pmos ad=0.2128p pd=1.5u as=0.2128p ps=1.5u w=1.12u l=0.13u
X346 wind_comp_0.sg13g2_and2_2$1_0.VSS.t10 wind_comp_0.sg13g2_and2_2$1_0.VSS.t7 wind_comp_0.sg13g2_and2_2$1_0.VSS.t9 wind_comp_0.sg13g2_and2_2$1_0.VSS.t8 sg13_lv_nmos ad=1.7p pd=10.68u as=0 ps=0 w=5u l=0.5u
X347 wind_comp_0.sg13g2_and2_2$1_0.VSS.t214 wind_comp_0.sg13g2_and2_2$1_0.VSS.t212 wind_comp_0.sg13g2_and2_2$1_0.VSS.t213 wind_comp_0.sg13g2_and2_2$1_0.VSS.t12 sg13_lv_nmos ad=1.7p pd=10.68u as=0 ps=0 w=5u l=0.5u
X348 wind_comp_0.sg13g2_and2_2$1_0.VDD.t39 wind_comp_0.comparator_1.dynamic_pcell_0.DRN_NET_IH wind_comp_0.comparator_1.sg13cmos5l_inv_16_0.A wind_comp_0.comparator_1.dynamic_pcell$7_0.VDD sg13_lv_pmos ad=0.2128p pd=1.5u as=0.2128p ps=1.5u w=1.12u l=0.13u
X349 wind_comp_0.sg13g2_and2_2$1_0.VDD.t110 wind_comp_0.sg13g2_and2_2$1_0.VDD.t108 wind_comp_0.sg13g2_and2_2$1_0.VDD.t109 wind_comp_0.comparator_0.dynamic_pcell_0.VDD sg13_lv_pmos ad=0.17p pd=1.68u as=0 ps=0 w=0.5u l=0.5u
X350 wind_comp_0.comparator_0.dynamic_pcell$1_0.P_GATE wind_comp_0.comparator_0.dynamic_pcell$1_0.DRN_NET_PQ_GATE_Q wind_comp_0.sg13g2_and2_2$1_0.VSS.t278 wind_comp_0.sg13g2_and2_2$1_0.VSS.t275 sg13_lv_nmos ad=63.19999f pd=0.74u as=63.19999f ps=0.74u w=0.26u l=10u
X351 wind_comp_0.sg13g2_and2_2$1_0.VSS.t28 wind_comp_0.sg13g2_and2_2$1_0.VSS.t26 wind_comp_0.sg13g2_and2_2$1_0.VSS.t27 wind_comp_0.sg13g2_and2_2$1_0.VSS.t19 sg13_lv_nmos ad=0.95p pd=5.38u as=0 ps=0 w=5u l=0.5u
X352 wind_comp_0.sg13g2_and2_2$1_0.VDD.t17 wind_comp_0.comparator_0.dynamic_pcell_0.DRN_NET_IH wind_comp_0.comparator_0.sg13cmos5l_inv_16_0.A wind_comp_0.comparator_0.dynamic_pcell_0.VDD sg13_lv_pmos ad=0.2128p pd=1.5u as=0.2128p ps=1.5u w=1.12u l=0.13u
X353 wind_comp_0.comparator_0.dynamic_pcell_0.DRN_NET_GJ_GATE_GH wind_comp_0.sg13g2_and2_2$1_0.VDD.t137 wind_comp_0.sg13g2_and2_2$1_0.VDD.t135 wind_comp_0.comparator_0.dynamic_pcell_0.VDD sg13_lv_pmos ad=0.5928p pd=3.5u as=0.5928p ps=3.5u w=3.12u l=0.5u
X354 wind_comp_0.comparator_0.dynamic_pcell_0.DRN_NET_IH wind_comp_0.sg13g2_and2_2$1_0.VDD.t190 wind_comp_0.sg13g2_and2_2$1_0.VDD.t188 wind_comp_0.comparator_0.dynamic_pcell_0.VDD sg13_lv_pmos ad=0.5928p pd=3.5u as=0.5928p ps=3.5u w=3.12u l=0.5u
X355 wind_comp_0.sg13g2_and2_2$1_0.VSS.t85 wind_comp_0.sg13g2_and2_2$1_0.VSS.t83 wind_comp_0.comparator_0.dynamic_pcell$7_0.DRN_NET_BE_GATE_AB wind_comp_0.sg13g2_and2_2$1_0.VSS.t84 sg13_lv_nmos ad=63.19999f pd=0.74u as=63.19999f ps=0.74u w=0.26u l=0.5u
X356 wind_comp_0.sg13g2_and2_2$1_0.VSS.t14 wind_comp_0.sg13g2_and2_2$1_0.VSS.t11 wind_comp_0.sg13g2_and2_2$1_0.VSS.t13 wind_comp_0.sg13g2_and2_2$1_0.VSS.t12 sg13_lv_nmos ad=1.7p pd=10.68u as=0 ps=0 w=5u l=0.5u
X357 wind_comp_0.comparator_0.dynamic_pcell$7_0.DRN_NET_CF_GATE_CD analog_bus2 wind_comp_0.comparator_0.dynamic_pcell$2_0.O_DRN wind_comp_0.sg13g2_and2_2$1_0.VSS.t396 sg13_lv_nmos ad=63.19999f pd=0.74u as=63.19999f ps=0.74u w=0.26u l=3u
X358 wind_comp_0.sg13g2_and2_2$1_0.VDD.t13 wind_comp_0.comparator_0.dynamic_pcell_0.DRN_NET_IH wind_comp_0.comparator_0.sg13cmos5l_inv_16_0.A wind_comp_0.comparator_0.dynamic_pcell_0.VDD sg13_lv_pmos ad=0.2128p pd=1.5u as=0.2128p ps=1.5u w=1.12u l=0.13u
X359 wind_comp_0.sg13g2_and2_2$1_0.VSS.t152 wind_comp_0.sg13g2_and2_2$1_0.VSS.t150 wind_comp_0.sg13g2_and2_2$1_0.VSS.t149 wind_comp_0.sg13g2_and2_2$1_0.VSS.t24 sg13_lv_nmos ad=0.95p pd=5.38u as=0 ps=0 w=5u l=0.5u
X360 wind_comp_0.sg13g2_and2_2$1_0.VDD.t207 wind_comp_0.sg13g2_and2_2$1_0.VDD.t205 wind_comp_0.sg13g2_and2_2$1_0.VDD.t206 wind_comp_0.comparator_1.dynamic_pcell$7_0.VDD sg13_lv_pmos ad=0.17p pd=1.68u as=0 ps=0 w=0.5u l=0.5u
X361 wind_comp_0.comparator_1.dynamic_pcell$2_0.O_DRN analog_bus0 wind_comp_0.comparator_1.dynamic_pcell$7_0.DRN_NET_BE_GATE_AB wind_comp_0.sg13g2_and2_2$1_0.VSS.t398 sg13_lv_nmos ad=63.19999f pd=0.74u as=63.19999f ps=0.74u w=0.26u l=3u
X362 wind_comp_0.sg13g2_and2_2$1_0.VSS.t300 wind_comp_0.comparator_1.dynamic_pcell$1_0.DRN_NET_PQ_GATE_Q wind_comp_0.comparator_1.dynamic_pcell$1_0.DRN_NET_PQ_GATE_Q wind_comp_0.sg13g2_and2_2$1_0.VSS.t299 sg13_lv_nmos ad=63.19999f pd=0.74u as=63.19999f ps=0.74u w=0.26u l=10u
X363 wind_comp_0.sg13g2_and2_2$1_0.VSS.t182 wind_comp_0.sg13g2_and2_2$1_0.VSS.t183 wind_comp_0.sg13g2_and2_2$1_0.VSS.t182 wind_comp_0.sg13g2_and2_2$1_0.VSS.t163 sg13_lv_nmos ad=63.19999f pd=0.74u as=0 ps=0 w=0.26u l=0.5u
X364 wind_comp_0.comparator_1.sg13cmos5l_inv_16_0.A wind_comp_0.comparator_1.dynamic_pcell_0.DRN_NET_IH wind_comp_0.sg13g2_and2_2$1_0.VSS.t322 wind_comp_0.sg13g2_and2_2$1_0.VSS.t323 sg13_lv_nmos ad=0.1406p pd=1.12u as=0.1406p ps=1.12u w=0.74u l=0.13u
X365 wind_comp_0.sg13g2_and2_2$1_0.VSS.t346 wind_comp_0.comparator_0.sg13cmos5l_inv_16_0.A wind_comp_0.sg13g2_and2_2$1_0.A wind_comp_0.sg13g2_and2_2$1_0.VSS.t345 sg13_lv_nmos ad=0.1406p pd=1.12u as=0.1406p ps=1.12u w=0.74u l=0.13u
X366 wind_comp_0.sg13g2_and2_2$1_0.VDD.t89 wind_comp_0.comparator_1.sg13cmos5l_inv_16_0.A wind_comp_0.sg13g2_and2_2$1_0.B wind_comp_0.comparator_1.dynamic_pcell$7_0.VDD sg13_lv_pmos ad=0.2128p pd=1.5u as=0.2128p ps=1.5u w=1.12u l=0.13u
X367 wind_comp_0.sg13g2_and2_2$1_0.VSS.t194 wind_comp_0.sg13g2_and2_2$1_0.VSS.t193 wind_comp_0.sg13g2_and2_2$1_0.VSS.t194 wind_comp_0.sg13g2_and2_2$1_0.VSS.t177 sg13_lv_nmos ad=0.1082p pd=1.34u as=0 ps=0 w=0.26u l=0.5u
X368 wind_comp_0.sg13g2_and2_2$1_0.VSS.t1 wind_comp_0.comparator_0.dynamic_pcell_0.DRN_NET_GJ_GATE_GH wind_comp_0.comparator_0.dynamic_pcell_0.DRN_NET_GJ_GATE_GH wind_comp_0.sg13g2_and2_2$1_0.VSS.t0 sg13_lv_nmos ad=55.5f pd=0.74u as=55.5f ps=0.74u w=0.15u l=3u
X369 wind_comp_0.sg13g2_and2_2$1_0.VDD.t147 wind_comp_0.sg13g2_and2_2$1_0.VDD.t146 wind_comp_0.comparator_0.dynamic_pcell$1_0.P_GATE wind_comp_0.comparator_0.dynamic_pcell_0.VDD sg13_lv_pmos ad=66.49999f pd=0.73u as=66.49999f ps=0.73u w=0.35u l=0.5u
X370 wind_comp_0.comparator_0.dynamic_pcell_0.SRC_NET_IJ wind_comp_0.comparator_0.dynamic_pcell$2_0.DRN_NET_LM_GATE_KL wind_comp_0.sg13g2_and2_2$1_0.VDD.t56 wind_comp_0.comparator_0.dynamic_pcell_0.VDD sg13_lv_pmos ad=95f pd=0.88u as=95f ps=0.88u w=0.5u l=3u
X371 wind_comp_0.sg13g2_and2_2$1_0.VDD.t28 wind_comp_0.comparator_1.dynamic_pcell$7_0.DRN_NET_BE_GATE_AB wind_comp_0.comparator_1.dynamic_pcell$1_0.DRN_NET_PQ_GATE_Q wind_comp_0.comparator_1.dynamic_pcell$7_0.VDD sg13_lv_pmos ad=66.49999f pd=0.73u as=66.49999f ps=0.73u w=0.35u l=1u
X372 wind_comp_0.sg13g2_and2_2$1_0.VSS.t128 wind_comp_0.sg13g2_and2_2$1_0.VSS.t127 wind_comp_0.comparator_1.dynamic_pcell_0.DRN_NET_IH wind_comp_0.sg13g2_and2_2$1_0.VSS.t116 sg13_lv_nmos ad=55.5f pd=0.74u as=55.5f ps=0.74u w=0.15u l=0.5u
X373 wind_comp_0.sg13g2_and2_2$1_0.VDD.t73 wind_comp_0.comparator_0.sg13cmos5l_inv_16_0.A wind_comp_0.sg13g2_and2_2$1_0.A wind_comp_0.comparator_0.dynamic_pcell_0.VDD sg13_lv_pmos ad=0.2128p pd=1.5u as=0.2128p ps=1.5u w=1.12u l=0.13u
X374 wind_comp_0.sg13g2_and2_2$1_0.VSS.t139 wind_comp_0.comparator_1.nmos$2_0.Drain wind_comp_0.comparator_1.dynamic_pcell$2_0.O_DRN wind_comp_0.sg13g2_and2_2$1_0.VSS.t361 sg13_lv_nmos ad=0.95p pd=5.38u as=0.95p ps=5.38u w=5u l=3u
X375 wind_comp_0.sg13g2_and2_2$1_0.VDD.t69 wind_comp_0.comparator_0.sg13cmos5l_inv_16_0.A wind_comp_0.sg13g2_and2_2$1_0.A wind_comp_0.comparator_0.dynamic_pcell_0.VDD sg13_lv_pmos ad=0.2128p pd=1.5u as=0.2128p ps=1.5u w=1.12u l=0.13u
X376 wind_comp_0.comparator_0.dynamic_pcell$1_0.P_GATE wind_comp_0.comparator_0.dynamic_pcell$7_0.DRN_NET_CF_GATE_CD wind_comp_0.sg13g2_and2_2$1_0.VDD.t6 wind_comp_0.comparator_0.dynamic_pcell_0.VDD sg13_lv_pmos ad=66.49999f pd=0.73u as=66.49999f ps=0.73u w=0.35u l=1u
X377 wind_comp_0.sg13g2_and2_2$1_0.VSS.t75 wind_comp_0.sg13g2_and2_2$1_0.VSS.t73 wind_comp_0.sg13g2_and2_2$1_0.VSS.t74 wind_comp_0.sg13g2_and2_2$1_0.VSS.t61 sg13_lv_nmos ad=0.1005p pd=1.34u as=0 ps=0 w=0.15u l=0.5u
X378 wind_comp_0.sg13g2_and2_2$1_0.VSS.t370 wind_comp_0.comparator_1.sg13cmos5l_inv_16_0.A wind_comp_0.sg13g2_and2_2$1_0.B wind_comp_0.sg13g2_and2_2$1_0.VSS.t369 sg13_lv_nmos ad=0.1406p pd=1.12u as=0.1406p ps=1.12u w=0.74u l=0.13u
X379 wind_comp_0.sg13g2_and2_2$1_0.VSS.t203 wind_comp_0.sg13g2_and2_2$1_0.VSS.t202 wind_comp_0.sg13g2_and2_2$1_0.VSS.t203 wind_comp_0.sg13g2_and2_2$1_0.VSS.t177 sg13_lv_nmos ad=0.1082p pd=1.34u as=0 ps=0 w=0.26u l=0.5u
X380 wind_comp_0.sg13g2_and2_2$1_0.B wind_comp_0.comparator_1.sg13cmos5l_inv_16_0.A wind_comp_0.sg13g2_and2_2$1_0.VSS.t379 wind_comp_0.sg13g2_and2_2$1_0.VSS.t380 sg13_lv_nmos ad=0.1406p pd=1.12u as=0.1406p ps=1.12u w=0.74u l=0.13u
X381 wind_comp_0.sg13g2_and2_2$1_0.VSS.t270 wind_comp_0.comparator_0.dynamic_pcell_0.DRN_NET_IH wind_comp_0.comparator_0.sg13cmos5l_inv_16_0.A wind_comp_0.sg13g2_and2_2$1_0.VSS.t269 sg13_lv_nmos ad=0.1406p pd=1.12u as=0.1406p ps=1.12u w=0.74u l=0.13u
X382 wind_comp_0.sg13g2_and2_2$1_0.VSS.t80 wind_comp_0.sg13g2_and2_2$1_0.VSS.t78 wind_comp_0.sg13g2_and2_2$1_0.VSS.t80 wind_comp_0.sg13g2_and2_2$1_0.VSS.t79 sg13_lv_nmos ad=0.1082p pd=1.34u as=0 ps=0 w=0.26u l=0.5u
X383 wind_comp_0.comparator_0.sg13cmos5l_inv_16_0.A wind_comp_0.comparator_0.dynamic_pcell_0.DRN_NET_IH wind_comp_0.sg13g2_and2_2$1_0.VDD.t10 wind_comp_0.comparator_0.dynamic_pcell_0.VDD sg13_lv_pmos ad=0.2128p pd=1.5u as=0.4368p ps=3.02u w=1.12u l=0.13u
X384 wind_comp_0.sg13g2_and2_2$1_0.B wind_comp_0.comparator_1.sg13cmos5l_inv_16_0.A wind_comp_0.sg13g2_and2_2$1_0.VSS.t373 wind_comp_0.sg13g2_and2_2$1_0.VSS.t374 sg13_lv_nmos ad=0.1406p pd=1.12u as=0.1406p ps=1.12u w=0.74u l=0.13u
X385 wind_comp_0.comparator_1.nmos_0.Gate enable.t2 wind_comp_0.sg13g2_and2_2$1_0.VSS.t406 wind_comp_0.sg13g2_and2_2$1_0.VSS.t405 sg13_lv_nmos ad=0.2516p pd=2.16u as=0.2516p ps=2.16u w=0.74u l=0.13u
X386 wind_comp_0.sg13g2_and2_2$1_0.VSS.t325 wind_comp_0.comparator_1.dynamic_pcell_0.DRN_NET_IH wind_comp_0.comparator_1.sg13cmos5l_inv_16_0.A wind_comp_0.sg13g2_and2_2$1_0.VSS.t324 sg13_lv_nmos ad=0.2516p pd=2.16u as=0.1406p ps=1.12u w=0.74u l=0.13u
X387 wind_comp_0.comparator_0.dynamic_pcell$1_0.P_GATE wind_comp_0.sg13g2_and2_2$1_0.VDD.t153 wind_comp_0.sg13g2_and2_2$1_0.VDD.t151 wind_comp_0.comparator_0.dynamic_pcell_0.VDD sg13_lv_pmos ad=66.49999f pd=0.73u as=66.49999f ps=0.73u w=0.35u l=0.5u
X388 wind_comp_0.sg13g2_and2_2$1_0.A wind_comp_0.comparator_0.sg13cmos5l_inv_16_0.A wind_comp_0.sg13g2_and2_2$1_0.VSS.t346 wind_comp_0.sg13g2_and2_2$1_0.VSS.t347 sg13_lv_nmos ad=0.1406p pd=1.12u as=0.1406p ps=1.12u w=0.74u l=0.13u
X389 wind_comp_0.sg13g2_and2_2$1_0.A wind_comp_0.comparator_0.sg13cmos5l_inv_16_0.A wind_comp_0.sg13g2_and2_2$1_0.VSS.t340 wind_comp_0.sg13g2_and2_2$1_0.VSS.t341 sg13_lv_nmos ad=0.1406p pd=1.12u as=0.1406p ps=1.12u w=0.74u l=0.13u
X390 wind_comp_0.sg13g2_and2_2$1_0.VSS.t93 wind_comp_0.sg13g2_and2_2$1_0.VSS.t92 wind_comp_0.sg13g2_and2_2$1_0.VSS.t93 wind_comp_0.sg13g2_and2_2$1_0.VSS.t87 sg13_lv_nmos ad=63.19999f pd=0.74u as=0 ps=0 w=0.26u l=0.5u
X391 wind_comp_0.sg13g2_and2_2$1_0.A wind_comp_0.comparator_0.sg13cmos5l_inv_16_0.A wind_comp_0.sg13g2_and2_2$1_0.VSS.t335 wind_comp_0.sg13g2_and2_2$1_0.VSS.t334 sg13_lv_nmos ad=0.1406p pd=1.12u as=0.2516p ps=2.16u w=0.74u l=0.13u
X392 wind_comp_0.comparator_1.dynamic_pcell$7_0.DRN_NET_BE_GATE_AB wind_comp_0.comparator_1.dynamic_pcell$7_0.DRN_NET_BE_GATE_AB wind_comp_0.sg13g2_and2_2$1_0.VDD.t28 wind_comp_0.comparator_1.dynamic_pcell$7_0.VDD sg13_lv_pmos ad=0.119p pd=1.38u as=66.49999f ps=0.73u w=0.35u l=1u
X393 wind_comp_0.comparator_1.dynamic_pcell$7_0.DRN_NET_CF_GATE_CD s4_an wind_comp_0.comparator_1.dynamic_pcell$2_0.O_DRN wind_comp_0.sg13g2_and2_2$1_0.VSS.t397 sg13_lv_nmos ad=63.19999f pd=0.74u as=63.19999f ps=0.74u w=0.26u l=3u
X394 wind_comp_0.sg13g2_and2_2$1_0.VSS.t218 wind_comp_0.sg13g2_and2_2$1_0.VSS.t219 wind_comp_0.sg13g2_and2_2$1_0.VSS.t218 wind_comp_0.sg13g2_and2_2$1_0.VSS.t201 sg13_lv_nmos ad=63.19999f pd=0.74u as=0 ps=0 w=0.26u l=0.5u
X395 wind_comp_0.sg13g2_and2_2$1_0.VDD.t103 wind_comp_0.sg13g2_and2_2$1_0.VDD.t102 wind_comp_0.comparator_0.dynamic_pcell_0.DRN_NET_IH wind_comp_0.comparator_0.dynamic_pcell_0.VDD sg13_lv_pmos ad=0.5928p pd=3.5u as=0.5928p ps=3.5u w=3.12u l=0.5u
C0 clk m3_0_18723# 0.0106f
C1 analog_bus0 m3_0_22839# 0.1256f
C2 m4_46271_27032# m4_46756_27032# 0.13507f
C3 wind_comp_0.comparator_1.nmos_0.Gate enable 0.1975f
C4 m4_44321_27032# m4_44846_27032# 0.08419f
C5 vbias vss_1v2_uq0 0.05286f
C6 wind_comp_0.comparator_0.dynamic_pcell_0.SRC_NET_IJ wind_comp_0.comparator_0.dynamic_pcell$1_0.DRN_NET_PQ_GATE_Q 0.40722f
C7 dig_in[1] vss_1v2_uq0 0.01075f
C8 wind_comp_0.comparator_1.dynamic_pcell_0.DRN_NET_GJ_GATE_GH wind_comp_0.comparator_1.dynamic_pcell$7_0.DRN_NET_BE_GATE_AB 0.02097f
C9 wind_comp_0.comparator_1.dynamic_pcell_0.SRC_NET_IJ wind_comp_0.comparator_1.dynamic_pcell$1_0.P_GATE 0.72849f
C10 m4_57537_27032# m4_57912_27032# 0.07429f
C11 dig_in[9] vss_1v2_uq0 0.01075f
C12 wind_comp_0.sg13g2_and2_2$1_0.B wind_comp_0.comparator_1.dynamic_pcell$1_0.P_GATE 0.02318f
C13 wind_comp_0.comparator_1.dynamic_pcell$2_0.DRN_NET_LM_GATE_KL m4_58962_27032# 0.06049f
C14 wind_comp_0.comparator_0.nmos$2_0.Drain m4_46271_27032# 0.02129f
C15 enable reset 0.19831f
C16 a_51539_28086# analog_bus1 0.12479f
C17 wind_comp_0.comparator_0.dynamic_pcell$1_0.P_GATE ibias 0.02313f
C18 dig_in[21] vss_1v2_uq0 0.01075f
C19 m4_55627_27032r# m4_56152_27032# 0.07429f
C20 analog_bus1 m4_21542_3976# 4.69593f
C21 wind_comp_0.comparator_1.dynamic_pcell$1_0.DRN_NET_PQ_GATE_Q enable 0.04385f
C22 wind_comp_0.comparator_1.dynamic_pcell_0.DRN_NET_IH wind_comp_0.comparator_1.sg13cmos5l_inv_16_0.A 0.85132f
C23 wind_comp_0.comparator_1.nmos$2_0.Drain enable 0.17935f
C24 wind_comp_0.comparator_0.nmos$2_0.Drain wind_comp_0.comparator_0.dynamic_pcell_0.DRN_NET_IH 0.03378f
C25 wind_comp_0.comparator_0.dynamic_pcell_0.DRN_NET_GJ_GATE_GH m4_45896_27032# 0.01015f
C26 wind_comp_0.comparator_0.nmos_0.Gate wind_comp_0.comparator_0.dynamic_pcell_0.DRN_NET_GJ_GATE_GH 0.0177f
C27 dig_out[1] dig_out[0] 0.20933f
C28 wind_comp_0.comparator_1.dynamic_pcell_0.SRC_NET_IJ wind_comp_0.comparator_1.dynamic_pcell_0.DRN_NET_GJ_GATE_GH 0.63021f
C29 wind_comp_0.comparator_1.nmos$2_0.Drain m4_56152_27032# 0.01459f
C30 wind_comp_0.comparator_0.dynamic_pcell$2_0.DRN_NET_LM_GATE_KL wind_comp_0.comparator_0.dynamic_pcell$1_0.P_GATE 0.02944f
C31 wind_comp_0.comparator_1.dynamic_pcell_0.DRN_NET_IH wind_comp_0.comparator_1.dynamic_pcell$2_0.DRN_NET_LM_GATE_KL 0.07512f
C32 wind_comp_0.comparator_1.dynamic_pcell$1_0.P_GATE s4_an 0.07574f
C33 wind_comp_0.comparator_1.dynamic_pcell$7_0.DRN_NET_BE_GATE_AB ibias 0.02239f
C34 m3_0_18723# vss_1v2_uq0 0.02829f
C35 dig_out[8] dig_out[7] 0.20933f
C36 wind_comp_0.comparator_0.dynamic_pcell$2_0.DRN_NET_LM_GATE_KL wind_comp_0.comparator_0.dynamic_pcell_0.DRN_NET_GJ_GATE_GH 0.16327f
C37 dig_in[0] dig_out[11] 0.03555f
C38 wind_comp_0.comparator_1.dynamic_pcell$1_0.DRN_NET_PQ_GATE_Q wind_comp_0.comparator_1.dynamic_pcell$2_0.O_DRN 0.48307f
C39 wind_comp_0.comparator_0.dynamic_pcell$1_0.P_GATE wind_comp_0.comparator_0.dynamic_pcell$7_0.DRN_NET_BE_GATE_AB 0.2714f
C40 wind_comp_0.comparator_1.nmos$2_0.Drain wind_comp_0.comparator_1.dynamic_pcell$2_0.O_DRN 2.42598f
C41 wind_comp_0.comparator_1.dynamic_pcell_0.DRN_NET_GJ_GATE_GH s4_an 0.02023f
C42 dig_in[4] dig_in[3] 0.20933f
C43 wind_comp_0.comparator_1.dynamic_pcell$7_0.DRN_NET_CF_GATE_CD enable 0.16186f
C44 dig_out[6] vss_1v2_uq0 0.01075f
C45 wind_comp_0.sg13g2_and2_2$1_0.A a_51539_28086# 0.09084f
C46 enable m4_21542_3976# 2.26988f
C47 wind_comp_0.sg13g2_and2_2$1_0.B ibias 0.15718f
C48 dig_in[8] dig_in[7] 0.20933f
C49 m3_0_22839# vss_3v3 0.03355f
C50 ibias m3_0_19311# 0.1256f
C51 dig_in[2] vss_1v2_uq0 0.01075f
C52 wind_comp_0.comparator_0.dynamic_pcell_0.DRN_NET_GJ_GATE_GH wind_comp_0.comparator_0.dynamic_pcell$7_0.DRN_NET_BE_GATE_AB 0.02097f
C53 dig_in[12] dig_in[11] 0.20933f
C54 dig_in[10] vss_1v2_uq0 0.01075f
C55 wind_comp_0.comparator_0.dynamic_pcell$1_0.P_GATE wind_comp_0.comparator_0.dynamic_pcell$2_0.O_DRN 0.1307f
C56 dig_in[20] dig_in[19] 0.20933f
C57 wind_comp_0.comparator_0.nmos$2_0.Drain m4_45896_27032# 0.01463f
C58 wind_comp_0.comparator_0.nmos$2_0.Drain wind_comp_0.comparator_0.nmos_0.Gate 0.01445f
C59 wind_comp_0.comparator_1.dynamic_pcell$7_0.DRN_NET_BE_GATE_AB analog_bus0 1.45895f
C60 wind_comp_0.comparator_1.nmos_0.Gate wind_comp_0.comparator_1.dynamic_pcell$1_0.DRN_NET_PQ_GATE_Q 0.08053f
C61 dig_in[22] vss_1v2_uq0 0.01075f
C62 dig_in[16] dig_in[15] 0.20933f
C63 wind_comp_0.comparator_1.nmos$2_0.Drain wind_comp_0.comparator_1.nmos_0.Gate 0.01445f
C64 wind_comp_0.comparator_0.nmos$2_0.Drain ibias 0.18299f
C65 analog_bus2 m4_21542_3976# 5.05307f
C66 ibias s4_an 0.15862f
C67 wind_comp_0.comparator_0.dynamic_pcell_0.DRN_NET_GJ_GATE_GH wind_comp_0.comparator_0.dynamic_pcell$2_0.O_DRN 0.12398f
C68 wind_comp_0.comparator_1.dynamic_pcell$7_0.DRN_NET_CF_GATE_CD wind_comp_0.comparator_1.dynamic_pcell$2_0.O_DRN 0.0352f
C69 wind_comp_0.comparator_1.nmos$2_0.Drain m4_55627_27032r# 0.0249f
C70 wind_comp_0.comparator_0.nmos$2_0.Drain wind_comp_0.comparator_0.dynamic_pcell$2_0.DRN_NET_LM_GATE_KL 1.96067f
C71 wind_comp_0.comparator_0.dynamic_pcell$1_0.P_GATE wind_comp_0.comparator_0.dynamic_pcell$1_0.DRN_NET_PQ_GATE_Q 10.6685f
C72 wind_comp_0.comparator_1.dynamic_pcell_0.DRN_NET_GJ_GATE_GH m4_57537_27032# 0.01015f
C73 wind_comp_0.comparator_1.nmos$2_0.Drain wind_comp_0.comparator_1.dynamic_pcell$1_0.DRN_NET_PQ_GATE_Q 0.01196f
C74 wind_comp_0.sg13g2_and2_2$1_0.B analog_bus0 0.02293f
C75 wind_comp_0.comparator_0.nmos$2_0.Drain wind_comp_0.comparator_0.sg13cmos5l_inv_16_0.A 0.0152f
C76 wind_comp_0.comparator_1.dynamic_pcell_0.DRN_NET_GJ_GATE_GH wind_comp_0.comparator_1.dynamic_pcell$1_0.P_GATE 1.92362f
C77 m4_47656_27032# m4_48181_27032# 0.07181f
C78 wind_comp_0.comparator_0.dynamic_pcell$1_0.DRN_NET_PQ_GATE_Q wind_comp_0.comparator_0.dynamic_pcell_0.DRN_NET_GJ_GATE_GH 1.08317f
C79 dig_out[0] vss_1v2_uq0 0.0315f
C80 m4_45896_27032# m4_46271_27032# 0.03662f
C81 dig_out[7] vss_1v2_uq0 0.01075f
C82 wind_comp_0.sg13g2_and2_2$1_0.B wind_comp_0.comparator_1.sg13cmos5l_inv_16_0.A 0.85679f
C83 m5_21908_34934# m4_21542_3976# 37.7075f
C84 wind_comp_0.comparator_0.dynamic_pcell$7_0.DRN_NET_BE_GATE_AB s4_an 1.45895f
C85 m4_21542_3976# vdd1v2 37.6728f
C86 s4_an analog_bus0 3.35488f
C87 ibias m3_0_19899# 0.1256f
C88 dig_in[3] vss_1v2_uq0 0.01075f
C89 wind_comp_0.comparator_1.dynamic_pcell_0.SRC_NET_IJ wind_comp_0.comparator_1.dynamic_pcell$2_0.DRN_NET_LM_GATE_KL 2.90157f
C90 wind_comp_0.comparator_1.dynamic_pcell$2_0.DRN_NET_LM_GATE_KL wind_comp_0.sg13g2_and2_2$1_0.B 0.10219f
C91 m4_57012_27032# m4_57537_27032# 0.03662f
C92 m4_54577_27032# enable 0.08039f
C93 dig_in[11] vss_1v2_uq0 0.01075f
C94 wind_comp_0.sg13g2_and2_2$1_0.A wind_comp_0.comparator_0.dynamic_pcell$1_0.P_GATE 0.02409f
C95 wind_comp_0.comparator_1.dynamic_pcell$1_0.P_GATE ibias 0.02282f
C96 wind_comp_0.comparator_0.dynamic_pcell$1_0.P_GATE enable 0.02679f
C97 wind_comp_0.comparator_0.nmos$2_0.Drain m4_45371_27032r# 0.02508f
C98 wind_comp_0.comparator_1.dynamic_pcell$7_0.DRN_NET_CF_GATE_CD wind_comp_0.comparator_1.dynamic_pcell$1_0.DRN_NET_PQ_GATE_Q 0.11165f
C99 wind_comp_0.comparator_0.nmos$2_0.Drain wind_comp_0.comparator_0.dynamic_pcell$2_0.O_DRN 2.42598f
C100 wind_comp_0.sg13g2_and2_2$1_0.B analog_bus1 0.02879f
C101 dig_in[23] vss_1v2_uq0 0.01075f
C102 m4_55102_27032# m4_55627_27032r# 0.07181f
C103 s4_an wind_comp_0.comparator_0.dynamic_pcell$2_0.O_DRN 0.30829f
C104 wind_comp_0.comparator_0.dynamic_pcell$2_0.DRN_NET_LM_GATE_KL wind_comp_0.comparator_0.dynamic_pcell_0.DRN_NET_IH 0.07512f
C105 wind_comp_0.comparator_1.nmos$2_0.Drain m4_58962_27032# 0.10523f
C106 wind_comp_0.comparator_0.dynamic_pcell_0.DRN_NET_GJ_GATE_GH m4_44846_27032# 0.03326f
C107 dig_out[2] dig_out[1] 0.20933f
C108 wind_comp_0.comparator_1.nmos$2_0.Drain m4_55102_27032# 0.01689f
C109 wind_comp_0.comparator_0.sg13cmos5l_inv_16_0.A wind_comp_0.comparator_0.dynamic_pcell_0.DRN_NET_IH 0.85132f
C110 wind_comp_0.comparator_1.dynamic_pcell$2_0.DRN_NET_LM_GATE_KL s4_an 0.1656f
C111 wind_comp_0.comparator_0.dynamic_pcell$1_0.P_GATE wind_comp_0.comparator_0.dynamic_pcell$7_0.DRN_NET_CF_GATE_CD 4.5035f
C112 wind_comp_0.comparator_0.dynamic_pcell$1_0.P_GATE analog_bus2 0.05938f
C113 wind_comp_0.comparator_1.dynamic_pcell$7_0.DRN_NET_BE_GATE_AB enable 0.25248f
C114 wind_comp_0.comparator_0.nmos$2_0.Drain wind_comp_0.comparator_0.dynamic_pcell$1_0.DRN_NET_PQ_GATE_Q 0.01196f
C115 analog_bus1 s4_an 0.01212f
C116 wind_comp_0.comparator_1.dynamic_pcell_0.DRN_NET_IH wind_comp_0.comparator_1.dynamic_pcell$1_0.DRN_NET_PQ_GATE_Q 1.95576f
C117 dig_out[6] dig_out[5] 0.20933f
C118 dig_out[9] dig_out[8] 0.20933f
C119 wind_comp_0.comparator_1.dynamic_pcell_0.DRN_NET_IH wind_comp_0.comparator_1.nmos$2_0.Drain 0.03378f
C120 wind_comp_0.comparator_0.dynamic_pcell$1_0.DRN_NET_PQ_GATE_Q s4_an 0.11353f
C121 wind_comp_0.comparator_0.dynamic_pcell_0.DRN_NET_GJ_GATE_GH wind_comp_0.comparator_0.dynamic_pcell$7_0.DRN_NET_CF_GATE_CD 0.02539f
C122 wind_comp_0.comparator_0.dynamic_pcell_0.DRN_NET_GJ_GATE_GH analog_bus2 0.01917f
C123 dig_in[1] dig_in[0] 0.20933f
C124 dig_out[1] vss_1v2_uq0 0.01075f
C125 wind_comp_0.comparator_1.dynamic_pcell$1_0.P_GATE analog_bus0 2.89436f
C126 dig_in[5] dig_in[4] 0.20933f
C127 ibias1 m3_0_19899# 0.1256f
C128 dig_out[8] vss_1v2_uq0 0.01075f
C129 wind_comp_0.sg13g2_and2_2$1_0.A wind_comp_0.sg13g2_and2_2$1_0.B 0.10214f
C130 wind_comp_0.comparator_0.nmos_0.Gate ibias 0.07648f
C131 wind_comp_0.sg13g2_and2_2$1_0.B enable 0.08175f
C132 wind_comp_0.comparator_0.dynamic_pcell_0.DRN_NET_IH m4_45371_27032r# 0.01464f
C133 dig_in[9] dig_in[8] 0.20933f
C134 dig_in[4] vss_1v2_uq0 0.01075f
C135 wind_comp_0.comparator_1.dynamic_pcell$7_0.DRN_NET_BE_GATE_AB wind_comp_0.comparator_1.dynamic_pcell$2_0.O_DRN 0.06659f
C136 m4_48706_27032# enable 0.08039f
C137 dig_in[13] dig_in[12] 0.20933f
C138 wind_comp_0.comparator_1.dynamic_pcell_0.DRN_NET_GJ_GATE_GH analog_bus0 0.03234f
C139 dig_in[12] vss_1v2_uq0 0.01075f
C140 dig_in[21] dig_in[20] 0.20933f
C141 wind_comp_0.comparator_0.nmos$2_0.Drain m4_44846_27032# 0.02541f
C142 wind_comp_0.comparator_0.nmos$2_0.Drain wind_comp_0.sg13g2_and2_2$1_0.A 0.01384f
C143 wind_comp_0.comparator_0.nmos$2_0.Drain enable 0.17935f
C144 wind_comp_0.comparator_1.dynamic_pcell$2_0.DRN_NET_LM_GATE_KL wind_comp_0.comparator_1.dynamic_pcell$1_0.P_GATE 0.02944f
C145 wind_comp_0.sg13g2_and2_2$1_0.A s4_an 0.02639f
C146 enable s4_an 0.84606f
C147 wind_comp_0.comparator_1.nmos$2_0.Drain m4_58437_27032# 0.02541f
C148 clk vss_1v2_uq0 0.02611f
C149 vdd_3v3 vss_3v3 0.02281f
C150 wind_comp_0.comparator_0.dynamic_pcell$1_0.DRN_NET_PQ_GATE_Q wind_comp_0.comparator_0.dynamic_pcell_0.DRN_NET_IH 1.95576f
C151 wind_comp_0.comparator_1.nmos$2_0.Drain m4_54577_27032# 0.0126f
C152 ibias vss_1v2_uq0 2.24024f
C153 wind_comp_0.comparator_1.dynamic_pcell_0.DRN_NET_GJ_GATE_GH wind_comp_0.comparator_1.dynamic_pcell$2_0.DRN_NET_LM_GATE_KL 0.16327f
C154 wind_comp_0.comparator_0.dynamic_pcell$7_0.DRN_NET_CF_GATE_CD s4_an 0.62481f
C155 wind_comp_0.comparator_0.sg13cmos5l_inv_16_0.A wind_comp_0.comparator_0.dynamic_pcell$2_0.DRN_NET_LM_GATE_KL 0.04751f
C156 wind_comp_0.comparator_0.dynamic_pcell$7_0.DRN_NET_BE_GATE_AB ibias 0.02288f
C157 analog_bus2 s4_an 3.24505f
C158 ibias analog_bus0 8.43446f
C159 m4_47281_27032# m4_47656_27032# 0.07429f
C160 dig_out[2] vss_1v2_uq0 0.01075f
C161 wind_comp_0.comparator_1.dynamic_pcell$7_0.DRN_NET_BE_GATE_AB wind_comp_0.comparator_1.dynamic_pcell$1_0.DRN_NET_PQ_GATE_Q 4.24199f
C162 wind_comp_0.comparator_0.dynamic_pcell_0.SRC_NET_IJ wind_comp_0.comparator_0.dynamic_pcell$1_0.P_GATE 0.72849f
C163 m4_45371_27032r# m4_45896_27032# 0.07429f
C164 s4_an wind_comp_0.comparator_1.dynamic_pcell$2_0.O_DRN 0.22995f
C165 wind_comp_0.sg13g2_and2_2$1_0.B wind_comp_0.comparator_1.nmos_0.Gate 0.18042f
C166 ibias1 m3_0_20487# 0.1256f
C167 dig_out[9] vss_1v2_uq0 0.01075f
C168 m4_48706_27032# m4_48181_27032# 0.08419f
C169 wind_comp_0.comparator_0.dynamic_pcell_0.DRN_NET_IH m4_44846_27032# 0.03405f
C170 m4_58437_27032# m4_58962_27032# 0.08419f
C171 wind_comp_0.comparator_0.dynamic_pcell_0.SRC_NET_IJ wind_comp_0.comparator_0.dynamic_pcell_0.DRN_NET_GJ_GATE_GH 0.63021f
C172 dig_in[5] vss_1v2_uq0 0.01075f
C173 wind_comp_0.comparator_0.nmos$2_0.Drain m4_48181_27032# 0.01689f
C174 dig_in[17] vss_1v2_uq0 0.01075f
C175 wind_comp_0.comparator_1.dynamic_pcell$1_0.P_GATE enable 0.02632f
C176 m4_56527_27032# m4_57012_27032# 0.13507f
C177 dig_in[13] vss_1v2_uq0 0.01075f
C178 wind_comp_0.comparator_0.dynamic_pcell$2_0.DRN_NET_LM_GATE_KL wind_comp_0.comparator_0.dynamic_pcell$2_0.O_DRN 0.01756f
C179 wind_comp_0.comparator_1.dynamic_pcell_0.SRC_NET_IJ wind_comp_0.comparator_1.dynamic_pcell$1_0.DRN_NET_PQ_GATE_Q 0.40722f
C180 wind_comp_0.comparator_0.nmos$2_0.Drain m4_44321_27032# 0.10523f
C181 analog_bus1 ibias 8.72712f
C182 wind_comp_0.sg13g2_and2_2$1_0.B wind_comp_0.comparator_1.dynamic_pcell$1_0.DRN_NET_PQ_GATE_Q 0.02816f
C183 wind_comp_0.comparator_0.nmos_0.Gate wind_comp_0.comparator_0.dynamic_pcell$1_0.DRN_NET_PQ_GATE_Q 0.08053f
C184 m4_54577_27032# m4_55102_27032# 0.08419f
C185 wind_comp_0.comparator_1.nmos$2_0.Drain wind_comp_0.sg13g2_and2_2$1_0.B 0.01412f
C186 vbias m3_0_18723# 0.1256f
C187 wind_comp_0.comparator_0.dynamic_pcell$1_0.DRN_NET_PQ_GATE_Q ibias 0.04128f
C188 wind_comp_0.comparator_1.nmos$2_0.Drain m4_57912_27032# 0.02508f
C189 wind_comp_0.comparator_1.dynamic_pcell_0.DRN_NET_IH m4_58437_27032# 0.03405f
C190 wind_comp_0.comparator_1.dynamic_pcell$7_0.DRN_NET_CF_GATE_CD wind_comp_0.comparator_1.dynamic_pcell$7_0.DRN_NET_BE_GATE_AB 4.46697f
C191 dig_out[3] dig_out[2] 0.20933f
C192 ibias1 vss_1v2_uq0 0.01252f
C193 wind_comp_0.comparator_0.dynamic_pcell$2_0.DRN_NET_LM_GATE_KL wind_comp_0.comparator_0.dynamic_pcell$1_0.DRN_NET_PQ_GATE_Q 0.02804f
C194 wind_comp_0.comparator_0.dynamic_pcell$7_0.DRN_NET_BE_GATE_AB wind_comp_0.comparator_0.dynamic_pcell$2_0.O_DRN 0.06659f
C195 wind_comp_0.comparator_1.dynamic_pcell$1_0.DRN_NET_PQ_GATE_Q s4_an 1.23568f
C196 wind_comp_0.comparator_1.dynamic_pcell$1_0.P_GATE wind_comp_0.comparator_1.dynamic_pcell$2_0.O_DRN 0.1307f
C197 dig_out[10] dig_out[9] 0.20933f
C198 enable clk 0.20933f
C199 dig_in[2] dig_in[1] 0.20933f
C200 reset dig_in[23] 0.20933f
C201 dig_out[3] vss_1v2_uq0 0.01075f
C202 wind_comp_0.sg13g2_and2_2$1_0.B wind_comp_0.comparator_1.dynamic_pcell$7_0.DRN_NET_CF_GATE_CD 0.02295f
C203 wind_comp_0.sg13g2_and2_2$1_0.B a_51539_28086# 0.18662f
C204 analog_bus1 analog_bus0 4.17345f
C205 wind_comp_0.sg13g2_and2_2$1_0.A wind_comp_0.comparator_0.nmos_0.Gate 0.18338f
C206 wind_comp_0.comparator_0.nmos_0.Gate enable 0.19744f
C207 analog_bus3 m3_0_20487# 0.1256f
C208 dig_in[6] dig_in[5] 0.20933f
C209 wind_comp_0.comparator_0.dynamic_pcell$1_0.DRN_NET_PQ_GATE_Q wind_comp_0.comparator_0.dynamic_pcell$7_0.DRN_NET_BE_GATE_AB 4.24199f
C210 dig_out[10] vss_1v2_uq0 0.01075f
C211 wind_comp_0.sg13g2_and2_2$1_0.A ibias 0.13761f
C212 enable ibias 3.1496f
C213 wind_comp_0.comparator_1.dynamic_pcell_0.DRN_NET_GJ_GATE_GH wind_comp_0.comparator_1.dynamic_pcell$2_0.O_DRN 0.12398f
C214 dig_in[10] dig_in[9] 0.20933f
C215 dig_in[6] vss_1v2_uq0 0.01075f
C216 wind_comp_0.comparator_1.dynamic_pcell$2_0.DRN_NET_LM_GATE_KL wind_comp_0.comparator_1.sg13cmos5l_inv_16_0.A 0.04738f
C217 dig_in[18] dig_in[17] 0.20933f
C218 wind_comp_0.comparator_0.nmos$2_0.Drain m4_47656_27032# 0.0249f
C219 dig_in[18] vss_1v2_uq0 0.01075f
C220 dig_in[14] dig_in[13] 0.20933f
C221 dig_in[14] vss_1v2_uq0 0.01075f
C222 dig_in[22] dig_in[21] 0.20933f
C223 wind_comp_0.sg13g2_and2_2$1_0.A wind_comp_0.comparator_0.dynamic_pcell$2_0.DRN_NET_LM_GATE_KL 0.10173f
C224 wind_comp_0.comparator_0.dynamic_pcell$2_0.DRN_NET_LM_GATE_KL enable 0.11349f
C225 wind_comp_0.comparator_1.dynamic_pcell_0.DRN_NET_IH wind_comp_0.comparator_1.dynamic_pcell_0.SRC_NET_IJ 0.22976f
C226 wind_comp_0.comparator_1.dynamic_pcell$7_0.DRN_NET_CF_GATE_CD s4_an 1.58844f
C227 wind_comp_0.comparator_0.dynamic_pcell$1_0.DRN_NET_PQ_GATE_Q wind_comp_0.comparator_0.dynamic_pcell$2_0.O_DRN 0.48307f
C228 wind_comp_0.comparator_0.dynamic_pcell$7_0.DRN_NET_CF_GATE_CD ibias 0.06297f
C229 ibias analog_bus2 0.85784f
C230 vbias m3_0_19311# 0.1256f
C231 wind_comp_0.comparator_0.sg13cmos5l_inv_16_0.A wind_comp_0.sg13g2_and2_2$1_0.A 0.85562f
C232 wind_comp_0.comparator_0.sg13cmos5l_inv_16_0.A enable 0.01605f
C233 wind_comp_0.comparator_1.nmos$2_0.Drain m4_57537_27032# 0.01463f
C234 wind_comp_0.comparator_1.dynamic_pcell_0.DRN_NET_IH m4_57912_27032# 0.01464f
C235 wind_comp_0.comparator_1.dynamic_pcell_0.DRN_NET_GJ_GATE_GH wind_comp_0.comparator_1.nmos_0.Gate 0.0177f
C236 wind_comp_0.comparator_1.dynamic_pcell$1_0.P_GATE wind_comp_0.comparator_1.dynamic_pcell$1_0.DRN_NET_PQ_GATE_Q 10.6685f
C237 wind_comp_0.comparator_1.nmos$2_0.Drain wind_comp_0.comparator_1.dynamic_pcell$1_0.P_GATE 0.0256f
C238 wind_comp_0.comparator_0.dynamic_pcell$2_0.DRN_NET_LM_GATE_KL analog_bus2 0.05792f
C239 analog_bus0 vss_3v3 0.04352f
C240 enable vss_1v2_uq0 4.49725f
C241 wind_comp_0.sg13g2_and2_2$1_0.A wind_comp_0.comparator_0.dynamic_pcell$7_0.DRN_NET_BE_GATE_AB 0.02351f
C242 wind_comp_0.comparator_0.dynamic_pcell$7_0.DRN_NET_BE_GATE_AB enable 0.25323f
C243 wind_comp_0.comparator_0.dynamic_pcell$1_0.P_GATE wind_comp_0.comparator_0.dynamic_pcell_0.DRN_NET_GJ_GATE_GH 1.92362f
C244 enable analog_bus0 0.03437f
C245 wind_comp_0.comparator_0.dynamic_pcell_0.SRC_NET_IJ wind_comp_0.comparator_0.dynamic_pcell_0.DRN_NET_IH 0.22976f
C246 m4_46756_27032# m4_47281_27032# 0.03662f
C247 wind_comp_0.comparator_1.dynamic_pcell_0.DRN_NET_GJ_GATE_GH wind_comp_0.comparator_1.dynamic_pcell$1_0.DRN_NET_PQ_GATE_Q 1.08317f
C248 wind_comp_0.comparator_1.dynamic_pcell_0.DRN_NET_GJ_GATE_GH wind_comp_0.comparator_1.nmos$2_0.Drain 2.35146f
C249 dig_out[4] vss_1v2_uq0 0.01075f
C250 m4_44846_27032# m4_45371_27032r# 0.07181f
C251 wind_comp_0.comparator_0.dynamic_pcell$7_0.DRN_NET_BE_GATE_AB wind_comp_0.comparator_0.dynamic_pcell$7_0.DRN_NET_CF_GATE_CD 4.46697f
C252 wind_comp_0.comparator_1.nmos_0.Gate ibias 0.07652f
C253 wind_comp_0.comparator_1.sg13cmos5l_inv_16_0.A enable 0.01605f
C254 wind_comp_0.comparator_0.dynamic_pcell$7_0.DRN_NET_BE_GATE_AB analog_bus2 0.59246f
C255 analog_bus3 m3_0_21075# 0.1256f
C256 dig_out[5] vss_1v2_uq0 0.01075f
C257 dig_out[11] vss_1v2_uq0 0.01559f
C258 m4_57912_27032# m4_58437_27032# 0.07181f
C259 wind_comp_0.comparator_1.dynamic_pcell$7_0.DRN_NET_CF_GATE_CD wind_comp_0.comparator_1.dynamic_pcell$1_0.P_GATE 4.50368f
C260 dig_in[7] vss_1v2_uq0 0.01075f
C261 wind_comp_0.comparator_1.dynamic_pcell$2_0.DRN_NET_LM_GATE_KL enable 0.11171f
C262 wind_comp_0.comparator_0.nmos$2_0.Drain m4_47281_27032# 0.01459f
C263 analog_bus1 vss_3v3 0.01641f
C264 dig_in[19] vss_1v2_uq0 0.01075f
C265 m4_56152_27032# m4_56527_27032# 0.03662f
C266 analog_bus0 wind_comp_0.comparator_1.dynamic_pcell$2_0.O_DRN 0.30829f
C267 dig_in[15] vss_1v2_uq0 0.01075f
C268 wind_comp_0.comparator_0.dynamic_pcell$7_0.DRN_NET_CF_GATE_CD wind_comp_0.comparator_0.dynamic_pcell$2_0.O_DRN 0.0352f
C269 wind_comp_0.comparator_0.dynamic_pcell$2_0.DRN_NET_LM_GATE_KL m4_44321_27032# 0.06049f
C270 enable analog_bus1 7.98179f
C271 analog_bus2 wind_comp_0.comparator_0.dynamic_pcell$2_0.O_DRN 0.22995f
C272 wind_comp_0.sg13g2_and2_2$1_0.A wind_comp_0.comparator_0.dynamic_pcell$1_0.DRN_NET_PQ_GATE_Q 0.02864f
C273 wind_comp_0.comparator_1.dynamic_pcell$1_0.DRN_NET_PQ_GATE_Q ibias 0.04086f
C274 wind_comp_0.comparator_0.dynamic_pcell$1_0.DRN_NET_PQ_GATE_Q enable 0.04456f
C275 analog_bus1 m3_0_21663# 0.1256f
C276 wind_comp_0.comparator_1.nmos$2_0.Drain ibias 0.18299f
C277 analog_bus2 m3_0_21075# 0.1256f
C278 wind_comp_0.comparator_1.nmos$2_0.Drain m4_57012_27032# 0.02129f
C279 wind_comp_0.comparator_1.dynamic_pcell_0.DRN_NET_GJ_GATE_GH wind_comp_0.comparator_1.dynamic_pcell$7_0.DRN_NET_CF_GATE_CD 0.02539f
C280 wind_comp_0.comparator_0.nmos$2_0.Drain wind_comp_0.comparator_0.dynamic_pcell$1_0.P_GATE 0.0256f
C281 dig_out[4] dig_out[3] 0.20933f
C282 wind_comp_0.sg13g2_and2_2$1_0.B wind_comp_0.comparator_1.dynamic_pcell$7_0.DRN_NET_BE_GATE_AB 0.02293f
C283 wind_comp_0.comparator_1.dynamic_pcell_0.DRN_NET_IH wind_comp_0.comparator_1.dynamic_pcell$1_0.P_GATE 0.5803f
C284 analog_bus1 analog_bus2 4.20794f
C285 wind_comp_0.comparator_0.dynamic_pcell$1_0.P_GATE s4_an 2.89639f
C286 wind_comp_0.comparator_0.dynamic_pcell$1_0.DRN_NET_PQ_GATE_Q wind_comp_0.comparator_0.dynamic_pcell$7_0.DRN_NET_CF_GATE_CD 0.11165f
C287 dig_out[7] dig_out[6] 0.20933f
C288 wind_comp_0.comparator_0.dynamic_pcell$1_0.DRN_NET_PQ_GATE_Q analog_bus2 0.24193f
C289 wind_comp_0.comparator_1.dynamic_pcell$2_0.DRN_NET_LM_GATE_KL wind_comp_0.comparator_1.dynamic_pcell$2_0.O_DRN 0.01756f
C290 wind_comp_0.comparator_0.nmos$2_0.Drain wind_comp_0.comparator_0.dynamic_pcell_0.DRN_NET_GJ_GATE_GH 2.35146f
C291 dig_out[11] dig_out[10] 0.20933f
C292 analog_bus0 m3_0_22251# 0.1256f
C293 wind_comp_0.comparator_0.dynamic_pcell_0.DRN_NET_GJ_GATE_GH s4_an 0.03234f
C294 reset vss_1v2_uq0 0.0108f
C295 wind_comp_0.comparator_1.dynamic_pcell_0.DRN_NET_IH wind_comp_0.comparator_1.dynamic_pcell_0.DRN_NET_GJ_GATE_GH 2.10778f
C296 dig_in[3] dig_in[2] 0.20933f
C297 wind_comp_0.comparator_0.dynamic_pcell$2_0.DRN_NET_LM_GATE_KL wind_comp_0.comparator_0.dynamic_pcell_0.SRC_NET_IJ 2.90157f
C298 wind_comp_0.comparator_1.dynamic_pcell$7_0.DRN_NET_BE_GATE_AB s4_an 0.60677f
C299 wind_comp_0.comparator_1.dynamic_pcell$7_0.DRN_NET_CF_GATE_CD ibias 0.06253f
C300 wind_comp_0.comparator_1.dynamic_pcell$1_0.DRN_NET_PQ_GATE_Q analog_bus0 0.11353f
C301 wind_comp_0.sg13g2_and2_2$1_0.A enable 0.08167f
C302 dig_in[7] dig_in[6] 0.20933f
C303 ibias m4_21542_3976# 5.39058f
C304 dig_in[0] vss_1v2_uq0 0.01559f
C305 dig_in[11] dig_in[10] 0.20933f
C306 dig_in[8] vss_1v2_uq0 0.01075f
C307 dig_in[19] dig_in[18] 0.20933f
C308 wind_comp_0.comparator_0.nmos$2_0.Drain m4_46756_27032# 0.02127f
C309 dig_in[16] dig_in[17] 0.20933f
C310 dig_in[20] vss_1v2_uq0 0.01075f
C311 dig_in[15] dig_in[14] 0.20933f
C312 dig_in[16] vss_1v2_uq0 0.01075f
C313 wind_comp_0.sg13g2_and2_2$1_0.A wind_comp_0.comparator_0.dynamic_pcell$7_0.DRN_NET_CF_GATE_CD 0.02366f
C314 dig_in[23] dig_in[22] 0.20933f
C315 wind_comp_0.comparator_0.dynamic_pcell$7_0.DRN_NET_CF_GATE_CD enable 0.1625f
C316 wind_comp_0.sg13g2_and2_2$1_0.A analog_bus2 0.03616f
C317 wind_comp_0.comparator_0.dynamic_pcell$1_0.P_GATE wind_comp_0.comparator_0.dynamic_pcell_0.DRN_NET_IH 0.5803f
C318 wind_comp_0.comparator_1.nmos$2_0.Drain wind_comp_0.comparator_1.sg13cmos5l_inv_16_0.A 0.01519f
C319 wind_comp_0.comparator_1.dynamic_pcell_0.SRC_NET_IJ s4_an 0.0163f
C320 enable analog_bus2 9.09035f
C321 analog_bus1 m3_0_22251# 0.1256f
C322 wind_comp_0.sg13g2_and2_2$1_0.B s4_an 0.0316f
C323 analog_bus2 m3_0_21663# 0.1256f
C324 wind_comp_0.comparator_1.dynamic_pcell$2_0.DRN_NET_LM_GATE_KL wind_comp_0.comparator_1.dynamic_pcell$1_0.DRN_NET_PQ_GATE_Q 0.02804f
C325 wind_comp_0.comparator_1.nmos$2_0.Drain m4_56527_27032# 0.02127f
C326 wind_comp_0.comparator_0.nmos$2_0.Drain m4_48706_27032# 0.0126f
C327 wind_comp_0.comparator_1.dynamic_pcell$2_0.DRN_NET_LM_GATE_KL wind_comp_0.comparator_1.nmos$2_0.Drain 1.96067f
C328 wind_comp_0.comparator_0.dynamic_pcell_0.DRN_NET_GJ_GATE_GH wind_comp_0.comparator_0.dynamic_pcell_0.DRN_NET_IH 2.10778f
C329 wind_comp_0.comparator_1.dynamic_pcell_0.DRN_NET_GJ_GATE_GH m4_58437_27032# 0.03326f
C330 wind_comp_0.comparator_1.dynamic_pcell$7_0.DRN_NET_CF_GATE_CD analog_bus0 0.62481f
C331 wind_comp_0.comparator_0.dynamic_pcell$7_0.DRN_NET_CF_GATE_CD analog_bus2 1.57977f
C332 m4_21542_3976# vss_1v2_uq0 15.1581f
C333 dig_out[5] dig_out[4] 0.20933f
C334 analog_bus0 m4_21542_3976# 5.06321f
C335 wind_comp_0.comparator_1.dynamic_pcell$7_0.DRN_NET_BE_GATE_AB wind_comp_0.comparator_1.dynamic_pcell$1_0.P_GATE 0.2714f
R0 enable enable.n11 149.203
R1 enable.n9 enable.t1 35.3051
R2 enable.n6 enable.t0 35.3043
R3 enable.n1 enable.t10 16.5863
R4 enable.n10 enable.t11 16.5863
R5 enable.n5 enable.t2 15.0022
R6 enable.n8 enable.t5 15.0022
R7 enable.n1 enable.t8 15.1275
R8 enable.n1 enable.t9 15.0005
R9 enable.n10 enable.t12 15.0005
R10 enable.n0 enable.n6 12.8903
R11 enable.n2 enable.n10 0.12986
R12 enable.n2 enable.n3 8.91724
R13 enable.n6 enable.n5 9.0005
R14 enable.n9 enable.n8 9.0005
R15 enable.n11 enable.n0 6.78408
R16 enable.n7 enable.t4 5.26199
R17 enable.n4 enable.t3 5.24366
R18 enable.n4 enable.t6 4.39106
R19 enable.n7 enable.t7 4.39106
R20 enable.n11 enable.n3 3.69968
R21 enable.n5 enable.n4 0.468833
R22 enable.n8 enable.n7 0.468833
R23 enable.t13 enable.n2 15.1275
R24 enable.n3 enable.n9 12.8903
R25 enable.n1 enable.n0 9.0466
R26 wind_comp_0.sg13g2_and2_2$1_0.VDD.n529 wind_comp_0.sg13g2_and2_2$1_0.VDD.t236 26.719
R27 wind_comp_0.sg13g2_and2_2$1_0.VDD.n524 wind_comp_0.sg13g2_and2_2$1_0.VDD.t28 26.719
R28 wind_comp_0.sg13g2_and2_2$1_0.VDD.n176 wind_comp_0.sg13g2_and2_2$1_0.VDD.t1 26.719
R29 wind_comp_0.sg13g2_and2_2$1_0.VDD.n611 wind_comp_0.sg13g2_and2_2$1_0.VDD.t8 26.719
R30 wind_comp_0.comparator_1.dynamic_pcell$2_0.SRC_NET_KL wind_comp_0.sg13g2_and2_2$1_0.VDD.t34 26.2046
R31 wind_comp_0.comparator_1.dynamic_pcell$2_0.SRC_NET_KL wind_comp_0.sg13g2_and2_2$1_0.VDD.t33 26.2046
R32 wind_comp_0.comparator_1.dynamic_pcell$2_0.SRC_NET_KL wind_comp_0.sg13g2_and2_2$1_0.VDD.t30 26.2046
R33 wind_comp_0.comparator_1.dynamic_pcell$2_0.SRC_NET_KL wind_comp_0.sg13g2_and2_2$1_0.VDD.t31 26.2046
R34 wind_comp_0.comparator_0.dynamic_pcell$2_0.SRC_NET_KL wind_comp_0.sg13g2_and2_2$1_0.VDD.t58 26.2046
R35 wind_comp_0.comparator_0.dynamic_pcell$2_0.SRC_NET_KL wind_comp_0.sg13g2_and2_2$1_0.VDD.t54 26.2046
R36 wind_comp_0.comparator_0.dynamic_pcell$2_0.SRC_NET_KL wind_comp_0.sg13g2_and2_2$1_0.VDD.t57 26.2046
R37 wind_comp_0.comparator_0.dynamic_pcell$2_0.SRC_NET_KL wind_comp_0.sg13g2_and2_2$1_0.VDD.t56 26.2046
R38 wind_comp_0.sg13g2_and2_2$1_0.VDD.n525 wind_comp_0.sg13g2_and2_2$1_0.VDD.t234 26.0005
R39 wind_comp_0.sg13g2_and2_2$1_0.VDD.n528 wind_comp_0.sg13g2_and2_2$1_0.VDD.t26 26.0005
R40 wind_comp_0.sg13g2_and2_2$1_0.VDD.n610 wind_comp_0.sg13g2_and2_2$1_0.VDD.t0 26.0005
R41 wind_comp_0.sg13g2_and2_2$1_0.VDD.n177 wind_comp_0.sg13g2_and2_2$1_0.VDD.t6 26.0005
R42 wind_comp_0.sg13g2_and2_2$1_0.VDD.n704 wind_comp_0.sg13g2_and2_2$1_0.VDD.n75 23.1023
R43 wind_comp_0.sg13g2_and2_2$1_0.VDD.n293 wind_comp_0.sg13g2_and2_2$1_0.VDD.t49 20.5284
R44 wind_comp_0.sg13g2_and2_2$1_0.VDD.n31 wind_comp_0.sg13g2_and2_2$1_0.VDD.t11 20.5284
R45 wind_comp_0.sg13g2_and2_2$1_0.VDD.n704 wind_comp_0.sg13g2_and2_2$1_0.VDD.n74 18.9755
R46 wind_comp_0.sg13g2_and2_2$1_0.VDD.n26 wind_comp_0.sg13g2_and2_2$1_0.VDD.n474 18.0005
R47 wind_comp_0.sg13g2_and2_2$1_0.VDD.n22 wind_comp_0.sg13g2_and2_2$1_0.VDD.n21 18.0005
R48 wind_comp_0.sg13g2_and2_2$1_0.VDD.n472 wind_comp_0.sg13g2_and2_2$1_0.VDD.n24 18.0005
R49 wind_comp_0.sg13g2_and2_2$1_0.VDD.n687 wind_comp_0.sg13g2_and2_2$1_0.VDD.n686 18.0005
R50 wind_comp_0.sg13g2_and2_2$1_0.VDD.n19 wind_comp_0.sg13g2_and2_2$1_0.VDD.n691 18.0005
R51 wind_comp_0.sg13g2_and2_2$1_0.VDD.n689 wind_comp_0.sg13g2_and2_2$1_0.VDD.n19 18.0005
R52 wind_comp_0.sg13g2_and2_2$1_0.VDD.n293 wind_comp_0.sg13g2_and2_2$1_0.VDD.t51 17.7393
R53 wind_comp_0.sg13g2_and2_2$1_0.VDD.n31 wind_comp_0.sg13g2_and2_2$1_0.VDD.t10 17.7393
R54 wind_comp_0.sg13g2_and2_2$1_0.VDD.n605 wind_comp_0.sg13g2_and2_2$1_0.VDD.t97 17.7086
R55 wind_comp_0.sg13g2_and2_2$1_0.VDD.n287 wind_comp_0.sg13g2_and2_2$1_0.VDD.t98 17.7086
R56 wind_comp_0.sg13g2_and2_2$1_0.VDD.n603 wind_comp_0.sg13g2_and2_2$1_0.VDD.t95 17.6763
R57 wind_comp_0.sg13g2_and2_2$1_0.VDD.n285 wind_comp_0.sg13g2_and2_2$1_0.VDD.t99 17.6763
R58 wind_comp_0.sg13g2_and2_2$1_0.VDD.n154 wind_comp_0.sg13g2_and2_2$1_0.VDD.n72 17.0125
R59 wind_comp_0.sg13g2_and2_2$1_0.VDD.n656 wind_comp_0.sg13g2_and2_2$1_0.VDD.n72 17.0033
R60 wind_comp_0.sg13g2_and2_2$1_0.VDD.n705 wind_comp_0.sg13g2_and2_2$1_0.VDD.n64 17.0005
R61 wind_comp_0.sg13g2_and2_2$1_0.VDD.n705 wind_comp_0.sg13g2_and2_2$1_0.VDD.n60 17.0005
R62 wind_comp_0.sg13g2_and2_2$1_0.VDD.n705 wind_comp_0.sg13g2_and2_2$1_0.VDD.n61 17.0005
R63 wind_comp_0.sg13g2_and2_2$1_0.VDD.n705 wind_comp_0.sg13g2_and2_2$1_0.VDD.n62 17.0005
R64 wind_comp_0.sg13g2_and2_2$1_0.VDD.n71 wind_comp_0.sg13g2_and2_2$1_0.VDD.n70 17.0005
R65 wind_comp_0.sg13g2_and2_2$1_0.VDD.n600 wind_comp_0.sg13g2_and2_2$1_0.VDD.n599 17.0005
R66 wind_comp_0.sg13g2_and2_2$1_0.VDD.n4 wind_comp_0.sg13g2_and2_2$1_0.VDD.n5 0.0051528
R67 wind_comp_0.sg13g2_and2_2$1_0.VDD.n595 wind_comp_0.sg13g2_and2_2$1_0.VDD.n594 17.0005
R68 wind_comp_0.sg13g2_and2_2$1_0.VDD.n595 wind_comp_0.sg13g2_and2_2$1_0.VDD.n289 17.0005
R69 wind_comp_0.sg13g2_and2_2$1_0.VDD.n595 wind_comp_0.sg13g2_and2_2$1_0.VDD.n290 17.0005
R70 wind_comp_0.sg13g2_and2_2$1_0.VDD.n596 wind_comp_0.sg13g2_and2_2$1_0.VDD.n250 17.0005
R71 wind_comp_0.sg13g2_and2_2$1_0.VDD.n596 wind_comp_0.sg13g2_and2_2$1_0.VDD.n282 17.0005
R72 wind_comp_0.sg13g2_and2_2$1_0.VDD.n596 wind_comp_0.sg13g2_and2_2$1_0.VDD.n278 17.0005
R73 wind_comp_0.sg13g2_and2_2$1_0.VDD.n596 wind_comp_0.sg13g2_and2_2$1_0.VDD.n276 17.0005
R74 wind_comp_0.sg13g2_and2_2$1_0.VDD.n596 wind_comp_0.sg13g2_and2_2$1_0.VDD.n274 17.0005
R75 wind_comp_0.sg13g2_and2_2$1_0.VDD.n596 wind_comp_0.sg13g2_and2_2$1_0.VDD.n272 17.0005
R76 wind_comp_0.sg13g2_and2_2$1_0.VDD.n596 wind_comp_0.sg13g2_and2_2$1_0.VDD.n270 17.0005
R77 wind_comp_0.sg13g2_and2_2$1_0.VDD.n596 wind_comp_0.sg13g2_and2_2$1_0.VDD.n268 17.0005
R78 wind_comp_0.sg13g2_and2_2$1_0.VDD.n596 wind_comp_0.sg13g2_and2_2$1_0.VDD.n266 17.0005
R79 wind_comp_0.sg13g2_and2_2$1_0.VDD.n596 wind_comp_0.sg13g2_and2_2$1_0.VDD.n264 17.0005
R80 wind_comp_0.sg13g2_and2_2$1_0.VDD.n596 wind_comp_0.sg13g2_and2_2$1_0.VDD.n262 17.0005
R81 wind_comp_0.sg13g2_and2_2$1_0.VDD.n596 wind_comp_0.sg13g2_and2_2$1_0.VDD.n260 17.0005
R82 wind_comp_0.sg13g2_and2_2$1_0.VDD.n596 wind_comp_0.sg13g2_and2_2$1_0.VDD.n256 17.0005
R83 wind_comp_0.sg13g2_and2_2$1_0.VDD.n596 wind_comp_0.sg13g2_and2_2$1_0.VDD.n254 17.0005
R84 wind_comp_0.sg13g2_and2_2$1_0.VDD.n596 wind_comp_0.sg13g2_and2_2$1_0.VDD.n252 17.0005
R85 wind_comp_0.sg13g2_and2_2$1_0.VDD.n520 wind_comp_0.sg13g2_and2_2$1_0.VDD.n249 17.0005
R86 wind_comp_0.sg13g2_and2_2$1_0.VDD.n253 wind_comp_0.sg13g2_and2_2$1_0.VDD.n249 17.0005
R87 wind_comp_0.sg13g2_and2_2$1_0.VDD.n255 wind_comp_0.sg13g2_and2_2$1_0.VDD.n249 17.0005
R88 wind_comp_0.sg13g2_and2_2$1_0.VDD.n257 wind_comp_0.sg13g2_and2_2$1_0.VDD.n249 17.0005
R89 wind_comp_0.sg13g2_and2_2$1_0.VDD.n261 wind_comp_0.sg13g2_and2_2$1_0.VDD.n249 17.0005
R90 wind_comp_0.sg13g2_and2_2$1_0.VDD.n263 wind_comp_0.sg13g2_and2_2$1_0.VDD.n249 17.0005
R91 wind_comp_0.sg13g2_and2_2$1_0.VDD.n265 wind_comp_0.sg13g2_and2_2$1_0.VDD.n249 17.0005
R92 wind_comp_0.sg13g2_and2_2$1_0.VDD.n267 wind_comp_0.sg13g2_and2_2$1_0.VDD.n249 17.0005
R93 wind_comp_0.sg13g2_and2_2$1_0.VDD.n269 wind_comp_0.sg13g2_and2_2$1_0.VDD.n249 17.0005
R94 wind_comp_0.sg13g2_and2_2$1_0.VDD.n271 wind_comp_0.sg13g2_and2_2$1_0.VDD.n249 17.0005
R95 wind_comp_0.sg13g2_and2_2$1_0.VDD.n273 wind_comp_0.sg13g2_and2_2$1_0.VDD.n249 17.0005
R96 wind_comp_0.sg13g2_and2_2$1_0.VDD.n275 wind_comp_0.sg13g2_and2_2$1_0.VDD.n249 17.0005
R97 wind_comp_0.sg13g2_and2_2$1_0.VDD.n277 wind_comp_0.sg13g2_and2_2$1_0.VDD.n249 17.0005
R98 wind_comp_0.sg13g2_and2_2$1_0.VDD.n595 wind_comp_0.sg13g2_and2_2$1_0.VDD.n10 17.0005
R99 wind_comp_0.sg13g2_and2_2$1_0.VDD.n595 wind_comp_0.sg13g2_and2_2$1_0.VDD.n291 17.0005
R100 wind_comp_0.sg13g2_and2_2$1_0.VDD.n595 wind_comp_0.sg13g2_and2_2$1_0.VDD.n294 17.0005
R101 wind_comp_0.sg13g2_and2_2$1_0.VDD.n595 wind_comp_0.sg13g2_and2_2$1_0.VDD.n296 17.0005
R102 wind_comp_0.sg13g2_and2_2$1_0.VDD.n595 wind_comp_0.sg13g2_and2_2$1_0.VDD.n298 17.0005
R103 wind_comp_0.sg13g2_and2_2$1_0.VDD.n595 wind_comp_0.sg13g2_and2_2$1_0.VDD.n7 17.0005
R104 wind_comp_0.sg13g2_and2_2$1_0.VDD.n595 wind_comp_0.sg13g2_and2_2$1_0.VDD.n300 17.0005
R105 wind_comp_0.sg13g2_and2_2$1_0.VDD.n595 wind_comp_0.sg13g2_and2_2$1_0.VDD.n303 17.0005
R106 wind_comp_0.sg13g2_and2_2$1_0.VDD.n595 wind_comp_0.sg13g2_and2_2$1_0.VDD.n305 17.0005
R107 wind_comp_0.sg13g2_and2_2$1_0.VDD.n595 wind_comp_0.sg13g2_and2_2$1_0.VDD.n307 17.0005
R108 wind_comp_0.sg13g2_and2_2$1_0.VDD.n595 wind_comp_0.sg13g2_and2_2$1_0.VDD.n310 17.0005
R109 wind_comp_0.sg13g2_and2_2$1_0.VDD.n595 wind_comp_0.sg13g2_and2_2$1_0.VDD.n312 17.0005
R110 wind_comp_0.sg13g2_and2_2$1_0.VDD.n595 wind_comp_0.sg13g2_and2_2$1_0.VDD.n315 17.0005
R111 wind_comp_0.sg13g2_and2_2$1_0.VDD.n595 wind_comp_0.sg13g2_and2_2$1_0.VDD.n317 17.0005
R112 wind_comp_0.sg13g2_and2_2$1_0.VDD.n595 wind_comp_0.sg13g2_and2_2$1_0.VDD.n320 17.0005
R113 wind_comp_0.sg13g2_and2_2$1_0.VDD.n595 wind_comp_0.sg13g2_and2_2$1_0.VDD.n322 17.0005
R114 wind_comp_0.sg13g2_and2_2$1_0.VDD.n9 wind_comp_0.sg13g2_and2_2$1_0.VDD.n17 17.0005
R115 wind_comp_0.sg13g2_and2_2$1_0.VDD.n292 wind_comp_0.sg13g2_and2_2$1_0.VDD.n17 17.0005
R116 wind_comp_0.sg13g2_and2_2$1_0.VDD.n297 wind_comp_0.sg13g2_and2_2$1_0.VDD.n17 17.0005
R117 wind_comp_0.sg13g2_and2_2$1_0.VDD.n299 wind_comp_0.sg13g2_and2_2$1_0.VDD.n17 17.0005
R118 wind_comp_0.sg13g2_and2_2$1_0.VDD.n8 wind_comp_0.sg13g2_and2_2$1_0.VDD.n17 8.4953
R119 wind_comp_0.sg13g2_and2_2$1_0.VDD.n301 wind_comp_0.sg13g2_and2_2$1_0.VDD.n17 17.0005
R120 wind_comp_0.sg13g2_and2_2$1_0.VDD.n306 wind_comp_0.sg13g2_and2_2$1_0.VDD.n17 17.0005
R121 wind_comp_0.sg13g2_and2_2$1_0.VDD.n311 wind_comp_0.sg13g2_and2_2$1_0.VDD.n17 17.0005
R122 wind_comp_0.sg13g2_and2_2$1_0.VDD.n314 wind_comp_0.sg13g2_and2_2$1_0.VDD.n17 17.0005
R123 wind_comp_0.sg13g2_and2_2$1_0.VDD.n319 wind_comp_0.sg13g2_and2_2$1_0.VDD.n17 17.0005
R124 wind_comp_0.sg13g2_and2_2$1_0.VDD.n443 wind_comp_0.sg13g2_and2_2$1_0.VDD.n17 17.0005
R125 wind_comp_0.sg13g2_and2_2$1_0.VDD.n595 wind_comp_0.sg13g2_and2_2$1_0.VDD.n591 17.0005
R126 wind_comp_0.sg13g2_and2_2$1_0.VDD.n462 wind_comp_0.sg13g2_and2_2$1_0.VDD.n17 17.0005
R127 wind_comp_0.sg13g2_and2_2$1_0.VDD.n464 wind_comp_0.sg13g2_and2_2$1_0.VDD.n17 17.0005
R128 wind_comp_0.sg13g2_and2_2$1_0.VDD.n466 wind_comp_0.sg13g2_and2_2$1_0.VDD.n17 17.0005
R129 wind_comp_0.sg13g2_and2_2$1_0.VDD.n469 wind_comp_0.sg13g2_and2_2$1_0.VDD.n17 17.0005
R130 wind_comp_0.sg13g2_and2_2$1_0.VDD.n23 wind_comp_0.sg13g2_and2_2$1_0.VDD.n17 17.0005
R131 wind_comp_0.sg13g2_and2_2$1_0.VDD.n414 wind_comp_0.sg13g2_and2_2$1_0.VDD.n17 17.0005
R132 wind_comp_0.sg13g2_and2_2$1_0.VDD.n416 wind_comp_0.sg13g2_and2_2$1_0.VDD.n17 17.0005
R133 wind_comp_0.sg13g2_and2_2$1_0.VDD.n413 wind_comp_0.sg13g2_and2_2$1_0.VDD.n17 17.0005
R134 wind_comp_0.sg13g2_and2_2$1_0.VDD.n411 wind_comp_0.sg13g2_and2_2$1_0.VDD.n17 17.0005
R135 wind_comp_0.sg13g2_and2_2$1_0.VDD.n409 wind_comp_0.sg13g2_and2_2$1_0.VDD.n17 17.0005
R136 wind_comp_0.sg13g2_and2_2$1_0.VDD.n18 wind_comp_0.sg13g2_and2_2$1_0.VDD.n17 17.0005
R137 wind_comp_0.sg13g2_and2_2$1_0.VDD.n405 wind_comp_0.sg13g2_and2_2$1_0.VDD.n17 17.0005
R138 wind_comp_0.sg13g2_and2_2$1_0.VDD.n341 wind_comp_0.sg13g2_and2_2$1_0.VDD.n25 0.00456857
R139 wind_comp_0.sg13g2_and2_2$1_0.VDD.n25 wind_comp_0.sg13g2_and2_2$1_0.VDD.n17 8.49922
R140 wind_comp_0.sg13g2_and2_2$1_0.VDD.n476 wind_comp_0.sg13g2_and2_2$1_0.VDD.n17 17.0005
R141 wind_comp_0.sg13g2_and2_2$1_0.VDD.n457 wind_comp_0.sg13g2_and2_2$1_0.VDD.n17 17.0005
R142 wind_comp_0.sg13g2_and2_2$1_0.VDD.n455 wind_comp_0.sg13g2_and2_2$1_0.VDD.n17 17.0005
R143 wind_comp_0.sg13g2_and2_2$1_0.VDD.n453 wind_comp_0.sg13g2_and2_2$1_0.VDD.n17 17.0005
R144 wind_comp_0.sg13g2_and2_2$1_0.VDD.n20 wind_comp_0.sg13g2_and2_2$1_0.VDD.n17 17.0005
R145 wind_comp_0.sg13g2_and2_2$1_0.VDD.n364 wind_comp_0.sg13g2_and2_2$1_0.VDD.n17 17.0005
R146 wind_comp_0.sg13g2_and2_2$1_0.VDD.n366 wind_comp_0.sg13g2_and2_2$1_0.VDD.n17 17.0005
R147 wind_comp_0.sg13g2_and2_2$1_0.VDD.n369 wind_comp_0.sg13g2_and2_2$1_0.VDD.n17 17.0005
R148 wind_comp_0.sg13g2_and2_2$1_0.VDD.n11 wind_comp_0.sg13g2_and2_2$1_0.VDD.n17 4.24777
R149 wind_comp_0.sg13g2_and2_2$1_0.VDD.n341 wind_comp_0.sg13g2_and2_2$1_0.VDD.n13 17.0005
R150 wind_comp_0.sg13g2_and2_2$1_0.VDD.n15 wind_comp_0.sg13g2_and2_2$1_0.VDD.n13 17.0005
R151 wind_comp_0.sg13g2_and2_2$1_0.VDD.n408 wind_comp_0.sg13g2_and2_2$1_0.VDD.n13 17.0005
R152 wind_comp_0.sg13g2_and2_2$1_0.VDD.n410 wind_comp_0.sg13g2_and2_2$1_0.VDD.n13 17.0005
R153 wind_comp_0.sg13g2_and2_2$1_0.VDD.n412 wind_comp_0.sg13g2_and2_2$1_0.VDD.n13 17.0005
R154 wind_comp_0.sg13g2_and2_2$1_0.VDD.n415 wind_comp_0.sg13g2_and2_2$1_0.VDD.n13 17.0005
R155 wind_comp_0.sg13g2_and2_2$1_0.VDD.n24 wind_comp_0.sg13g2_and2_2$1_0.VDD.n13 17.0005
R156 wind_comp_0.sg13g2_and2_2$1_0.VDD.n471 wind_comp_0.sg13g2_and2_2$1_0.VDD.n13 17.0005
R157 wind_comp_0.sg13g2_and2_2$1_0.VDD.n468 wind_comp_0.sg13g2_and2_2$1_0.VDD.n13 17.0005
R158 wind_comp_0.sg13g2_and2_2$1_0.VDD.n465 wind_comp_0.sg13g2_and2_2$1_0.VDD.n13 17.0005
R159 wind_comp_0.sg13g2_and2_2$1_0.VDD.n463 wind_comp_0.sg13g2_and2_2$1_0.VDD.n13 17.0005
R160 wind_comp_0.sg13g2_and2_2$1_0.VDD.n460 wind_comp_0.sg13g2_and2_2$1_0.VDD.n13 17.0005
R161 wind_comp_0.sg13g2_and2_2$1_0.VDD.n458 wind_comp_0.sg13g2_and2_2$1_0.VDD.n13 17.0005
R162 wind_comp_0.sg13g2_and2_2$1_0.VDD.n456 wind_comp_0.sg13g2_and2_2$1_0.VDD.n13 17.0005
R163 wind_comp_0.sg13g2_and2_2$1_0.VDD.n353 wind_comp_0.sg13g2_and2_2$1_0.VDD.n13 17.0005
R164 wind_comp_0.sg13g2_and2_2$1_0.VDD.n22 wind_comp_0.sg13g2_and2_2$1_0.VDD.n13 17.0005
R165 wind_comp_0.sg13g2_and2_2$1_0.VDD.n365 wind_comp_0.sg13g2_and2_2$1_0.VDD.n13 17.0005
R166 wind_comp_0.sg13g2_and2_2$1_0.VDD.n368 wind_comp_0.sg13g2_and2_2$1_0.VDD.n13 17.0005
R167 wind_comp_0.sg13g2_and2_2$1_0.VDD.n370 wind_comp_0.sg13g2_and2_2$1_0.VDD.n13 17.0005
R168 wind_comp_0.sg13g2_and2_2$1_0.VDD.n372 wind_comp_0.sg13g2_and2_2$1_0.VDD.n13 17.0005
R169 wind_comp_0.sg13g2_and2_2$1_0.VDD.n14 wind_comp_0.sg13g2_and2_2$1_0.VDD.n12 0.0120626
R170 wind_comp_0.sg13g2_and2_2$1_0.VDD.n11 wind_comp_0.sg13g2_and2_2$1_0.VDD.n12 0.00960191
R171 wind_comp_0.sg13g2_and2_2$1_0.VDD.n12 wind_comp_0.sg13g2_and2_2$1_0.VDD.n13 5.6653
R172 wind_comp_0.sg13g2_and2_2$1_0.VDD.n362 wind_comp_0.sg13g2_and2_2$1_0.VDD.t225 17.0005
R173 wind_comp_0.sg13g2_and2_2$1_0.VDD.n358 wind_comp_0.sg13g2_and2_2$1_0.VDD.t224 17.0005
R174 wind_comp_0.sg13g2_and2_2$1_0.VDD.n345 wind_comp_0.sg13g2_and2_2$1_0.VDD.t216 17.0005
R175 wind_comp_0.sg13g2_and2_2$1_0.VDD.n347 wind_comp_0.sg13g2_and2_2$1_0.VDD.t215 17.0005
R176 wind_comp_0.sg13g2_and2_2$1_0.VDD.n402 wind_comp_0.sg13g2_and2_2$1_0.VDD.t207 17.0005
R177 wind_comp_0.sg13g2_and2_2$1_0.VDD.n398 wind_comp_0.sg13g2_and2_2$1_0.VDD.t206 17.0005
R178 wind_comp_0.sg13g2_and2_2$1_0.VDD.n438 wind_comp_0.sg13g2_and2_2$1_0.VDD.t232 17.0005
R179 wind_comp_0.sg13g2_and2_2$1_0.VDD.n433 wind_comp_0.sg13g2_and2_2$1_0.VDD.t229 17.0005
R180 wind_comp_0.sg13g2_and2_2$1_0.VDD.n423 wind_comp_0.sg13g2_and2_2$1_0.VDD.t220 17.0005
R181 wind_comp_0.sg13g2_and2_2$1_0.VDD.n376 wind_comp_0.sg13g2_and2_2$1_0.VDD.t222 17.0005
R182 wind_comp_0.sg13g2_and2_2$1_0.VDD.n383 wind_comp_0.sg13g2_and2_2$1_0.VDD.t209 17.0005
R183 wind_comp_0.sg13g2_and2_2$1_0.VDD.n379 wind_comp_0.sg13g2_and2_2$1_0.VDD.t213 17.0005
R184 wind_comp_0.sg13g2_and2_2$1_0.VDD.n515 wind_comp_0.sg13g2_and2_2$1_0.VDD.t175 17.0005
R185 wind_comp_0.sg13g2_and2_2$1_0.VDD.n513 wind_comp_0.sg13g2_and2_2$1_0.VDD.t178 17.0005
R186 wind_comp_0.sg13g2_and2_2$1_0.VDD.n508 wind_comp_0.sg13g2_and2_2$1_0.VDD.t158 17.0005
R187 wind_comp_0.sg13g2_and2_2$1_0.VDD.n506 wind_comp_0.sg13g2_and2_2$1_0.VDD.t168 17.0005
R188 wind_comp_0.sg13g2_and2_2$1_0.VDD.n241 wind_comp_0.sg13g2_and2_2$1_0.VDD.t165 17.0005
R189 wind_comp_0.sg13g2_and2_2$1_0.VDD.n243 wind_comp_0.sg13g2_and2_2$1_0.VDD.t160 17.0005
R190 wind_comp_0.sg13g2_and2_2$1_0.VDD.n236 wind_comp_0.sg13g2_and2_2$1_0.VDD.t170 17.0005
R191 wind_comp_0.sg13g2_and2_2$1_0.VDD.n234 wind_comp_0.sg13g2_and2_2$1_0.VDD.t171 17.0005
R192 wind_comp_0.sg13g2_and2_2$1_0.VDD.n224 wind_comp_0.sg13g2_and2_2$1_0.VDD.n68 17.0005
R193 wind_comp_0.sg13g2_and2_2$1_0.VDD.n222 wind_comp_0.sg13g2_and2_2$1_0.VDD.n68 17.0005
R194 wind_comp_0.sg13g2_and2_2$1_0.VDD.n220 wind_comp_0.sg13g2_and2_2$1_0.VDD.n68 17.0005
R195 wind_comp_0.sg13g2_and2_2$1_0.VDD.n218 wind_comp_0.sg13g2_and2_2$1_0.VDD.n68 17.0005
R196 wind_comp_0.sg13g2_and2_2$1_0.VDD.n216 wind_comp_0.sg13g2_and2_2$1_0.VDD.n68 17.0005
R197 wind_comp_0.sg13g2_and2_2$1_0.VDD.n214 wind_comp_0.sg13g2_and2_2$1_0.VDD.n68 17.0005
R198 wind_comp_0.sg13g2_and2_2$1_0.VDD.n212 wind_comp_0.sg13g2_and2_2$1_0.VDD.n68 17.0005
R199 wind_comp_0.sg13g2_and2_2$1_0.VDD.n210 wind_comp_0.sg13g2_and2_2$1_0.VDD.n68 17.0005
R200 wind_comp_0.sg13g2_and2_2$1_0.VDD.n208 wind_comp_0.sg13g2_and2_2$1_0.VDD.n68 17.0005
R201 wind_comp_0.sg13g2_and2_2$1_0.VDD.n204 wind_comp_0.sg13g2_and2_2$1_0.VDD.n68 17.0005
R202 wind_comp_0.sg13g2_and2_2$1_0.VDD.n202 wind_comp_0.sg13g2_and2_2$1_0.VDD.n68 17.0005
R203 wind_comp_0.sg13g2_and2_2$1_0.VDD.n200 wind_comp_0.sg13g2_and2_2$1_0.VDD.n68 17.0005
R204 wind_comp_0.sg13g2_and2_2$1_0.VDD.n198 wind_comp_0.sg13g2_and2_2$1_0.VDD.n68 17.0005
R205 wind_comp_0.sg13g2_and2_2$1_0.VDD.n199 wind_comp_0.sg13g2_and2_2$1_0.VDD.n71 17.0005
R206 wind_comp_0.sg13g2_and2_2$1_0.VDD.n201 wind_comp_0.sg13g2_and2_2$1_0.VDD.n71 17.0005
R207 wind_comp_0.sg13g2_and2_2$1_0.VDD.n203 wind_comp_0.sg13g2_and2_2$1_0.VDD.n71 17.0005
R208 wind_comp_0.sg13g2_and2_2$1_0.VDD.n207 wind_comp_0.sg13g2_and2_2$1_0.VDD.n71 17.0005
R209 wind_comp_0.sg13g2_and2_2$1_0.VDD.n209 wind_comp_0.sg13g2_and2_2$1_0.VDD.n71 17.0005
R210 wind_comp_0.sg13g2_and2_2$1_0.VDD.n211 wind_comp_0.sg13g2_and2_2$1_0.VDD.n71 17.0005
R211 wind_comp_0.sg13g2_and2_2$1_0.VDD.n213 wind_comp_0.sg13g2_and2_2$1_0.VDD.n71 17.0005
R212 wind_comp_0.sg13g2_and2_2$1_0.VDD.n215 wind_comp_0.sg13g2_and2_2$1_0.VDD.n71 17.0005
R213 wind_comp_0.sg13g2_and2_2$1_0.VDD.n217 wind_comp_0.sg13g2_and2_2$1_0.VDD.n71 17.0005
R214 wind_comp_0.sg13g2_and2_2$1_0.VDD.n219 wind_comp_0.sg13g2_and2_2$1_0.VDD.n71 17.0005
R215 wind_comp_0.sg13g2_and2_2$1_0.VDD.n221 wind_comp_0.sg13g2_and2_2$1_0.VDD.n71 17.0005
R216 wind_comp_0.sg13g2_and2_2$1_0.VDD.n223 wind_comp_0.sg13g2_and2_2$1_0.VDD.n71 17.0005
R217 wind_comp_0.sg13g2_and2_2$1_0.VDD.n225 wind_comp_0.sg13g2_and2_2$1_0.VDD.n71 17.0005
R218 wind_comp_0.sg13g2_and2_2$1_0.VDD.n229 wind_comp_0.sg13g2_and2_2$1_0.VDD.n71 17.0005
R219 wind_comp_0.sg13g2_and2_2$1_0.VDD.n705 wind_comp_0.sg13g2_and2_2$1_0.VDD.n34 17.0005
R220 wind_comp_0.sg13g2_and2_2$1_0.VDD.n109 wind_comp_0.sg13g2_and2_2$1_0.VDD.t128 17.0005
R221 wind_comp_0.sg13g2_and2_2$1_0.VDD.n117 wind_comp_0.sg13g2_and2_2$1_0.VDD.t131 17.0005
R222 wind_comp_0.sg13g2_and2_2$1_0.VDD.n678 wind_comp_0.sg13g2_and2_2$1_0.VDD.t116 17.0005
R223 wind_comp_0.sg13g2_and2_2$1_0.VDD.n680 wind_comp_0.sg13g2_and2_2$1_0.VDD.t107 17.0005
R224 wind_comp_0.sg13g2_and2_2$1_0.VDD.n79 wind_comp_0.sg13g2_and2_2$1_0.VDD.t123 17.0005
R225 wind_comp_0.sg13g2_and2_2$1_0.VDD.n77 wind_comp_0.sg13g2_and2_2$1_0.VDD.t122 17.0005
R226 wind_comp_0.sg13g2_and2_2$1_0.VDD.n98 wind_comp_0.sg13g2_and2_2$1_0.VDD.t110 17.0005
R227 wind_comp_0.sg13g2_and2_2$1_0.VDD.n92 wind_comp_0.sg13g2_and2_2$1_0.VDD.t109 17.0005
R228 wind_comp_0.sg13g2_and2_2$1_0.VDD.n115 wind_comp_0.sg13g2_and2_2$1_0.VDD.t130 17.0005
R229 wind_comp_0.sg13g2_and2_2$1_0.VDD.n105 wind_comp_0.sg13g2_and2_2$1_0.VDD.t114 17.0005
R230 wind_comp_0.sg13g2_and2_2$1_0.VDD.n83 wind_comp_0.sg13g2_and2_2$1_0.VDD.t120 17.0005
R231 wind_comp_0.sg13g2_and2_2$1_0.VDD.n85 wind_comp_0.sg13g2_and2_2$1_0.VDD.t118 17.0005
R232 wind_comp_0.sg13g2_and2_2$1_0.VDD.n614 wind_comp_0.sg13g2_and2_2$1_0.VDD.t142 17.0005
R233 wind_comp_0.sg13g2_and2_2$1_0.VDD.n616 wind_comp_0.sg13g2_and2_2$1_0.VDD.t143 17.0005
R234 wind_comp_0.sg13g2_and2_2$1_0.VDD.n170 wind_comp_0.sg13g2_and2_2$1_0.VDD.t151 17.0005
R235 wind_comp_0.sg13g2_and2_2$1_0.VDD.n168 wind_comp_0.sg13g2_and2_2$1_0.VDD.t152 17.0005
R236 wind_comp_0.sg13g2_and2_2$1_0.VDD.n189 wind_comp_0.sg13g2_and2_2$1_0.VDD.t105 17.0005
R237 wind_comp_0.sg13g2_and2_2$1_0.VDD.n187 wind_comp_0.sg13g2_and2_2$1_0.VDD.t163 17.0005
R238 wind_comp_0.sg13g2_and2_2$1_0.VDD.n180 wind_comp_0.sg13g2_and2_2$1_0.VDD.t149 17.0005
R239 wind_comp_0.sg13g2_and2_2$1_0.VDD.n182 wind_comp_0.sg13g2_and2_2$1_0.VDD.t147 17.0005
R240 wind_comp_0.sg13g2_and2_2$1_0.VDD.n154 wind_comp_0.sg13g2_and2_2$1_0.VDD.n153 16.922
R241 wind_comp_0.sg13g2_and2_2$1_0.VDD.n671 wind_comp_0.sg13g2_and2_2$1_0.VDD.t190 15.1867
R242 wind_comp_0.sg13g2_and2_2$1_0.VDD.t113 wind_comp_0.sg13g2_and2_2$1_0.VDD.n104 15.1867
R243 wind_comp_0.sg13g2_and2_2$1_0.VDD.t159 wind_comp_0.sg13g2_and2_2$1_0.VDD.n242 15.1618
R244 wind_comp_0.sg13g2_and2_2$1_0.VDD.t172 wind_comp_0.sg13g2_and2_2$1_0.VDD.n235 15.1618
R245 wind_comp_0.sg13g2_and2_2$1_0.VDD.n237 wind_comp_0.sg13g2_and2_2$1_0.VDD.t172 15.1618
R246 wind_comp_0.sg13g2_and2_2$1_0.VDD.n244 wind_comp_0.sg13g2_and2_2$1_0.VDD.t159 15.1618
R247 wind_comp_0.sg13g2_and2_2$1_0.VDD.n448 wind_comp_0.sg13g2_and2_2$1_0.VDD.t201 15.1618
R248 wind_comp_0.sg13g2_and2_2$1_0.VDD.t201 wind_comp_0.sg13g2_and2_2$1_0.VDD.n355 15.1618
R249 wind_comp_0.sg13g2_and2_2$1_0.VDD.n359 wind_comp_0.sg13g2_and2_2$1_0.VDD.t226 15.1618
R250 wind_comp_0.sg13g2_and2_2$1_0.VDD.t226 wind_comp_0.sg13g2_and2_2$1_0.VDD.n357 15.1618
R251 wind_comp_0.sg13g2_and2_2$1_0.VDD.t217 wind_comp_0.sg13g2_and2_2$1_0.VDD.n346 15.1618
R252 wind_comp_0.sg13g2_and2_2$1_0.VDD.n348 wind_comp_0.sg13g2_and2_2$1_0.VDD.t217 15.1618
R253 wind_comp_0.sg13g2_and2_2$1_0.VDD.n399 wind_comp_0.sg13g2_and2_2$1_0.VDD.t210 15.1618
R254 wind_comp_0.sg13g2_and2_2$1_0.VDD.t210 wind_comp_0.sg13g2_and2_2$1_0.VDD.n397 15.1618
R255 wind_comp_0.sg13g2_and2_2$1_0.VDD.t155 wind_comp_0.sg13g2_and2_2$1_0.VDD.n391 15.1618
R256 wind_comp_0.sg13g2_and2_2$1_0.VDD.n393 wind_comp_0.sg13g2_and2_2$1_0.VDD.t155 15.1618
R257 wind_comp_0.sg13g2_and2_2$1_0.VDD.n435 wind_comp_0.sg13g2_and2_2$1_0.VDD.t228 15.1618
R258 wind_comp_0.sg13g2_and2_2$1_0.VDD.t228 wind_comp_0.sg13g2_and2_2$1_0.VDD.n434 15.1618
R259 wind_comp_0.sg13g2_and2_2$1_0.VDD.t219 wind_comp_0.sg13g2_and2_2$1_0.VDD.n377 15.1618
R260 wind_comp_0.sg13g2_and2_2$1_0.VDD.n424 wind_comp_0.sg13g2_and2_2$1_0.VDD.t219 15.1618
R261 wind_comp_0.sg13g2_and2_2$1_0.VDD.t208 wind_comp_0.sg13g2_and2_2$1_0.VDD.n380 15.1618
R262 wind_comp_0.sg13g2_and2_2$1_0.VDD.n384 wind_comp_0.sg13g2_and2_2$1_0.VDD.t208 15.1618
R263 wind_comp_0.sg13g2_and2_2$1_0.VDD.n326 wind_comp_0.sg13g2_and2_2$1_0.VDD.t199 15.1618
R264 wind_comp_0.sg13g2_and2_2$1_0.VDD.t199 wind_comp_0.sg13g2_and2_2$1_0.VDD.n324 15.1618
R265 wind_comp_0.sg13g2_and2_2$1_0.VDD.n335 wind_comp_0.sg13g2_and2_2$1_0.VDD.t182 15.1618
R266 wind_comp_0.sg13g2_and2_2$1_0.VDD.t182 wind_comp_0.sg13g2_and2_2$1_0.VDD.n333 15.1618
R267 wind_comp_0.sg13g2_and2_2$1_0.VDD.t174 wind_comp_0.sg13g2_and2_2$1_0.VDD.n514 15.1618
R268 wind_comp_0.sg13g2_and2_2$1_0.VDD.t157 wind_comp_0.sg13g2_and2_2$1_0.VDD.n507 15.1618
R269 wind_comp_0.sg13g2_and2_2$1_0.VDD.n509 wind_comp_0.sg13g2_and2_2$1_0.VDD.t157 15.1618
R270 wind_comp_0.sg13g2_and2_2$1_0.VDD.n516 wind_comp_0.sg13g2_and2_2$1_0.VDD.t174 15.1618
R271 wind_comp_0.sg13g2_and2_2$1_0.VDD.t144 wind_comp_0.sg13g2_and2_2$1_0.VDD.n615 15.1618
R272 wind_comp_0.sg13g2_and2_2$1_0.VDD.t153 wind_comp_0.sg13g2_and2_2$1_0.VDD.n169 15.1618
R273 wind_comp_0.sg13g2_and2_2$1_0.VDD.n171 wind_comp_0.sg13g2_and2_2$1_0.VDD.t153 15.1618
R274 wind_comp_0.sg13g2_and2_2$1_0.VDD.n617 wind_comp_0.sg13g2_and2_2$1_0.VDD.t144 15.1618
R275 wind_comp_0.sg13g2_and2_2$1_0.VDD.t190 wind_comp_0.sg13g2_and2_2$1_0.VDD.n669 15.1618
R276 wind_comp_0.sg13g2_and2_2$1_0.VDD.n137 wind_comp_0.sg13g2_and2_2$1_0.VDD.t137 15.1618
R277 wind_comp_0.sg13g2_and2_2$1_0.VDD.t137 wind_comp_0.sg13g2_and2_2$1_0.VDD.n135 15.1618
R278 wind_comp_0.sg13g2_and2_2$1_0.VDD.n106 wind_comp_0.sg13g2_and2_2$1_0.VDD.t113 15.1618
R279 wind_comp_0.sg13g2_and2_2$1_0.VDD.n118 wind_comp_0.sg13g2_and2_2$1_0.VDD.t132 15.1618
R280 wind_comp_0.sg13g2_and2_2$1_0.VDD.t132 wind_comp_0.sg13g2_and2_2$1_0.VDD.n116 15.1618
R281 wind_comp_0.sg13g2_and2_2$1_0.VDD.t106 wind_comp_0.sg13g2_and2_2$1_0.VDD.n679 15.1618
R282 wind_comp_0.sg13g2_and2_2$1_0.VDD.n681 wind_comp_0.sg13g2_and2_2$1_0.VDD.t106 15.1618
R283 wind_comp_0.sg13g2_and2_2$1_0.VDD.n80 wind_comp_0.sg13g2_and2_2$1_0.VDD.t124 15.1618
R284 wind_comp_0.sg13g2_and2_2$1_0.VDD.t124 wind_comp_0.sg13g2_and2_2$1_0.VDD.n78 15.1618
R285 wind_comp_0.sg13g2_and2_2$1_0.VDD.n94 wind_comp_0.sg13g2_and2_2$1_0.VDD.t111 15.1618
R286 wind_comp_0.sg13g2_and2_2$1_0.VDD.t111 wind_comp_0.sg13g2_and2_2$1_0.VDD.n93 15.1618
R287 wind_comp_0.sg13g2_and2_2$1_0.VDD.t102 wind_comp_0.sg13g2_and2_2$1_0.VDD.n134 15.1618
R288 wind_comp_0.sg13g2_and2_2$1_0.VDD.n147 wind_comp_0.sg13g2_and2_2$1_0.VDD.t102 15.1618
R289 wind_comp_0.sg13g2_and2_2$1_0.VDD.t117 wind_comp_0.sg13g2_and2_2$1_0.VDD.n84 15.1618
R290 wind_comp_0.sg13g2_and2_2$1_0.VDD.n86 wind_comp_0.sg13g2_and2_2$1_0.VDD.t117 15.1618
R291 wind_comp_0.sg13g2_and2_2$1_0.VDD.t192 wind_comp_0.sg13g2_and2_2$1_0.VDD.n128 15.1618
R292 wind_comp_0.sg13g2_and2_2$1_0.VDD.n660 wind_comp_0.sg13g2_and2_2$1_0.VDD.t192 15.1618
R293 wind_comp_0.sg13g2_and2_2$1_0.VDD.t104 wind_comp_0.sg13g2_and2_2$1_0.VDD.n188 15.1618
R294 wind_comp_0.sg13g2_and2_2$1_0.VDD.t146 wind_comp_0.sg13g2_and2_2$1_0.VDD.n181 15.1618
R295 wind_comp_0.sg13g2_and2_2$1_0.VDD.n183 wind_comp_0.sg13g2_and2_2$1_0.VDD.t146 15.1618
R296 wind_comp_0.sg13g2_and2_2$1_0.VDD.n190 wind_comp_0.sg13g2_and2_2$1_0.VDD.t104 15.1618
R297 wind_comp_0.sg13g2_and2_2$1_0.VDD.n246 wind_comp_0.sg13g2_and2_2$1_0.VDD.t164 15.0005
R298 wind_comp_0.sg13g2_and2_2$1_0.VDD.n239 wind_comp_0.sg13g2_and2_2$1_0.VDD.t169 15.0005
R299 wind_comp_0.sg13g2_and2_2$1_0.VDD.t169 wind_comp_0.sg13g2_and2_2$1_0.VDD.n238 15.0005
R300 wind_comp_0.sg13g2_and2_2$1_0.VDD.t164 wind_comp_0.sg13g2_and2_2$1_0.VDD.n245 15.0005
R301 wind_comp_0.sg13g2_and2_2$1_0.VDD.t203 wind_comp_0.sg13g2_and2_2$1_0.VDD.n449 15.0005
R302 wind_comp_0.sg13g2_and2_2$1_0.VDD.n450 wind_comp_0.sg13g2_and2_2$1_0.VDD.t203 15.0005
R303 wind_comp_0.sg13g2_and2_2$1_0.VDD.t223 wind_comp_0.sg13g2_and2_2$1_0.VDD.n360 15.0005
R304 wind_comp_0.sg13g2_and2_2$1_0.VDD.n361 wind_comp_0.sg13g2_and2_2$1_0.VDD.t223 15.0005
R305 wind_comp_0.sg13g2_and2_2$1_0.VDD.n350 wind_comp_0.sg13g2_and2_2$1_0.VDD.t214 15.0005
R306 wind_comp_0.sg13g2_and2_2$1_0.VDD.t214 wind_comp_0.sg13g2_and2_2$1_0.VDD.n349 15.0005
R307 wind_comp_0.sg13g2_and2_2$1_0.VDD.t205 wind_comp_0.sg13g2_and2_2$1_0.VDD.n400 15.0005
R308 wind_comp_0.sg13g2_and2_2$1_0.VDD.n401 wind_comp_0.sg13g2_and2_2$1_0.VDD.t205 15.0005
R309 wind_comp_0.sg13g2_and2_2$1_0.VDD.n395 wind_comp_0.sg13g2_and2_2$1_0.VDD.t184 15.0005
R310 wind_comp_0.sg13g2_and2_2$1_0.VDD.t184 wind_comp_0.sg13g2_and2_2$1_0.VDD.n394 15.0005
R311 wind_comp_0.sg13g2_and2_2$1_0.VDD.n436 wind_comp_0.sg13g2_and2_2$1_0.VDD.t230 15.0005
R312 wind_comp_0.sg13g2_and2_2$1_0.VDD.t230 wind_comp_0.sg13g2_and2_2$1_0.VDD.n374 15.0005
R313 wind_comp_0.sg13g2_and2_2$1_0.VDD.n426 wind_comp_0.sg13g2_and2_2$1_0.VDD.t221 15.0005
R314 wind_comp_0.sg13g2_and2_2$1_0.VDD.t221 wind_comp_0.sg13g2_and2_2$1_0.VDD.n425 15.0005
R315 wind_comp_0.sg13g2_and2_2$1_0.VDD.n386 wind_comp_0.sg13g2_and2_2$1_0.VDD.t212 15.0005
R316 wind_comp_0.sg13g2_and2_2$1_0.VDD.t212 wind_comp_0.sg13g2_and2_2$1_0.VDD.n385 15.0005
R317 wind_comp_0.sg13g2_and2_2$1_0.VDD.t196 wind_comp_0.sg13g2_and2_2$1_0.VDD.n327 15.0005
R318 wind_comp_0.sg13g2_and2_2$1_0.VDD.n328 wind_comp_0.sg13g2_and2_2$1_0.VDD.t196 15.0005
R319 wind_comp_0.sg13g2_and2_2$1_0.VDD.t179 wind_comp_0.sg13g2_and2_2$1_0.VDD.n336 15.0005
R320 wind_comp_0.sg13g2_and2_2$1_0.VDD.n337 wind_comp_0.sg13g2_and2_2$1_0.VDD.t179 15.0005
R321 wind_comp_0.sg13g2_and2_2$1_0.VDD.n518 wind_comp_0.sg13g2_and2_2$1_0.VDD.t176 15.0005
R322 wind_comp_0.sg13g2_and2_2$1_0.VDD.n511 wind_comp_0.sg13g2_and2_2$1_0.VDD.t166 15.0005
R323 wind_comp_0.sg13g2_and2_2$1_0.VDD.t166 wind_comp_0.sg13g2_and2_2$1_0.VDD.n510 15.0005
R324 wind_comp_0.sg13g2_and2_2$1_0.VDD.t176 wind_comp_0.sg13g2_and2_2$1_0.VDD.n517 15.0005
R325 wind_comp_0.sg13g2_and2_2$1_0.VDD.n619 wind_comp_0.sg13g2_and2_2$1_0.VDD.t141 15.0005
R326 wind_comp_0.sg13g2_and2_2$1_0.VDD.n173 wind_comp_0.sg13g2_and2_2$1_0.VDD.t150 15.0005
R327 wind_comp_0.sg13g2_and2_2$1_0.VDD.t150 wind_comp_0.sg13g2_and2_2$1_0.VDD.n172 15.0005
R328 wind_comp_0.sg13g2_and2_2$1_0.VDD.t141 wind_comp_0.sg13g2_and2_2$1_0.VDD.n618 15.0005
R329 wind_comp_0.sg13g2_and2_2$1_0.VDD.n674 wind_comp_0.sg13g2_and2_2$1_0.VDD.t187 15.0005
R330 wind_comp_0.sg13g2_and2_2$1_0.VDD.t187 wind_comp_0.sg13g2_and2_2$1_0.VDD.n673 15.0005
R331 wind_comp_0.sg13g2_and2_2$1_0.VDD.t134 wind_comp_0.sg13g2_and2_2$1_0.VDD.n138 15.0005
R332 wind_comp_0.sg13g2_and2_2$1_0.VDD.n139 wind_comp_0.sg13g2_and2_2$1_0.VDD.t134 15.0005
R333 wind_comp_0.sg13g2_and2_2$1_0.VDD.t126 wind_comp_0.sg13g2_and2_2$1_0.VDD.n107 15.0005
R334 wind_comp_0.sg13g2_and2_2$1_0.VDD.n108 wind_comp_0.sg13g2_and2_2$1_0.VDD.t126 15.0005
R335 wind_comp_0.sg13g2_and2_2$1_0.VDD.t129 wind_comp_0.sg13g2_and2_2$1_0.VDD.n121 15.0005
R336 wind_comp_0.sg13g2_and2_2$1_0.VDD.n122 wind_comp_0.sg13g2_and2_2$1_0.VDD.t129 15.0005
R337 wind_comp_0.sg13g2_and2_2$1_0.VDD.n683 wind_comp_0.sg13g2_and2_2$1_0.VDD.t115 15.0005
R338 wind_comp_0.sg13g2_and2_2$1_0.VDD.t115 wind_comp_0.sg13g2_and2_2$1_0.VDD.n682 15.0005
R339 wind_comp_0.sg13g2_and2_2$1_0.VDD.t121 wind_comp_0.sg13g2_and2_2$1_0.VDD.n699 15.0005
R340 wind_comp_0.sg13g2_and2_2$1_0.VDD.n700 wind_comp_0.sg13g2_and2_2$1_0.VDD.t121 15.0005
R341 wind_comp_0.sg13g2_and2_2$1_0.VDD.n95 wind_comp_0.sg13g2_and2_2$1_0.VDD.t108 15.0005
R342 wind_comp_0.sg13g2_and2_2$1_0.VDD.t108 wind_comp_0.sg13g2_and2_2$1_0.VDD.n91 15.0005
R343 wind_comp_0.sg13g2_and2_2$1_0.VDD.n149 wind_comp_0.sg13g2_and2_2$1_0.VDD.t139 15.0005
R344 wind_comp_0.sg13g2_and2_2$1_0.VDD.t139 wind_comp_0.sg13g2_and2_2$1_0.VDD.n148 15.0005
R345 wind_comp_0.sg13g2_and2_2$1_0.VDD.n88 wind_comp_0.sg13g2_and2_2$1_0.VDD.t119 15.0005
R346 wind_comp_0.sg13g2_and2_2$1_0.VDD.t119 wind_comp_0.sg13g2_and2_2$1_0.VDD.n87 15.0005
R347 wind_comp_0.sg13g2_and2_2$1_0.VDD.n662 wind_comp_0.sg13g2_and2_2$1_0.VDD.t194 15.0005
R348 wind_comp_0.sg13g2_and2_2$1_0.VDD.t194 wind_comp_0.sg13g2_and2_2$1_0.VDD.n661 15.0005
R349 wind_comp_0.sg13g2_and2_2$1_0.VDD.n192 wind_comp_0.sg13g2_and2_2$1_0.VDD.t161 15.0005
R350 wind_comp_0.sg13g2_and2_2$1_0.VDD.n185 wind_comp_0.sg13g2_and2_2$1_0.VDD.t148 15.0005
R351 wind_comp_0.sg13g2_and2_2$1_0.VDD.t148 wind_comp_0.sg13g2_and2_2$1_0.VDD.n184 15.0005
R352 wind_comp_0.sg13g2_and2_2$1_0.VDD.t161 wind_comp_0.sg13g2_and2_2$1_0.VDD.n191 15.0005
R353 wind_comp_0.sg13g2_and2_2$1_0.VDD.n153 wind_comp_0.sg13g2_and2_2$1_0.VDD.n111 13.2005
R354 wind_comp_0.sg13g2_and2_2$1_0.VDD.n473 wind_comp_0.sg13g2_and2_2$1_0.VDD.n21 10.7618
R355 wind_comp_0.sg13g2_and2_2$1_0.VDD.n474 wind_comp_0.sg13g2_and2_2$1_0.VDD.n473 10.7618
R356 wind_comp_0.sg13g2_and2_2$1_0.VDD.n690 wind_comp_0.sg13g2_and2_2$1_0.VDD.n687 10.7618
R357 wind_comp_0.sg13g2_and2_2$1_0.VDD.n691 wind_comp_0.sg13g2_and2_2$1_0.VDD.n690 10.7618
R358 wind_comp_0.sg13g2_and2_2$1_0.VDD.n342 wind_comp_0.comparator_1.dynamic_pcell$2_0.SRC_NET_KL 9.24864
R359 wind_comp_0.sg13g2_and2_2$1_0.VDD.n688 wind_comp_0.comparator_0.dynamic_pcell$2_0.SRC_NET_KL 9.24864
R360 wind_comp_0.sg13g2_and2_2$1_0.VDD.n524 wind_comp_0.sg13g2_and2_2$1_0.VDD.n527 9.0005
R361 wind_comp_0.sg13g2_and2_2$1_0.VDD.n530 wind_comp_0.sg13g2_and2_2$1_0.VDD.n529 9.0005
R362 wind_comp_0.sg13g2_and2_2$1_0.VDD.n473 wind_comp_0.comparator_1.dynamic_pcell$2_0.SRC_NET_KL 9.0005
R363 wind_comp_0.sg13g2_and2_2$1_0.VDD.n612 wind_comp_0.sg13g2_and2_2$1_0.VDD.n611 9.0005
R364 wind_comp_0.sg13g2_and2_2$1_0.VDD.n176 wind_comp_0.sg13g2_and2_2$1_0.VDD.n609 9.0005
R365 wind_comp_0.sg13g2_and2_2$1_0.VDD.n690 wind_comp_0.comparator_0.dynamic_pcell$2_0.SRC_NET_KL 9.0005
R366 wind_comp_0.sg13g2_and2_2$1_0.VDD.n3 wind_comp_0.sg13g2_and2_2$1_0.VDD.n0 5.65629
R367 wind_comp_0.sg13g2_and2_2$1_0.VDD.n58 wind_comp_0.sg13g2_and2_2$1_0.VDD.t73 8.76054
R368 wind_comp_0.sg13g2_and2_2$1_0.VDD.n54 wind_comp_0.sg13g2_and2_2$1_0.VDD.t71 8.76054
R369 wind_comp_0.sg13g2_and2_2$1_0.VDD.n52 wind_comp_0.sg13g2_and2_2$1_0.VDD.t69 8.76054
R370 wind_comp_0.sg13g2_and2_2$1_0.VDD.n50 wind_comp_0.sg13g2_and2_2$1_0.VDD.t67 8.76054
R371 wind_comp_0.sg13g2_and2_2$1_0.VDD.n48 wind_comp_0.sg13g2_and2_2$1_0.VDD.t65 8.76054
R372 wind_comp_0.sg13g2_and2_2$1_0.VDD.n46 wind_comp_0.sg13g2_and2_2$1_0.VDD.t63 8.76054
R373 wind_comp_0.sg13g2_and2_2$1_0.VDD.n231 wind_comp_0.sg13g2_and2_2$1_0.VDD.t52 8.76054
R374 wind_comp_0.sg13g2_and2_2$1_0.VDD.n4 wind_comp_0.sg13g2_and2_2$1_0.VDD.t5 8.76054
R375 wind_comp_0.sg13g2_and2_2$1_0.VDD.n6 wind_comp_0.sg13g2_and2_2$1_0.VDD.t47 8.76054
R376 wind_comp_0.sg13g2_and2_2$1_0.VDD.n302 wind_comp_0.sg13g2_and2_2$1_0.VDD.t45 8.76054
R377 wind_comp_0.sg13g2_and2_2$1_0.VDD.n308 wind_comp_0.sg13g2_and2_2$1_0.VDD.t43 8.76054
R378 wind_comp_0.sg13g2_and2_2$1_0.VDD.n313 wind_comp_0.sg13g2_and2_2$1_0.VDD.t41 8.76054
R379 wind_comp_0.sg13g2_and2_2$1_0.VDD.n318 wind_comp_0.sg13g2_and2_2$1_0.VDD.t39 8.76054
R380 wind_comp_0.sg13g2_and2_2$1_0.VDD.n576 wind_comp_0.sg13g2_and2_2$1_0.VDD.t87 8.76054
R381 wind_comp_0.sg13g2_and2_2$1_0.VDD.n578 wind_comp_0.sg13g2_and2_2$1_0.VDD.t85 8.76054
R382 wind_comp_0.sg13g2_and2_2$1_0.VDD.n580 wind_comp_0.sg13g2_and2_2$1_0.VDD.t83 8.76054
R383 wind_comp_0.sg13g2_and2_2$1_0.VDD.n582 wind_comp_0.sg13g2_and2_2$1_0.VDD.t81 8.76054
R384 wind_comp_0.sg13g2_and2_2$1_0.VDD.n584 wind_comp_0.sg13g2_and2_2$1_0.VDD.t79 8.76054
R385 wind_comp_0.sg13g2_and2_2$1_0.VDD.n588 wind_comp_0.sg13g2_and2_2$1_0.VDD.t77 8.76054
R386 wind_comp_0.sg13g2_and2_2$1_0.VDD.n27 wind_comp_0.sg13g2_and2_2$1_0.VDD.t23 8.76054
R387 wind_comp_0.sg13g2_and2_2$1_0.VDD.n40 wind_comp_0.sg13g2_and2_2$1_0.VDD.t21 8.76054
R388 wind_comp_0.sg13g2_and2_2$1_0.VDD.n38 wind_comp_0.sg13g2_and2_2$1_0.VDD.t19 8.76054
R389 wind_comp_0.sg13g2_and2_2$1_0.VDD.n36 wind_comp_0.sg13g2_and2_2$1_0.VDD.t17 8.76054
R390 wind_comp_0.sg13g2_and2_2$1_0.VDD.n33 wind_comp_0.sg13g2_and2_2$1_0.VDD.t15 8.76054
R391 wind_comp_0.sg13g2_and2_2$1_0.VDD.n29 wind_comp_0.sg13g2_and2_2$1_0.VDD.t13 8.76054
R392 wind_comp_0.sg13g2_and2_2$1_0.VDD.n43 wind_comp_0.sg13g2_and2_2$1_0.VDD.t61 8.75843
R393 wind_comp_0.sg13g2_and2_2$1_0.VDD.n573 wind_comp_0.sg13g2_and2_2$1_0.VDD.t89 8.75843
R394 wind_comp_0.sg13g2_and2_2$1_0.VDD.n565 wind_comp_0.sg13g2_and2_2$1_0.VDD.t37 8.5651
R395 wind_comp_0.sg13g2_and2_2$1_0.VDD.n686 wind_comp_0.sg13g2_and2_2$1_0.VDD.n0 8.50186
R396 wind_comp_0.sg13g2_and2_2$1_0.VDD.n600 wind_comp_0.sg13g2_and2_2$1_0.VDD.n230 8.50005
R397 wind_comp_0.sg13g2_and2_2$1_0.VDD.n600 wind_comp_0.sg13g2_and2_2$1_0.VDD.n5 5.66608
R398 wind_comp_0.sg13g2_and2_2$1_0.VDD.n407 wind_comp_0.sg13g2_and2_2$1_0.VDD.n17 8.49916
R399 wind_comp_0.sg13g2_and2_2$1_0.VDD.n371 wind_comp_0.sg13g2_and2_2$1_0.VDD.n17 8.49916
R400 wind_comp_0.sg13g2_and2_2$1_0.VDD.n475 wind_comp_0.sg13g2_and2_2$1_0.VDD.n13 8.49916
R401 wind_comp_0.sg13g2_and2_2$1_0.VDD.n406 wind_comp_0.sg13g2_and2_2$1_0.VDD.n13 8.49916
R402 wind_comp_0.sg13g2_and2_2$1_0.VDD.n596 wind_comp_0.sg13g2_and2_2$1_0.VDD.n283 8.49831
R403 wind_comp_0.sg13g2_and2_2$1_0.VDD.n596 wind_comp_0.sg13g2_and2_2$1_0.VDD.n284 8.49831
R404 wind_comp_0.sg13g2_and2_2$1_0.VDD.n602 wind_comp_0.sg13g2_and2_2$1_0.VDD.n71 8.49831
R405 wind_comp_0.sg13g2_and2_2$1_0.VDD.n71 wind_comp_0.sg13g2_and2_2$1_0.VDD.n69 8.49831
R406 wind_comp_0.sg13g2_and2_2$1_0.VDD.n295 wind_comp_0.sg13g2_and2_2$1_0.VDD.n17 8.49512
R407 wind_comp_0.sg13g2_and2_2$1_0.VDD.n304 wind_comp_0.sg13g2_and2_2$1_0.VDD.n17 8.49512
R408 wind_comp_0.sg13g2_and2_2$1_0.VDD.n309 wind_comp_0.sg13g2_and2_2$1_0.VDD.n17 8.49512
R409 wind_comp_0.sg13g2_and2_2$1_0.VDD.n316 wind_comp_0.sg13g2_and2_2$1_0.VDD.n17 8.49512
R410 wind_comp_0.sg13g2_and2_2$1_0.VDD.n321 wind_comp_0.sg13g2_and2_2$1_0.VDD.n17 8.49512
R411 wind_comp_0.sg13g2_and2_2$1_0.VDD.n596 wind_comp_0.sg13g2_and2_2$1_0.VDD.n280 8.49381
R412 wind_comp_0.sg13g2_and2_2$1_0.VDD.n596 wind_comp_0.sg13g2_and2_2$1_0.VDD.n258 8.49381
R413 wind_comp_0.sg13g2_and2_2$1_0.VDD.n259 wind_comp_0.sg13g2_and2_2$1_0.VDD.n249 8.49381
R414 wind_comp_0.sg13g2_and2_2$1_0.VDD.n279 wind_comp_0.sg13g2_and2_2$1_0.VDD.n249 8.49381
R415 wind_comp_0.sg13g2_and2_2$1_0.VDD.n281 wind_comp_0.sg13g2_and2_2$1_0.VDD.n249 8.49381
R416 wind_comp_0.sg13g2_and2_2$1_0.VDD.n228 wind_comp_0.sg13g2_and2_2$1_0.VDD.n68 8.49381
R417 wind_comp_0.sg13g2_and2_2$1_0.VDD.n226 wind_comp_0.sg13g2_and2_2$1_0.VDD.n68 8.49381
R418 wind_comp_0.sg13g2_and2_2$1_0.VDD.n206 wind_comp_0.sg13g2_and2_2$1_0.VDD.n68 8.49381
R419 wind_comp_0.sg13g2_and2_2$1_0.VDD.n205 wind_comp_0.sg13g2_and2_2$1_0.VDD.n71 8.49381
R420 wind_comp_0.sg13g2_and2_2$1_0.VDD.n227 wind_comp_0.sg13g2_and2_2$1_0.VDD.n71 8.49381
R421 wind_comp_0.sg13g2_and2_2$1_0.VDD.n705 wind_comp_0.sg13g2_and2_2$1_0.VDD.n41 8.49078
R422 wind_comp_0.sg13g2_and2_2$1_0.VDD.n705 wind_comp_0.sg13g2_and2_2$1_0.VDD.n39 8.49078
R423 wind_comp_0.sg13g2_and2_2$1_0.VDD.n705 wind_comp_0.sg13g2_and2_2$1_0.VDD.n37 8.49078
R424 wind_comp_0.sg13g2_and2_2$1_0.VDD.n705 wind_comp_0.sg13g2_and2_2$1_0.VDD.n35 8.49078
R425 wind_comp_0.sg13g2_and2_2$1_0.VDD.n705 wind_comp_0.sg13g2_and2_2$1_0.VDD.n28 8.49078
R426 wind_comp_0.sg13g2_and2_2$1_0.VDD.n705 wind_comp_0.sg13g2_and2_2$1_0.VDD.n32 8.49078
R427 wind_comp_0.sg13g2_and2_2$1_0.VDD.n705 wind_comp_0.sg13g2_and2_2$1_0.VDD.n42 8.47144
R428 wind_comp_0.sg13g2_and2_2$1_0.VDD.n595 wind_comp_0.sg13g2_and2_2$1_0.VDD.n572 8.47144
R429 wind_comp_0.sg13g2_and2_2$1_0.VDD.n705 wind_comp_0.sg13g2_and2_2$1_0.VDD.n67 8.47111
R430 wind_comp_0.sg13g2_and2_2$1_0.VDD.n707 wind_comp_0.sg13g2_and2_2$1_0.VDD.n705 8.47111
R431 wind_comp_0.sg13g2_and2_2$1_0.VDD.n705 wind_comp_0.sg13g2_and2_2$1_0.VDD.n59 8.47111
R432 wind_comp_0.sg13g2_and2_2$1_0.VDD.n705 wind_comp_0.sg13g2_and2_2$1_0.VDD.n55 8.47111
R433 wind_comp_0.sg13g2_and2_2$1_0.VDD.n705 wind_comp_0.sg13g2_and2_2$1_0.VDD.n53 8.47111
R434 wind_comp_0.sg13g2_and2_2$1_0.VDD.n705 wind_comp_0.sg13g2_and2_2$1_0.VDD.n51 8.47111
R435 wind_comp_0.sg13g2_and2_2$1_0.VDD.n705 wind_comp_0.sg13g2_and2_2$1_0.VDD.n47 8.47111
R436 wind_comp_0.sg13g2_and2_2$1_0.VDD.n705 wind_comp_0.sg13g2_and2_2$1_0.VDD.n45 8.47111
R437 wind_comp_0.sg13g2_and2_2$1_0.VDD.n595 wind_comp_0.sg13g2_and2_2$1_0.VDD.n569 8.47111
R438 wind_comp_0.sg13g2_and2_2$1_0.VDD.n595 wind_comp_0.sg13g2_and2_2$1_0.VDD.n567 8.47111
R439 wind_comp_0.sg13g2_and2_2$1_0.VDD.n595 wind_comp_0.sg13g2_and2_2$1_0.VDD.n575 8.47111
R440 wind_comp_0.sg13g2_and2_2$1_0.VDD.n595 wind_comp_0.sg13g2_and2_2$1_0.VDD.n577 8.47111
R441 wind_comp_0.sg13g2_and2_2$1_0.VDD.n595 wind_comp_0.sg13g2_and2_2$1_0.VDD.n581 8.47111
R442 wind_comp_0.sg13g2_and2_2$1_0.VDD.n595 wind_comp_0.sg13g2_and2_2$1_0.VDD.n583 8.47111
R443 wind_comp_0.sg13g2_and2_2$1_0.VDD.n595 wind_comp_0.sg13g2_and2_2$1_0.VDD.n585 8.47111
R444 wind_comp_0.sg13g2_and2_2$1_0.VDD.n595 wind_comp_0.sg13g2_and2_2$1_0.VDD.n589 8.47111
R445 wind_comp_0.sg13g2_and2_2$1_0.VDD.n152 wind_comp_0.sg13g2_and2_2$1_0.VDD.n72 8.46995
R446 wind_comp_0.sg13g2_and2_2$1_0.VDD.n129 wind_comp_0.sg13g2_and2_2$1_0.VDD.n72 8.46995
R447 wind_comp_0.sg13g2_and2_2$1_0.VDD.n706 wind_comp_0.sg13g2_and2_2$1_0.VDD.t25 5.97247
R448 wind_comp_0.sg13g2_and2_2$1_0.VDD.n57 wind_comp_0.sg13g2_and2_2$1_0.VDD.t75 5.97146
R449 wind_comp_0.sg13g2_and2_2$1_0.VDD.n598 wind_comp_0.sg13g2_and2_2$1_0.VDD.t53 5.97146
R450 wind_comp_0.sg13g2_and2_2$1_0.VDD.n568 wind_comp_0.sg13g2_and2_2$1_0.VDD.t36 5.97146
R451 wind_comp_0.sg13g2_and2_2$1_0.VDD.n587 wind_comp_0.sg13g2_and2_2$1_0.VDD.t76 5.97146
R452 wind_comp_0.sg13g2_and2_2$1_0.VDD.n65 wind_comp_0.sg13g2_and2_2$1_0.VDD.t60 5.96935
R453 wind_comp_0.sg13g2_and2_2$1_0.VDD.n571 wind_comp_0.sg13g2_and2_2$1_0.VDD.t91 5.96935
R454 wind_comp_0.sg13g2_and2_2$1_0.VDD.n63 wind_comp_0.sg13g2_and2_2$1_0.VDD.t94 5.96512
R455 wind_comp_0.sg13g2_and2_2$1_0.VDD.n590 wind_comp_0.sg13g2_and2_2$1_0.VDD.t101 5.96512
R456 wind_comp_0.comparator_0.dynamic_pcell_0.VDD wind_comp_0.sg13g2_and2_2$1_0.VDD.n2 0.089858
R457 wind_comp_0.sg13g2_and2_2$1_0.VDD.n2 wind_comp_0.sg13g2_and2_2$1_0.VDD.n0 0.00327148
R458 wind_comp_0.sg13g2_and2_2$1_0.VDD.n705 wind_comp_0.sg13g2_and2_2$1_0.VDD.n30 5.64963
R459 wind_comp_0.sg13g2_and2_2$1_0.VDD.n705 wind_comp_0.sg13g2_and2_2$1_0.VDD.n56 5.61485
R460 wind_comp_0.sg13g2_and2_2$1_0.VDD.n705 wind_comp_0.sg13g2_and2_2$1_0.VDD.n49 5.61485
R461 wind_comp_0.sg13g2_and2_2$1_0.VDD.n595 wind_comp_0.sg13g2_and2_2$1_0.VDD.n579 5.61485
R462 wind_comp_0.sg13g2_and2_2$1_0.VDD.n595 wind_comp_0.sg13g2_and2_2$1_0.VDD.n586 5.61485
R463 wind_comp_0.sg13g2_and2_2$1_0.VDD.n75 wind_comp_0.sg13g2_and2_2$1_0.VDD.n0 5.61281
R464 wind_comp_0.sg13g2_and2_2$1_0.VDD.n81 wind_comp_0.sg13g2_and2_2$1_0.VDD.n0 5.61281
R465 wind_comp_0.sg13g2_and2_2$1_0.VDD.n554 wind_comp_0.sg13g2_and2_2$1_0.VDD.n17 5.61281
R466 wind_comp_0.sg13g2_and2_2$1_0.VDD.n556 wind_comp_0.sg13g2_and2_2$1_0.VDD.n17 5.61281
R467 wind_comp_0.sg13g2_and2_2$1_0.VDD.n558 wind_comp_0.sg13g2_and2_2$1_0.VDD.n17 5.61281
R468 wind_comp_0.sg13g2_and2_2$1_0.VDD.n429 wind_comp_0.sg13g2_and2_2$1_0.VDD.n13 5.61281
R469 wind_comp_0.sg13g2_and2_2$1_0.VDD.n420 wind_comp_0.sg13g2_and2_2$1_0.VDD.n13 5.61281
R470 wind_comp_0.sg13g2_and2_2$1_0.VDD.n375 wind_comp_0.sg13g2_and2_2$1_0.VDD.n13 5.60001
R471 wind_comp_0.sg13g2_and2_2$1_0.VDD.n378 wind_comp_0.sg13g2_and2_2$1_0.VDD.n13 5.60001
R472 wind_comp_0.sg13g2_and2_2$1_0.VDD.n76 wind_comp_0.sg13g2_and2_2$1_0.VDD.n0 5.60001
R473 wind_comp_0.sg13g2_and2_2$1_0.VDD.n373 wind_comp_0.sg13g2_and2_2$1_0.VDD.n13 5.60001
R474 wind_comp_0.sg13g2_and2_2$1_0.VDD.n114 wind_comp_0.sg13g2_and2_2$1_0.VDD.n0 5.60001
R475 wind_comp_0.sg13g2_and2_2$1_0.VDD.n90 wind_comp_0.sg13g2_and2_2$1_0.VDD.n0 5.60001
R476 wind_comp_0.sg13g2_and2_2$1_0.VDD.n606 wind_comp_0.sg13g2_and2_2$1_0.VDD.n71 4.24324
R477 wind_comp_0.sg13g2_and2_2$1_0.VDD.n596 wind_comp_0.sg13g2_and2_2$1_0.VDD.n288 4.24305
R478 wind_comp_0.sg13g2_and2_2$1_0.VDD.n431 wind_comp_0.sg13g2_and2_2$1_0.VDD.n13 4.18441
R479 wind_comp_0.sg13g2_and2_2$1_0.VDD.n696 wind_comp_0.sg13g2_and2_2$1_0.VDD.n0 4.18441
R480 wind_comp_0.sg13g2_and2_2$1_0.VDD.n444 wind_comp_0.sg13g2_and2_2$1_0.VDD.n17 4.18435
R481 wind_comp_0.sg13g2_and2_2$1_0.VDD.n389 wind_comp_0.sg13g2_and2_2$1_0.VDD.n13 4.18423
R482 wind_comp_0.sg13g2_and2_2$1_0.VDD.n131 wind_comp_0.sg13g2_and2_2$1_0.VDD.n72 4.17435
R483 wind_comp_0.sg13g2_and2_2$1_0.VDD.n562 wind_comp_0.sg13g2_and2_2$1_0.VDD.n17 4.17416
R484 wind_comp_0.sg13g2_and2_2$1_0.VDD.n600 wind_comp_0.sg13g2_and2_2$1_0.VDD.t4 2.83383
R485 wind_comp_0.sg13g2_and2_2$1_0.VDD.n132 wind_comp_0.sg13g2_and2_2$1_0.VDD.n72 2.48986
R486 wind_comp_0.sg13g2_and2_2$1_0.VDD.n570 wind_comp_0.comparator_1.sg13cmos5l_inv_16_0.VDD 2.19925
R487 wind_comp_0.sg13g2_and2_2$1_0.VDD.n73 wind_comp_0.sg13g2_and2_2$1_0.VDD.n72 2.18738
R488 wind_comp_0.sg13g2_and2_2$1_0.VDD.n329 wind_comp_0.sg13g2_and2_2$1_0.VDD.t198 2.16436
R489 wind_comp_0.sg13g2_and2_2$1_0.VDD.n338 wind_comp_0.sg13g2_and2_2$1_0.VDD.t181 2.16436
R490 wind_comp_0.sg13g2_and2_2$1_0.VDD.n668 wind_comp_0.sg13g2_and2_2$1_0.VDD.t189 2.16436
R491 wind_comp_0.sg13g2_and2_2$1_0.VDD.n140 wind_comp_0.sg13g2_and2_2$1_0.VDD.t136 2.16436
R492 wind_comp_0.sg13g2_and2_2$1_0.VDD.n133 wind_comp_0.sg13g2_and2_2$1_0.VDD.t140 2.16436
R493 wind_comp_0.sg13g2_and2_2$1_0.VDD.n127 wind_comp_0.sg13g2_and2_2$1_0.VDD.t195 2.16436
R494 wind_comp_0.sg13g2_and2_2$1_0.VDD.n447 wind_comp_0.sg13g2_and2_2$1_0.VDD.t202 2.16422
R495 wind_comp_0.sg13g2_and2_2$1_0.VDD.n392 wind_comp_0.sg13g2_and2_2$1_0.VDD.t156 2.16422
R496 wind_comp_0.sg13g2_and2_2$1_0.VDD.n325 wind_comp_0.sg13g2_and2_2$1_0.VDD.t197 2.16422
R497 wind_comp_0.sg13g2_and2_2$1_0.VDD.n334 wind_comp_0.sg13g2_and2_2$1_0.VDD.t180 2.16422
R498 wind_comp_0.sg13g2_and2_2$1_0.VDD.n670 wind_comp_0.sg13g2_and2_2$1_0.VDD.t188 2.16422
R499 wind_comp_0.sg13g2_and2_2$1_0.VDD.n136 wind_comp_0.sg13g2_and2_2$1_0.VDD.t135 2.16422
R500 wind_comp_0.sg13g2_and2_2$1_0.VDD.n146 wind_comp_0.sg13g2_and2_2$1_0.VDD.t103 2.16422
R501 wind_comp_0.sg13g2_and2_2$1_0.VDD.n659 wind_comp_0.sg13g2_and2_2$1_0.VDD.t193 2.16422
R502 wind_comp_0.sg13g2_and2_2$1_0.VDD.n354 wind_comp_0.sg13g2_and2_2$1_0.VDD.t204 2.16418
R503 wind_comp_0.sg13g2_and2_2$1_0.VDD.n390 wind_comp_0.sg13g2_and2_2$1_0.VDD.t186 2.16418
R504 wind_comp_0.sg13g2_and2_2$1_0.VDD.n601 wind_comp_0.sg13g2_and2_2$1_0.VDD.n71 2.12625
R505 wind_comp_0.sg13g2_and2_2$1_0.VDD.n597 wind_comp_0.sg13g2_and2_2$1_0.VDD.n596 2.1255
R506 wind_comp_0.sg13g2_and2_2$1_0.VDD.n596 wind_comp_0.sg13g2_and2_2$1_0.VDD.n251 1.97104
R507 wind_comp_0.comparator_0.sg13cmos5l_inv_16_1.VDD wind_comp_0.sg13g2_and2_2$1_0.VDD.n708 1.9705
R508 wind_comp_0.sg13g2_and2_2$1_0.VDD.n196 wind_comp_0.sg13g2_and2_2$1_0.VDD.n71 1.9701
R509 wind_comp_0.sg13g2_and2_2$1_0.VDD.n480 wind_comp_0.sg13g2_and2_2$1_0.VDD.n17 1.9672
R510 wind_comp_0.sg13g2_and2_2$1_0.VDD.n523 wind_comp_0.sg13g2_and2_2$1_0.VDD.n249 1.94965
R511 wind_comp_0.sg13g2_and2_2$1_0.VDD.n604 wind_comp_0.sg13g2_and2_2$1_0.VDD.n71 1.87417
R512 wind_comp_0.sg13g2_and2_2$1_0.VDD.n596 wind_comp_0.sg13g2_and2_2$1_0.VDD.n286 1.87345
R513 wind_comp_0.sg13g2_and2_2$1_0.VDD.n574 wind_comp_0.comparator_1.sg13cmos5l_inv_16_0.VDD 1.84578
R514 wind_comp_0.sg13g2_and2_2$1_0.VDD.n175 wind_comp_0.sg13g2_and2_2$1_0.VDD.n68 1.69679
R515 wind_comp_0.sg13g2_and2_2$1_0.VDD.n685 wind_comp_0.sg13g2_and2_2$1_0.VDD.n125 1.57592
R516 wind_comp_0.sg13g2_and2_2$1_0.VDD.n613 wind_comp_0.sg13g2_and2_2$1_0.VDD.n68 1.51113
R517 wind_comp_0.sg13g2_and2_2$1_0.VDD.n126 wind_comp_0.sg13g2_and2_2$1_0.VDD.n72 1.50783
R518 wind_comp_0.sg13g2_and2_2$1_0.VDD.n167 wind_comp_0.sg13g2_and2_2$1_0.VDD.n68 1.49455
R519 wind_comp_0.sg13g2_and2_2$1_0.VDD.n522 wind_comp_0.sg13g2_and2_2$1_0.VDD.n249 1.49358
R520 wind_comp_0.sg13g2_and2_2$1_0.VDD.n688 wind_comp_0.comparator_0.dynamic_pcell$2_0.SRC_NET_KL 1.4877
R521 wind_comp_0.sg13g2_and2_2$1_0.VDD.n342 wind_comp_0.comparator_1.dynamic_pcell$2_0.SRC_NET_KL 1.4877
R522 wind_comp_0.sg13g2_and2_2$1_0.VDD.n677 wind_comp_0.sg13g2_and2_2$1_0.VDD.n72 1.4825
R523 wind_comp_0.sg13g2_and2_2$1_0.VDD.n430 wind_comp_0.sg13g2_and2_2$1_0.VDD.n352 1.38464
R524 wind_comp_0.sg13g2_and2_2$1_0.VDD.n419 wind_comp_0.sg13g2_and2_2$1_0.VDD.n418 1.38464
R525 wind_comp_0.sg13g2_and2_2$1_0.VDD.n704 wind_comp_0.sg13g2_and2_2$1_0.VDD.n703 1.38387
R526 wind_comp_0.sg13g2_and2_2$1_0.VDD.n695 wind_comp_0.sg13g2_and2_2$1_0.VDD.n694 1.38304
R527 wind_comp_0.sg13g2_and2_2$1_0.VDD.n693 wind_comp_0.sg13g2_and2_2$1_0.VDD.n101 1.36353
R528 wind_comp_0.sg13g2_and2_2$1_0.VDD.n531 wind_comp_0.sg13g2_and2_2$1_0.VDD.n249 1.34122
R529 wind_comp_0.sg13g2_and2_2$1_0.VDD.n608 wind_comp_0.sg13g2_and2_2$1_0.VDD.n68 1.34098
R530 wind_comp_0.sg13g2_and2_2$1_0.VDD.n526 wind_comp_0.sg13g2_and2_2$1_0.VDD.n249 1.34076
R531 wind_comp_0.sg13g2_and2_2$1_0.VDD.n560 wind_comp_0.sg13g2_and2_2$1_0.VDD.n17 1.33748
R532 wind_comp_0.sg13g2_and2_2$1_0.VDD.n694 wind_comp_0.sg13g2_and2_2$1_0.VDD.n693 1.31868
R533 wind_comp_0.sg13g2_and2_2$1_0.VDD.n1 wind_comp_0.sg13g2_and2_2$1_0.VDD.n0 0.875503
R534 wind_comp_0.sg13g2_and2_2$1_0.VDD.n125 wind_comp_0.sg13g2_and2_2$1_0.VDD.n124 1.31064
R535 wind_comp_0.sg13g2_and2_2$1_0.VDD.n533 wind_comp_0.sg13g2_and2_2$1_0.VDD.n532 1.29053
R536 wind_comp_0.sg13g2_and2_2$1_0.VDD.n381 wind_comp_0.sg13g2_and2_2$1_0.VDD.n340 1.28983
R537 wind_comp_0.sg13g2_and2_2$1_0.VDD.n621 wind_comp_0.sg13g2_and2_2$1_0.VDD.n164 1.27809
R538 wind_comp_0.sg13g2_and2_2$1_0.VDD.n607 wind_comp_0.sg13g2_and2_2$1_0.VDD.n164 1.27683
R539 wind_comp_0.sg13g2_and2_2$1_0.VDD.n441 wind_comp_0.sg13g2_and2_2$1_0.VDD.n440 1.27557
R540 wind_comp_0.sg13g2_and2_2$1_0.VDD.n532 wind_comp_0.sg13g2_and2_2$1_0.VDD.n248 1.27188
R541 wind_comp_0.sg13g2_and2_2$1_0.VDD.n101 wind_comp_0.sg13g2_and2_2$1_0.VDD.n100 1.27098
R542 wind_comp_0.sg13g2_and2_2$1_0.VDD.n442 wind_comp_0.sg13g2_and2_2$1_0.VDD.n441 1.26478
R543 wind_comp_0.sg13g2_and2_2$1_0.VDD.n477 wind_comp_0.sg13g2_and2_2$1_0.VDD.n340 1.25228
R544 wind_comp_0.sg13g2_and2_2$1_0.VDD.n454 wind_comp_0.sg13g2_and2_2$1_0.VDD.n352 1.22404
R545 wind_comp_0.sg13g2_and2_2$1_0.VDD.n418 wind_comp_0.sg13g2_and2_2$1_0.VDD.n417 1.22404
R546 wind_comp_0.sg13g2_and2_2$1_0.VDD.n19 wind_comp_0.sg13g2_and2_2$1_0.VDD.n0 1.21479
R547 wind_comp_0.sg13g2_and2_2$1_0.VDD.n703 wind_comp_0.sg13g2_and2_2$1_0.VDD.n702 1.20864
R548 wind_comp_0.sg13g2_and2_2$1_0.VDD.n21 wind_comp_0.comparator_1.dynamic_pcell$2_0.SRC_NET_KL 1.1973
R549 wind_comp_0.sg13g2_and2_2$1_0.VDD.n474 wind_comp_0.comparator_1.dynamic_pcell$2_0.SRC_NET_KL 1.1973
R550 wind_comp_0.sg13g2_and2_2$1_0.VDD.n687 wind_comp_0.comparator_0.dynamic_pcell$2_0.SRC_NET_KL 1.1973
R551 wind_comp_0.sg13g2_and2_2$1_0.VDD.n691 wind_comp_0.comparator_0.dynamic_pcell$2_0.SRC_NET_KL 1.1973
R552 wind_comp_0.sg13g2_and2_2$1_0.VDD.n685 wind_comp_0.sg13g2_and2_2$1_0.VDD.n684 1.17017
R553 wind_comp_0.sg13g2_and2_2$1_0.VDD.n685 wind_comp_0.sg13g2_and2_2$1_0.VDD.n113 1.17017
R554 wind_comp_0.sg13g2_and2_2$1_0.VDD.n143 wind_comp_0.sg13g2_and2_2$1_0.VDD.n142 1.15928
R555 wind_comp_0.sg13g2_and2_2$1_0.VDD.n330 wind_comp_0.sg13g2_and2_2$1_0.VDD.n329 1.15232
R556 wind_comp_0.sg13g2_and2_2$1_0.VDD.n339 wind_comp_0.sg13g2_and2_2$1_0.VDD.n338 1.15232
R557 wind_comp_0.sg13g2_and2_2$1_0.VDD.n672 wind_comp_0.sg13g2_and2_2$1_0.VDD.n668 1.15232
R558 wind_comp_0.sg13g2_and2_2$1_0.VDD.n141 wind_comp_0.sg13g2_and2_2$1_0.VDD.n140 1.15232
R559 wind_comp_0.sg13g2_and2_2$1_0.VDD.n145 wind_comp_0.sg13g2_and2_2$1_0.VDD.n133 1.15232
R560 wind_comp_0.sg13g2_and2_2$1_0.VDD.n658 wind_comp_0.sg13g2_and2_2$1_0.VDD.n127 1.15232
R561 wind_comp_0.sg13g2_and2_2$1_0.VDD.n325 wind_comp_0.sg13g2_and2_2$1_0.VDD.n324 1.15219
R562 wind_comp_0.sg13g2_and2_2$1_0.VDD.n334 wind_comp_0.sg13g2_and2_2$1_0.VDD.n333 1.15219
R563 wind_comp_0.sg13g2_and2_2$1_0.VDD.n671 wind_comp_0.sg13g2_and2_2$1_0.VDD.n670 1.15219
R564 wind_comp_0.sg13g2_and2_2$1_0.VDD.n136 wind_comp_0.sg13g2_and2_2$1_0.VDD.n135 1.15219
R565 wind_comp_0.sg13g2_and2_2$1_0.VDD.n147 wind_comp_0.sg13g2_and2_2$1_0.VDD.n146 1.15219
R566 wind_comp_0.sg13g2_and2_2$1_0.VDD.n660 wind_comp_0.sg13g2_and2_2$1_0.VDD.n659 1.15219
R567 wind_comp_0.sg13g2_and2_2$1_0.VDD.n451 wind_comp_0.sg13g2_and2_2$1_0.VDD.n354 1.1517
R568 wind_comp_0.sg13g2_and2_2$1_0.VDD.n396 wind_comp_0.sg13g2_and2_2$1_0.VDD.n390 1.1517
R569 wind_comp_0.sg13g2_and2_2$1_0.VDD.n447 wind_comp_0.sg13g2_and2_2$1_0.VDD.n355 1.15137
R570 wind_comp_0.sg13g2_and2_2$1_0.VDD.n392 wind_comp_0.sg13g2_and2_2$1_0.VDD.n391 1.15137
R571 wind_comp_0.sg13g2_and2_2$1_0.VDD.n448 wind_comp_0.sg13g2_and2_2$1_0.VDD.n447 1.1503
R572 wind_comp_0.sg13g2_and2_2$1_0.VDD.n393 wind_comp_0.sg13g2_and2_2$1_0.VDD.n392 1.1503
R573 wind_comp_0.sg13g2_and2_2$1_0.VDD.n446 wind_comp_0.sg13g2_and2_2$1_0.VDD.n354 1.14989
R574 wind_comp_0.sg13g2_and2_2$1_0.VDD.n390 wind_comp_0.sg13g2_and2_2$1_0.VDD.n344 1.14989
R575 wind_comp_0.sg13g2_and2_2$1_0.VDD.n326 wind_comp_0.sg13g2_and2_2$1_0.VDD.n325 1.14949
R576 wind_comp_0.sg13g2_and2_2$1_0.VDD.n335 wind_comp_0.sg13g2_and2_2$1_0.VDD.n334 1.14949
R577 wind_comp_0.sg13g2_and2_2$1_0.VDD.n670 wind_comp_0.sg13g2_and2_2$1_0.VDD.n669 1.14949
R578 wind_comp_0.sg13g2_and2_2$1_0.VDD.n137 wind_comp_0.sg13g2_and2_2$1_0.VDD.n136 1.14949
R579 wind_comp_0.sg13g2_and2_2$1_0.VDD.n146 wind_comp_0.sg13g2_and2_2$1_0.VDD.n134 1.14949
R580 wind_comp_0.sg13g2_and2_2$1_0.VDD.n659 wind_comp_0.sg13g2_and2_2$1_0.VDD.n128 1.14949
R581 wind_comp_0.sg13g2_and2_2$1_0.VDD.n479 wind_comp_0.sg13g2_and2_2$1_0.VDD.n478 1.14946
R582 wind_comp_0.sg13g2_and2_2$1_0.VDD.n329 wind_comp_0.sg13g2_and2_2$1_0.VDD.n323 1.14932
R583 wind_comp_0.sg13g2_and2_2$1_0.VDD.n338 wind_comp_0.sg13g2_and2_2$1_0.VDD.n332 1.14932
R584 wind_comp_0.sg13g2_and2_2$1_0.VDD.n675 wind_comp_0.sg13g2_and2_2$1_0.VDD.n668 1.14932
R585 wind_comp_0.sg13g2_and2_2$1_0.VDD.n140 wind_comp_0.sg13g2_and2_2$1_0.VDD.n112 1.14932
R586 wind_comp_0.sg13g2_and2_2$1_0.VDD.n150 wind_comp_0.sg13g2_and2_2$1_0.VDD.n133 1.14932
R587 wind_comp_0.sg13g2_and2_2$1_0.VDD.n663 wind_comp_0.sg13g2_and2_2$1_0.VDD.n127 1.14932
R588 wind_comp_0.sg13g2_and2_2$1_0.VDD.n144 wind_comp_0.sg13g2_and2_2$1_0.VDD.n143 1.1362
R589 wind_comp_0.sg13g2_and2_2$1_0.VDD.n472 wind_comp_0.sg13g2_and2_2$1_0.VDD.n342 1.1247
R590 wind_comp_0.sg13g2_and2_2$1_0.VDD.n689 wind_comp_0.sg13g2_and2_2$1_0.VDD.n688 1.1247
R591 wind_comp_0.sg13g2_and2_2$1_0.VDD.n692 wind_comp_0.sg13g2_and2_2$1_0.VDD.n112 1.09867
R592 wind_comp_0.sg13g2_and2_2$1_0.VDD.n478 wind_comp_0.sg13g2_and2_2$1_0.VDD.n477 1.07738
R593 wind_comp_0.sg13g2_and2_2$1_0.VDD.n153 wind_comp_0.sg13g2_and2_2$1_0.VDD.n130 1.07475
R594 wind_comp_0.sg13g2_and2_2$1_0.VDD.n459 wind_comp_0.sg13g2_and2_2$1_0.VDD.n331 1.00514
R595 wind_comp_0.sg13g2_and2_2$1_0.VDD.n557 wind_comp_0.sg13g2_and2_2$1_0.VDD.n331 0.992413
R596 wind_comp_0.sg13g2_and2_2$1_0.VDD.n655 wind_comp_0.sg13g2_and2_2$1_0.VDD.n130 0.991305
R597 wind_comp_0.sg13g2_and2_2$1_0.VDD.n665 wind_comp_0.sg13g2_and2_2$1_0.VDD.n72 0.974332
R598 wind_comp_0.sg13g2_and2_2$1_0.VDD.n103 wind_comp_0.sg13g2_and2_2$1_0.VDD.n72 0.94628
R599 wind_comp_0.sg13g2_and2_2$1_0.VDD.n111 wind_comp_0.sg13g2_and2_2$1_0.VDD.n110 0.901654
R600 wind_comp_0.sg13g2_and2_2$1_0.VDD.n667 wind_comp_0.sg13g2_and2_2$1_0.VDD.n72 0.880652
R601 wind_comp_0.sg13g2_and2_2$1_0.VDD.n3 wind_comp_0.sg13g2_and2_2$1_0.VDD.n692 0.292525
R602 wind_comp_0.sg13g2_and2_2$1_0.VDD.n672 wind_comp_0.sg13g2_and2_2$1_0.VDD.n74 0.861462
R603 wind_comp_0.sg13g2_and2_2$1_0.VDD.n565 wind_comp_0.sg13g2_and2_2$1_0.VDD.n564 0.846654
R604 wind_comp_0.sg13g2_and2_2$1_0.VDD.n666 wind_comp_0.sg13g2_and2_2$1_0.VDD.n665 0.842435
R605 wind_comp_0.sg13g2_and2_2$1_0.VDD.n534 wind_comp_0.sg13g2_and2_2$1_0.VDD.n249 0.811704
R606 wind_comp_0.sg13g2_and2_2$1_0.VDD.n622 wind_comp_0.sg13g2_and2_2$1_0.VDD.n68 0.810774
R607 wind_comp_0.sg13g2_and2_2$1_0.VDD.n597 wind_comp_0.sg13g2_and2_2$1_0.VDD.n249 0.810024
R608 wind_comp_0.sg13g2_and2_2$1_0.VDD.n601 wind_comp_0.sg13g2_and2_2$1_0.VDD.n68 0.810024
R609 wind_comp_0.sg13g2_and2_2$1_0.VDD.n153 wind_comp_0.sg13g2_and2_2$1_0.VDD.n73 0.802773
R610 wind_comp_0.sg13g2_and2_2$1_0.VDD.n10 wind_comp_0.comparator_1.sg13cmos5l_inv_16_1.VDD 0.779333
R611 wind_comp_0.sg13g2_and2_2$1_0.VDD.n667 wind_comp_0.sg13g2_and2_2$1_0.VDD.n666 0.760638
R612 wind_comp_0.sg13g2_and2_2$1_0.VDD.n676 wind_comp_0.sg13g2_and2_2$1_0.VDD.n667 0.74526
R613 wind_comp_0.sg13g2_and2_2$1_0.VDD.n611 wind_comp_0.sg13g2_and2_2$1_0.VDD.n610 0.72779
R614 wind_comp_0.sg13g2_and2_2$1_0.VDD.n177 wind_comp_0.sg13g2_and2_2$1_0.VDD.n176 0.72779
R615 wind_comp_0.sg13g2_and2_2$1_0.VDD.n529 wind_comp_0.sg13g2_and2_2$1_0.VDD.n528 0.72779
R616 wind_comp_0.sg13g2_and2_2$1_0.VDD.n525 wind_comp_0.sg13g2_and2_2$1_0.VDD.n524 0.72779
R617 wind_comp_0.sg13g2_and2_2$1_0.VDD.n1 wind_comp_0.sg13g2_and2_2$1_0.VDD.n704 0.973653
R618 wind_comp_0.sg13g2_and2_2$1_0.VDD.n677 wind_comp_0.sg13g2_and2_2$1_0.VDD.n676 0.715266
R619 wind_comp_0.sg13g2_and2_2$1_0.VDD.n665 wind_comp_0.sg13g2_and2_2$1_0.VDD.n664 0.699961
R620 wind_comp_0.sg13g2_and2_2$1_0.VDD.n613 wind_comp_0.sg13g2_and2_2$1_0.VDD.n612 0.654949
R621 wind_comp_0.sg13g2_and2_2$1_0.VDD.n526 wind_comp_0.sg13g2_and2_2$1_0.VDD.n248 0.651493
R622 wind_comp_0.sg13g2_and2_2$1_0.VDD.n608 wind_comp_0.sg13g2_and2_2$1_0.VDD.n607 0.651075
R623 wind_comp_0.sg13g2_and2_2$1_0.VDD.n533 wind_comp_0.sg13g2_and2_2$1_0.VDD.n531 0.650804
R624 wind_comp_0.sg13g2_and2_2$1_0.VDD.n560 wind_comp_0.sg13g2_and2_2$1_0.VDD.n559 0.650116
R625 wind_comp_0.sg13g2_and2_2$1_0.VDD.n561 wind_comp_0.sg13g2_and2_2$1_0.VDD.n560 0.649381
R626 wind_comp_0.sg13g2_and2_2$1_0.VDD.n609 wind_comp_0.sg13g2_and2_2$1_0.VDD.n175 0.647
R627 wind_comp_0.sg13g2_and2_2$1_0.VDD.n1 wind_comp_0.sg13g2_and2_2$1_0.VDD.n73 1.76227
R628 wind_comp_0.sg13g2_and2_2$1_0.VDD.n621 wind_comp_0.sg13g2_and2_2$1_0.VDD.n613 0.600409
R629 wind_comp_0.sg13g2_and2_2$1_0.VDD.n527 wind_comp_0.sg13g2_and2_2$1_0.VDD.n523 0.588635
R630 wind_comp_0.sg13g2_and2_2$1_0.VDD.n530 wind_comp_0.sg13g2_and2_2$1_0.VDD.n523 0.588335
R631 wind_comp_0.sg13g2_and2_2$1_0.VDD.n531 wind_comp_0.sg13g2_and2_2$1_0.VDD.n530 0.583258
R632 wind_comp_0.sg13g2_and2_2$1_0.VDD.n609 wind_comp_0.sg13g2_and2_2$1_0.VDD.n608 0.582962
R633 wind_comp_0.sg13g2_and2_2$1_0.VDD.n527 wind_comp_0.sg13g2_and2_2$1_0.VDD.n526 0.58246
R634 wind_comp_0.sg13g2_and2_2$1_0.VDD.n655 wind_comp_0.sg13g2_and2_2$1_0.VDD.n126 0.569028
R635 wind_comp_0.sg13g2_and2_2$1_0.VDD.n664 wind_comp_0.sg13g2_and2_2$1_0.VDD.n126 0.545431
R636 wind_comp_0.sg13g2_and2_2$1_0.VDD.n551 wind_comp_0.sg13g2_and2_2$1_0.VDD.n482 0.533477
R637 wind_comp_0.sg13g2_and2_2$1_0.VDD.n650 wind_comp_0.sg13g2_and2_2$1_0.VDD.n649 0.533477
R638 wind_comp_0.sg13g2_and2_2$1_0.VDD.n653 wind_comp_0.sg13g2_and2_2$1_0.VDD.n652 0.533477
R639 wind_comp_0.sg13g2_and2_2$1_0.VDD.n535 wind_comp_0.sg13g2_and2_2$1_0.VDD.n503 0.529912
R640 wind_comp_0.sg13g2_and2_2$1_0.VDD.n537 wind_comp_0.sg13g2_and2_2$1_0.VDD.n536 0.529912
R641 wind_comp_0.sg13g2_and2_2$1_0.VDD.n538 wind_comp_0.sg13g2_and2_2$1_0.VDD.n491 0.529912
R642 wind_comp_0.sg13g2_and2_2$1_0.VDD.n540 wind_comp_0.sg13g2_and2_2$1_0.VDD.n539 0.529912
R643 wind_comp_0.sg13g2_and2_2$1_0.VDD.n541 wind_comp_0.sg13g2_and2_2$1_0.VDD.n490 0.529912
R644 wind_comp_0.sg13g2_and2_2$1_0.VDD.n543 wind_comp_0.sg13g2_and2_2$1_0.VDD.n542 0.529912
R645 wind_comp_0.sg13g2_and2_2$1_0.VDD.n544 wind_comp_0.sg13g2_and2_2$1_0.VDD.n486 0.529912
R646 wind_comp_0.sg13g2_and2_2$1_0.VDD.n546 wind_comp_0.sg13g2_and2_2$1_0.VDD.n545 0.529912
R647 wind_comp_0.sg13g2_and2_2$1_0.VDD.n547 wind_comp_0.sg13g2_and2_2$1_0.VDD.n485 0.529912
R648 wind_comp_0.sg13g2_and2_2$1_0.VDD.n549 wind_comp_0.sg13g2_and2_2$1_0.VDD.n548 0.529912
R649 wind_comp_0.sg13g2_and2_2$1_0.VDD.n550 wind_comp_0.sg13g2_and2_2$1_0.VDD.n481 0.529912
R650 wind_comp_0.sg13g2_and2_2$1_0.VDD.n552 wind_comp_0.sg13g2_and2_2$1_0.VDD.n551 0.529912
R651 wind_comp_0.sg13g2_and2_2$1_0.VDD.n503 wind_comp_0.sg13g2_and2_2$1_0.VDD.n502 0.529912
R652 wind_comp_0.sg13g2_and2_2$1_0.VDD.n537 wind_comp_0.sg13g2_and2_2$1_0.VDD.n494 0.529912
R653 wind_comp_0.sg13g2_and2_2$1_0.VDD.n538 wind_comp_0.sg13g2_and2_2$1_0.VDD.n493 0.529912
R654 wind_comp_0.sg13g2_and2_2$1_0.VDD.n539 wind_comp_0.sg13g2_and2_2$1_0.VDD.n492 0.529912
R655 wind_comp_0.sg13g2_and2_2$1_0.VDD.n496 wind_comp_0.sg13g2_and2_2$1_0.VDD.n490 0.529912
R656 wind_comp_0.sg13g2_and2_2$1_0.VDD.n543 wind_comp_0.sg13g2_and2_2$1_0.VDD.n489 0.529912
R657 wind_comp_0.sg13g2_and2_2$1_0.VDD.n544 wind_comp_0.sg13g2_and2_2$1_0.VDD.n488 0.529912
R658 wind_comp_0.sg13g2_and2_2$1_0.VDD.n545 wind_comp_0.sg13g2_and2_2$1_0.VDD.n487 0.529912
R659 wind_comp_0.sg13g2_and2_2$1_0.VDD.n499 wind_comp_0.sg13g2_and2_2$1_0.VDD.n485 0.529912
R660 wind_comp_0.sg13g2_and2_2$1_0.VDD.n549 wind_comp_0.sg13g2_and2_2$1_0.VDD.n484 0.529912
R661 wind_comp_0.sg13g2_and2_2$1_0.VDD.n550 wind_comp_0.sg13g2_and2_2$1_0.VDD.n483 0.529912
R662 wind_comp_0.sg13g2_and2_2$1_0.VDD.n502 wind_comp_0.sg13g2_and2_2$1_0.VDD.n501 0.529912
R663 wind_comp_0.sg13g2_and2_2$1_0.VDD.n501 wind_comp_0.sg13g2_and2_2$1_0.VDD.n484 0.529912
R664 wind_comp_0.sg13g2_and2_2$1_0.VDD.n654 wind_comp_0.sg13g2_and2_2$1_0.VDD.n653 0.529912
R665 wind_comp_0.sg13g2_and2_2$1_0.VDD.n156 wind_comp_0.sg13g2_and2_2$1_0.VDD.n155 0.529912
R666 wind_comp_0.sg13g2_and2_2$1_0.VDD.n635 wind_comp_0.sg13g2_and2_2$1_0.VDD.n634 0.529912
R667 wind_comp_0.sg13g2_and2_2$1_0.VDD.n637 wind_comp_0.sg13g2_and2_2$1_0.VDD.n636 0.529912
R668 wind_comp_0.sg13g2_and2_2$1_0.VDD.n638 wind_comp_0.sg13g2_and2_2$1_0.VDD.n628 0.529912
R669 wind_comp_0.sg13g2_and2_2$1_0.VDD.n640 wind_comp_0.sg13g2_and2_2$1_0.VDD.n639 0.529912
R670 wind_comp_0.sg13g2_and2_2$1_0.VDD.n641 wind_comp_0.sg13g2_and2_2$1_0.VDD.n627 0.529912
R671 wind_comp_0.sg13g2_and2_2$1_0.VDD.n643 wind_comp_0.sg13g2_and2_2$1_0.VDD.n642 0.529912
R672 wind_comp_0.sg13g2_and2_2$1_0.VDD.n644 wind_comp_0.sg13g2_and2_2$1_0.VDD.n623 0.529912
R673 wind_comp_0.sg13g2_and2_2$1_0.VDD.n646 wind_comp_0.sg13g2_and2_2$1_0.VDD.n645 0.529912
R674 wind_comp_0.sg13g2_and2_2$1_0.VDD.n647 wind_comp_0.sg13g2_and2_2$1_0.VDD.n163 0.529912
R675 wind_comp_0.sg13g2_and2_2$1_0.VDD.n649 wind_comp_0.sg13g2_and2_2$1_0.VDD.n648 0.529912
R676 wind_comp_0.sg13g2_and2_2$1_0.VDD.n157 wind_comp_0.sg13g2_and2_2$1_0.VDD.n156 0.529912
R677 wind_comp_0.sg13g2_and2_2$1_0.VDD.n634 wind_comp_0.sg13g2_and2_2$1_0.VDD.n633 0.529912
R678 wind_comp_0.sg13g2_and2_2$1_0.VDD.n637 wind_comp_0.sg13g2_and2_2$1_0.VDD.n632 0.529912
R679 wind_comp_0.sg13g2_and2_2$1_0.VDD.n638 wind_comp_0.sg13g2_and2_2$1_0.VDD.n631 0.529912
R680 wind_comp_0.sg13g2_and2_2$1_0.VDD.n639 wind_comp_0.sg13g2_and2_2$1_0.VDD.n630 0.529912
R681 wind_comp_0.sg13g2_and2_2$1_0.VDD.n629 wind_comp_0.sg13g2_and2_2$1_0.VDD.n627 0.529912
R682 wind_comp_0.sg13g2_and2_2$1_0.VDD.n643 wind_comp_0.sg13g2_and2_2$1_0.VDD.n626 0.529912
R683 wind_comp_0.sg13g2_and2_2$1_0.VDD.n644 wind_comp_0.sg13g2_and2_2$1_0.VDD.n625 0.529912
R684 wind_comp_0.sg13g2_and2_2$1_0.VDD.n645 wind_comp_0.sg13g2_and2_2$1_0.VDD.n624 0.529912
R685 wind_comp_0.sg13g2_and2_2$1_0.VDD.n163 wind_comp_0.sg13g2_and2_2$1_0.VDD.n162 0.529912
R686 wind_comp_0.sg13g2_and2_2$1_0.VDD.n553 wind_comp_0.sg13g2_and2_2$1_0.VDD.n480 0.518346
R687 wind_comp_0.sg13g2_and2_2$1_0.VDD.n130 wind_comp_0.sg13g2_and2_2$1_0.VDD.n72 0.514711
R688 wind_comp_0.sg13g2_and2_2$1_0.VDD.n612 wind_comp_0.sg13g2_and2_2$1_0.VDD.n175 0.513341
R689 wind_comp_0.sg13g2_and2_2$1_0.VDD.n480 wind_comp_0.sg13g2_and2_2$1_0.VDD.n479 0.48477
R690 wind_comp_0.sg13g2_and2_2$1_0.VDD.n692 wind_comp_0.sg13g2_and2_2$1_0.VDD.n111 0.448962
R691 wind_comp_0.sg13g2_and2_2$1_0.VDD.n563 wind_comp_0.sg13g2_and2_2$1_0.VDD.n562 0.423228
R692 wind_comp_0.sg13g2_and2_2$1_0.VDD.n331 wind_comp_0.sg13g2_and2_2$1_0.VDD.n17 0.420804
R693 wind_comp_0.sg13g2_and2_2$1_0.VDD.n44 wind_comp_0.comparator_0.sg13cmos5l_inv_16_0.VDD 0.41425
R694 wind_comp_0.sg13g2_and2_2$1_0.VDD.n686 wind_comp_0.sg13g2_and2_2$1_0.VDD.n685 0.410422
R695 wind_comp_0.sg13g2_and2_2$1_0.VDD.n685 wind_comp_0.sg13g2_and2_2$1_0.VDD.n74 0.406654
R696 wind_comp_0.sg13g2_and2_2$1_0.VDD.n521 wind_comp_0.sg13g2_and2_2$1_0.VDD.n251 0.393664
R697 wind_comp_0.sg13g2_and2_2$1_0.VDD.n196 wind_comp_0.sg13g2_and2_2$1_0.VDD.n195 0.392409
R698 wind_comp_0.sg13g2_and2_2$1_0.VDD.n197 wind_comp_0.sg13g2_and2_2$1_0.VDD.n196 0.391992
R699 wind_comp_0.sg13g2_and2_2$1_0.VDD.n593 wind_comp_0.sg13g2_and2_2$1_0.VDD.n251 0.390883
R700 wind_comp_0.sg13g2_and2_2$1_0.VDD.n705 wind_comp_0.comparator_0.dynamic_pcell_0.VDD 0.386864
R701 wind_comp_0.comparator_1.dynamic_pcell$7_0.VDD wind_comp_0.sg13g2_and2_2$1_0.VDD.n595 0.386864
R702 wind_comp_0.sg13g2_and2_2$1_0.VDD.n566 wind_comp_0.sg13g2_and2_2$1_0.VDD.n565 0.363218
R703 wind_comp_0.sg13g2_and2_2$1_0.VDD.n143 wind_comp_0.sg13g2_and2_2$1_0.VDD.n72 0.354101
R704 wind_comp_0.comparator_0.dynamic_pcell_0.VDD wind_comp_0.sg13g2_and2_2$1_0.VDD.n71 0.327423
R705 wind_comp_0.sg13g2_and2_2$1_0.VDD.n596 wind_comp_0.comparator_1.dynamic_pcell$7_0.VDD 0.327423
R706 wind_comp_0.sg13g2_and2_2$1_0.VDD.n478 wind_comp_0.sg13g2_and2_2$1_0.VDD.n17 0.325283
R707 wind_comp_0.sg13g2_and2_2$1_0.VDD.n362 wind_comp_0.sg13g2_and2_2$1_0.VDD.n356 0.296125
R708 wind_comp_0.sg13g2_and2_2$1_0.VDD.n363 wind_comp_0.sg13g2_and2_2$1_0.VDD.n362 0.296125
R709 wind_comp_0.sg13g2_and2_2$1_0.VDD.n359 wind_comp_0.sg13g2_and2_2$1_0.VDD.n358 0.296125
R710 wind_comp_0.sg13g2_and2_2$1_0.VDD.n358 wind_comp_0.sg13g2_and2_2$1_0.VDD.n357 0.296125
R711 wind_comp_0.sg13g2_and2_2$1_0.VDD.n351 wind_comp_0.sg13g2_and2_2$1_0.VDD.n345 0.296125
R712 wind_comp_0.sg13g2_and2_2$1_0.VDD.n345 wind_comp_0.sg13g2_and2_2$1_0.VDD.n343 0.296125
R713 wind_comp_0.sg13g2_and2_2$1_0.VDD.n347 wind_comp_0.sg13g2_and2_2$1_0.VDD.n346 0.296125
R714 wind_comp_0.sg13g2_and2_2$1_0.VDD.n348 wind_comp_0.sg13g2_and2_2$1_0.VDD.n347 0.296125
R715 wind_comp_0.sg13g2_and2_2$1_0.VDD.n402 wind_comp_0.sg13g2_and2_2$1_0.VDD.n16 0.296125
R716 wind_comp_0.sg13g2_and2_2$1_0.VDD.n403 wind_comp_0.sg13g2_and2_2$1_0.VDD.n402 0.296125
R717 wind_comp_0.sg13g2_and2_2$1_0.VDD.n399 wind_comp_0.sg13g2_and2_2$1_0.VDD.n398 0.296125
R718 wind_comp_0.sg13g2_and2_2$1_0.VDD.n398 wind_comp_0.sg13g2_and2_2$1_0.VDD.n397 0.296125
R719 wind_comp_0.sg13g2_and2_2$1_0.VDD.n439 wind_comp_0.sg13g2_and2_2$1_0.VDD.n438 0.296125
R720 wind_comp_0.sg13g2_and2_2$1_0.VDD.n438 wind_comp_0.sg13g2_and2_2$1_0.VDD.n437 0.296125
R721 wind_comp_0.sg13g2_and2_2$1_0.VDD.n434 wind_comp_0.sg13g2_and2_2$1_0.VDD.n433 0.296125
R722 wind_comp_0.sg13g2_and2_2$1_0.VDD.n435 wind_comp_0.sg13g2_and2_2$1_0.VDD.n433 0.296125
R723 wind_comp_0.sg13g2_and2_2$1_0.VDD.n423 wind_comp_0.sg13g2_and2_2$1_0.VDD.n377 0.296125
R724 wind_comp_0.sg13g2_and2_2$1_0.VDD.n424 wind_comp_0.sg13g2_and2_2$1_0.VDD.n423 0.296125
R725 wind_comp_0.sg13g2_and2_2$1_0.VDD.n427 wind_comp_0.sg13g2_and2_2$1_0.VDD.n376 0.296125
R726 wind_comp_0.sg13g2_and2_2$1_0.VDD.n422 wind_comp_0.sg13g2_and2_2$1_0.VDD.n376 0.296125
R727 wind_comp_0.sg13g2_and2_2$1_0.VDD.n383 wind_comp_0.sg13g2_and2_2$1_0.VDD.n380 0.296125
R728 wind_comp_0.sg13g2_and2_2$1_0.VDD.n384 wind_comp_0.sg13g2_and2_2$1_0.VDD.n383 0.296125
R729 wind_comp_0.sg13g2_and2_2$1_0.VDD.n387 wind_comp_0.sg13g2_and2_2$1_0.VDD.n379 0.296125
R730 wind_comp_0.sg13g2_and2_2$1_0.VDD.n382 wind_comp_0.sg13g2_and2_2$1_0.VDD.n379 0.296125
R731 wind_comp_0.sg13g2_and2_2$1_0.VDD.n110 wind_comp_0.sg13g2_and2_2$1_0.VDD.n109 0.296125
R732 wind_comp_0.sg13g2_and2_2$1_0.VDD.n109 wind_comp_0.sg13g2_and2_2$1_0.VDD.n102 0.296125
R733 wind_comp_0.sg13g2_and2_2$1_0.VDD.n117 wind_comp_0.sg13g2_and2_2$1_0.VDD.n116 0.296125
R734 wind_comp_0.sg13g2_and2_2$1_0.VDD.n118 wind_comp_0.sg13g2_and2_2$1_0.VDD.n117 0.296125
R735 wind_comp_0.sg13g2_and2_2$1_0.VDD.n684 wind_comp_0.sg13g2_and2_2$1_0.VDD.n678 0.296125
R736 wind_comp_0.sg13g2_and2_2$1_0.VDD.n678 wind_comp_0.sg13g2_and2_2$1_0.VDD.n113 0.296125
R737 wind_comp_0.sg13g2_and2_2$1_0.VDD.n680 wind_comp_0.sg13g2_and2_2$1_0.VDD.n679 0.296125
R738 wind_comp_0.sg13g2_and2_2$1_0.VDD.n681 wind_comp_0.sg13g2_and2_2$1_0.VDD.n680 0.296125
R739 wind_comp_0.sg13g2_and2_2$1_0.VDD.n79 wind_comp_0.sg13g2_and2_2$1_0.VDD.n78 0.296125
R740 wind_comp_0.sg13g2_and2_2$1_0.VDD.n80 wind_comp_0.sg13g2_and2_2$1_0.VDD.n79 0.296125
R741 wind_comp_0.sg13g2_and2_2$1_0.VDD.n701 wind_comp_0.sg13g2_and2_2$1_0.VDD.n77 0.296125
R742 wind_comp_0.sg13g2_and2_2$1_0.VDD.n698 wind_comp_0.sg13g2_and2_2$1_0.VDD.n77 0.296125
R743 wind_comp_0.sg13g2_and2_2$1_0.VDD.n98 wind_comp_0.sg13g2_and2_2$1_0.VDD.n97 0.296125
R744 wind_comp_0.sg13g2_and2_2$1_0.VDD.n99 wind_comp_0.sg13g2_and2_2$1_0.VDD.n98 0.296125
R745 wind_comp_0.sg13g2_and2_2$1_0.VDD.n94 wind_comp_0.sg13g2_and2_2$1_0.VDD.n92 0.296125
R746 wind_comp_0.sg13g2_and2_2$1_0.VDD.n93 wind_comp_0.sg13g2_and2_2$1_0.VDD.n92 0.296125
R747 wind_comp_0.sg13g2_and2_2$1_0.VDD.n123 wind_comp_0.sg13g2_and2_2$1_0.VDD.n115 0.296125
R748 wind_comp_0.sg13g2_and2_2$1_0.VDD.n120 wind_comp_0.sg13g2_and2_2$1_0.VDD.n115 0.296125
R749 wind_comp_0.sg13g2_and2_2$1_0.VDD.n105 wind_comp_0.sg13g2_and2_2$1_0.VDD.n104 0.296125
R750 wind_comp_0.sg13g2_and2_2$1_0.VDD.n106 wind_comp_0.sg13g2_and2_2$1_0.VDD.n105 0.296125
R751 wind_comp_0.sg13g2_and2_2$1_0.VDD.n89 wind_comp_0.sg13g2_and2_2$1_0.VDD.n83 0.296125
R752 wind_comp_0.sg13g2_and2_2$1_0.VDD.n83 wind_comp_0.sg13g2_and2_2$1_0.VDD.n82 0.296125
R753 wind_comp_0.sg13g2_and2_2$1_0.VDD.n85 wind_comp_0.sg13g2_and2_2$1_0.VDD.n84 0.296125
R754 wind_comp_0.sg13g2_and2_2$1_0.VDD.n86 wind_comp_0.sg13g2_and2_2$1_0.VDD.n85 0.296125
R755 wind_comp_0.sg13g2_and2_2$1_0.VDD.n437 wind_comp_0.sg13g2_and2_2$1_0.VDD.n432 0.293833
R756 wind_comp_0.sg13g2_and2_2$1_0.VDD.n440 wind_comp_0.sg13g2_and2_2$1_0.VDD.n439 0.293833
R757 wind_comp_0.sg13g2_and2_2$1_0.VDD.n428 wind_comp_0.sg13g2_and2_2$1_0.VDD.n427 0.293833
R758 wind_comp_0.sg13g2_and2_2$1_0.VDD.n422 wind_comp_0.sg13g2_and2_2$1_0.VDD.n421 0.293833
R759 wind_comp_0.sg13g2_and2_2$1_0.VDD.n388 wind_comp_0.sg13g2_and2_2$1_0.VDD.n387 0.293833
R760 wind_comp_0.sg13g2_and2_2$1_0.VDD.n382 wind_comp_0.sg13g2_and2_2$1_0.VDD.n381 0.293833
R761 wind_comp_0.sg13g2_and2_2$1_0.VDD.n120 wind_comp_0.sg13g2_and2_2$1_0.VDD.n119 0.293833
R762 wind_comp_0.sg13g2_and2_2$1_0.VDD.n124 wind_comp_0.sg13g2_and2_2$1_0.VDD.n123 0.293833
R763 wind_comp_0.sg13g2_and2_2$1_0.VDD.n698 wind_comp_0.sg13g2_and2_2$1_0.VDD.n697 0.293833
R764 wind_comp_0.sg13g2_and2_2$1_0.VDD.n702 wind_comp_0.sg13g2_and2_2$1_0.VDD.n701 0.293833
R765 wind_comp_0.sg13g2_and2_2$1_0.VDD.n97 wind_comp_0.sg13g2_and2_2$1_0.VDD.n96 0.293833
R766 wind_comp_0.sg13g2_and2_2$1_0.VDD.n100 wind_comp_0.sg13g2_and2_2$1_0.VDD.n99 0.293833
R767 wind_comp_0.sg13g2_and2_2$1_0.VDD.n501 wind_comp_0.sg13g2_and2_2$1_0.VDD.n495 0.264173
R768 wind_comp_0.sg13g2_and2_2$1_0.VDD.n501 wind_comp_0.sg13g2_and2_2$1_0.VDD.n497 0.264173
R769 wind_comp_0.sg13g2_and2_2$1_0.VDD.n501 wind_comp_0.sg13g2_and2_2$1_0.VDD.n498 0.264173
R770 wind_comp_0.sg13g2_and2_2$1_0.VDD.n501 wind_comp_0.sg13g2_and2_2$1_0.VDD.n500 0.264173
R771 wind_comp_0.sg13g2_and2_2$1_0.VDD.n501 wind_comp_0.sg13g2_and2_2$1_0.VDD.n482 0.264173
R772 wind_comp_0.sg13g2_and2_2$1_0.VDD.n652 wind_comp_0.sg13g2_and2_2$1_0.VDD.n651 0.264173
R773 wind_comp_0.sg13g2_and2_2$1_0.VDD.n651 wind_comp_0.sg13g2_and2_2$1_0.VDD.n158 0.264173
R774 wind_comp_0.sg13g2_and2_2$1_0.VDD.n651 wind_comp_0.sg13g2_and2_2$1_0.VDD.n159 0.264173
R775 wind_comp_0.sg13g2_and2_2$1_0.VDD.n651 wind_comp_0.sg13g2_and2_2$1_0.VDD.n160 0.264173
R776 wind_comp_0.sg13g2_and2_2$1_0.VDD.n651 wind_comp_0.sg13g2_and2_2$1_0.VDD.n161 0.264173
R777 wind_comp_0.sg13g2_and2_2$1_0.VDD.n651 wind_comp_0.sg13g2_and2_2$1_0.VDD.n650 0.264173
R778 wind_comp_0.sg13g2_and2_2$1_0.VDD.n703 wind_comp_0.sg13g2_and2_2$1_0.VDD.n0 0.260835
R779 wind_comp_0.sg13g2_and2_2$1_0.VDD.n562 wind_comp_0.sg13g2_and2_2$1_0.VDD.n561 0.252728
R780 wind_comp_0.sg13g2_and2_2$1_0.VDD.n558 wind_comp_0.sg13g2_and2_2$1_0.VDD.n557 0.250092
R781 wind_comp_0.sg13g2_and2_2$1_0.VDD.n557 wind_comp_0.sg13g2_and2_2$1_0.VDD.n556 0.249752
R782 wind_comp_0.sg13g2_and2_2$1_0.VDD.n144 wind_comp_0.sg13g2_and2_2$1_0.VDD.n131 0.245781
R783 wind_comp_0.sg13g2_and2_2$1_0.VDD.n516 wind_comp_0.sg13g2_and2_2$1_0.VDD.n515 0.244562
R784 wind_comp_0.sg13g2_and2_2$1_0.VDD.n515 wind_comp_0.sg13g2_and2_2$1_0.VDD.n514 0.244562
R785 wind_comp_0.sg13g2_and2_2$1_0.VDD.n513 wind_comp_0.sg13g2_and2_2$1_0.VDD.n504 0.244562
R786 wind_comp_0.sg13g2_and2_2$1_0.VDD.n519 wind_comp_0.sg13g2_and2_2$1_0.VDD.n513 0.244562
R787 wind_comp_0.sg13g2_and2_2$1_0.VDD.n509 wind_comp_0.sg13g2_and2_2$1_0.VDD.n508 0.244562
R788 wind_comp_0.sg13g2_and2_2$1_0.VDD.n508 wind_comp_0.sg13g2_and2_2$1_0.VDD.n507 0.244562
R789 wind_comp_0.sg13g2_and2_2$1_0.VDD.n506 wind_comp_0.sg13g2_and2_2$1_0.VDD.n505 0.244562
R790 wind_comp_0.sg13g2_and2_2$1_0.VDD.n512 wind_comp_0.sg13g2_and2_2$1_0.VDD.n506 0.244562
R791 wind_comp_0.sg13g2_and2_2$1_0.VDD.n241 wind_comp_0.sg13g2_and2_2$1_0.VDD.n232 0.244562
R792 wind_comp_0.sg13g2_and2_2$1_0.VDD.n247 wind_comp_0.sg13g2_and2_2$1_0.VDD.n241 0.244562
R793 wind_comp_0.sg13g2_and2_2$1_0.VDD.n244 wind_comp_0.sg13g2_and2_2$1_0.VDD.n243 0.244562
R794 wind_comp_0.sg13g2_and2_2$1_0.VDD.n243 wind_comp_0.sg13g2_and2_2$1_0.VDD.n242 0.244562
R795 wind_comp_0.sg13g2_and2_2$1_0.VDD.n236 wind_comp_0.sg13g2_and2_2$1_0.VDD.n235 0.244562
R796 wind_comp_0.sg13g2_and2_2$1_0.VDD.n237 wind_comp_0.sg13g2_and2_2$1_0.VDD.n236 0.244562
R797 wind_comp_0.sg13g2_and2_2$1_0.VDD.n240 wind_comp_0.sg13g2_and2_2$1_0.VDD.n234 0.244562
R798 wind_comp_0.sg13g2_and2_2$1_0.VDD.n234 wind_comp_0.sg13g2_and2_2$1_0.VDD.n233 0.244562
R799 wind_comp_0.sg13g2_and2_2$1_0.VDD.n614 wind_comp_0.sg13g2_and2_2$1_0.VDD.n165 0.244562
R800 wind_comp_0.sg13g2_and2_2$1_0.VDD.n620 wind_comp_0.sg13g2_and2_2$1_0.VDD.n614 0.244562
R801 wind_comp_0.sg13g2_and2_2$1_0.VDD.n617 wind_comp_0.sg13g2_and2_2$1_0.VDD.n616 0.244562
R802 wind_comp_0.sg13g2_and2_2$1_0.VDD.n616 wind_comp_0.sg13g2_and2_2$1_0.VDD.n615 0.244562
R803 wind_comp_0.sg13g2_and2_2$1_0.VDD.n170 wind_comp_0.sg13g2_and2_2$1_0.VDD.n169 0.244562
R804 wind_comp_0.sg13g2_and2_2$1_0.VDD.n171 wind_comp_0.sg13g2_and2_2$1_0.VDD.n170 0.244562
R805 wind_comp_0.sg13g2_and2_2$1_0.VDD.n174 wind_comp_0.sg13g2_and2_2$1_0.VDD.n168 0.244562
R806 wind_comp_0.sg13g2_and2_2$1_0.VDD.n168 wind_comp_0.sg13g2_and2_2$1_0.VDD.n166 0.244562
R807 wind_comp_0.sg13g2_and2_2$1_0.VDD.n190 wind_comp_0.sg13g2_and2_2$1_0.VDD.n189 0.244562
R808 wind_comp_0.sg13g2_and2_2$1_0.VDD.n189 wind_comp_0.sg13g2_and2_2$1_0.VDD.n188 0.244562
R809 wind_comp_0.sg13g2_and2_2$1_0.VDD.n187 wind_comp_0.sg13g2_and2_2$1_0.VDD.n178 0.244562
R810 wind_comp_0.sg13g2_and2_2$1_0.VDD.n193 wind_comp_0.sg13g2_and2_2$1_0.VDD.n187 0.244562
R811 wind_comp_0.sg13g2_and2_2$1_0.VDD.n186 wind_comp_0.sg13g2_and2_2$1_0.VDD.n180 0.244562
R812 wind_comp_0.sg13g2_and2_2$1_0.VDD.n180 wind_comp_0.sg13g2_and2_2$1_0.VDD.n179 0.244562
R813 wind_comp_0.sg13g2_and2_2$1_0.VDD.n182 wind_comp_0.sg13g2_and2_2$1_0.VDD.n181 0.244562
R814 wind_comp_0.sg13g2_and2_2$1_0.VDD.n183 wind_comp_0.sg13g2_and2_2$1_0.VDD.n182 0.244562
R815 wind_comp_0.sg13g2_and2_2$1_0.VDD.n14 wind_comp_0.sg13g2_and2_2$1_0.VDD.n356 0.238833
R816 wind_comp_0.sg13g2_and2_2$1_0.VDD.n367 wind_comp_0.sg13g2_and2_2$1_0.VDD.n363 0.238833
R817 wind_comp_0.sg13g2_and2_2$1_0.VDD.n461 wind_comp_0.sg13g2_and2_2$1_0.VDD.n351 0.238833
R818 wind_comp_0.sg13g2_and2_2$1_0.VDD.n470 wind_comp_0.sg13g2_and2_2$1_0.VDD.n343 0.238833
R819 wind_comp_0.sg13g2_and2_2$1_0.VDD.n18 wind_comp_0.sg13g2_and2_2$1_0.VDD.n16 0.238833
R820 wind_comp_0.sg13g2_and2_2$1_0.VDD.n404 wind_comp_0.sg13g2_and2_2$1_0.VDD.n403 0.238833
R821 wind_comp_0.sg13g2_and2_2$1_0.VDD.n693 wind_comp_0.sg13g2_and2_2$1_0.VDD.n102 0.238833
R822 wind_comp_0.sg13g2_and2_2$1_0.VDD.n693 wind_comp_0.sg13g2_and2_2$1_0.VDD.n89 0.238833
R823 wind_comp_0.sg13g2_and2_2$1_0.VDD.n693 wind_comp_0.sg13g2_and2_2$1_0.VDD.n82 0.238833
R824 wind_comp_0.comparator_1.dynamic_pcell$2_0.SRC_NET_KL wind_comp_0.sg13g2_and2_2$1_0.VDD.n472 0.2271
R825 wind_comp_0.comparator_0.dynamic_pcell$2_0.SRC_NET_KL wind_comp_0.sg13g2_and2_2$1_0.VDD.n689 0.2271
R826 wind_comp_0.sg13g2_and2_2$1_0.VDD.n532 wind_comp_0.sg13g2_and2_2$1_0.VDD.n249 0.22295
R827 wind_comp_0.sg13g2_and2_2$1_0.VDD.n446 wind_comp_0.sg13g2_and2_2$1_0.VDD.n445 0.2205
R828 wind_comp_0.sg13g2_and2_2$1_0.VDD.n676 wind_comp_0.sg13g2_and2_2$1_0.VDD.n675 0.2205
R829 wind_comp_0.sg13g2_and2_2$1_0.VDD.n151 wind_comp_0.sg13g2_and2_2$1_0.VDD.n150 0.2205
R830 wind_comp_0.sg13g2_and2_2$1_0.VDD.n664 wind_comp_0.sg13g2_and2_2$1_0.VDD.n663 0.2205
R831 wind_comp_0.sg13g2_and2_2$1_0.VDD.n658 wind_comp_0.sg13g2_and2_2$1_0.VDD.n657 0.2205
R832 wind_comp_0.sg13g2_and2_2$1_0.VDD.n164 wind_comp_0.sg13g2_and2_2$1_0.VDD.n68 0.218834
R833 wind_comp_0.sg13g2_and2_2$1_0.VDD.n566 wind_comp_0.sg13g2_and2_2$1_0.VDD.n563 0.211333
R834 wind_comp_0.sg13g2_and2_2$1_0.VDD.n528 wind_comp_0.comparator_1.dynamic_pcell$7_0.SRC_NET_ABCD 0.195845
R835 wind_comp_0.comparator_1.dynamic_pcell$7_0.SRC_NET_ABCD wind_comp_0.sg13g2_and2_2$1_0.VDD.n525 0.195845
R836 wind_comp_0.comparator_0.dynamic_pcell$7_0.SRC_NET_ABCD wind_comp_0.sg13g2_and2_2$1_0.VDD.n177 0.195845
R837 wind_comp_0.sg13g2_and2_2$1_0.VDD.n610 wind_comp_0.comparator_0.dynamic_pcell$7_0.SRC_NET_ABCD 0.195845
R838 wind_comp_0.sg13g2_and2_2$1_0.VDD.n655 wind_comp_0.sg13g2_and2_2$1_0.VDD.n131 0.195512
R839 wind_comp_0.sg13g2_and2_2$1_0.VDD.n430 wind_comp_0.sg13g2_and2_2$1_0.VDD.n429 0.195092
R840 wind_comp_0.sg13g2_and2_2$1_0.VDD.n420 wind_comp_0.sg13g2_and2_2$1_0.VDD.n419 0.195092
R841 wind_comp_0.sg13g2_and2_2$1_0.VDD.n695 wind_comp_0.sg13g2_and2_2$1_0.VDD.n81 0.194752
R842 wind_comp_0.sg13g2_and2_2$1_0.VDD.n556 wind_comp_0.sg13g2_and2_2$1_0.VDD.n555 0.191425
R843 wind_comp_0.sg13g2_and2_2$1_0.VDD.n559 wind_comp_0.sg13g2_and2_2$1_0.VDD.n558 0.191086
R844 wind_comp_0.sg13g2_and2_2$1_0.VDD.n673 wind_comp_0.sg13g2_and2_2$1_0.VDD.n672 0.186654
R845 wind_comp_0.sg13g2_and2_2$1_0.VDD.n673 wind_comp_0.sg13g2_and2_2$1_0.VDD.n671 0.186654
R846 wind_comp_0.sg13g2_and2_2$1_0.VDD.n108 wind_comp_0.sg13g2_and2_2$1_0.VDD.n104 0.186654
R847 wind_comp_0.sg13g2_and2_2$1_0.VDD.n110 wind_comp_0.sg13g2_and2_2$1_0.VDD.n108 0.186654
R848 wind_comp_0.sg13g2_and2_2$1_0.VDD.n590 wind_comp_0.sg13g2_and2_2$1_0.VDD.n586 0.185825
R849 wind_comp_0.sg13g2_and2_2$1_0.VDD.n63 wind_comp_0.sg13g2_and2_2$1_0.VDD.n56 0.185825
R850 wind_comp_0.sg13g2_and2_2$1_0.VDD.n389 wind_comp_0.sg13g2_and2_2$1_0.VDD.n388 0.184343
R851 wind_comp_0.sg13g2_and2_2$1_0.VDD.n445 wind_comp_0.sg13g2_and2_2$1_0.VDD.n444 0.18421
R852 wind_comp_0.sg13g2_and2_2$1_0.VDD.n555 wind_comp_0.sg13g2_and2_2$1_0.VDD.n554 0.184092
R853 wind_comp_0.sg13g2_and2_2$1_0.VDD.n432 wind_comp_0.sg13g2_and2_2$1_0.VDD.n431 0.18396
R854 wind_comp_0.sg13g2_and2_2$1_0.VDD.n697 wind_comp_0.sg13g2_and2_2$1_0.VDD.n696 0.18396
R855 wind_comp_0.sg13g2_and2_2$1_0.VDD.n51 wind_comp_0.sg13g2_and2_2$1_0.VDD.n50 0.174539
R856 wind_comp_0.sg13g2_and2_2$1_0.VDD.n581 wind_comp_0.sg13g2_and2_2$1_0.VDD.n580 0.174539
R857 wind_comp_0.sg13g2_and2_2$1_0.VDD.n57 wind_comp_0.sg13g2_and2_2$1_0.VDD.n56 0.174236
R858 wind_comp_0.sg13g2_and2_2$1_0.VDD.n587 wind_comp_0.sg13g2_and2_2$1_0.VDD.n586 0.174236
R859 wind_comp_0.sg13g2_and2_2$1_0.VDD.n48 wind_comp_0.sg13g2_and2_2$1_0.VDD.n47 0.172039
R860 wind_comp_0.sg13g2_and2_2$1_0.VDD.n578 wind_comp_0.sg13g2_and2_2$1_0.VDD.n577 0.172039
R861 wind_comp_0.sg13g2_and2_2$1_0.VDD.n522 wind_comp_0.sg13g2_and2_2$1_0.VDD.n521 0.171651
R862 wind_comp_0.sg13g2_and2_2$1_0.VDD.n694 wind_comp_0.sg13g2_and2_2$1_0.VDD.n0 0.169817
R863 wind_comp_0.sg13g2_and2_2$1_0.VDD.n621 wind_comp_0.sg13g2_and2_2$1_0.VDD.n167 0.169716
R864 wind_comp_0.sg13g2_and2_2$1_0.VDD.n554 wind_comp_0.sg13g2_and2_2$1_0.VDD.n553 0.169086
R865 wind_comp_0.sg13g2_and2_2$1_0.VDD.n197 wind_comp_0.sg13g2_and2_2$1_0.VDD.n167 0.168614
R866 wind_comp_0.sg13g2_and2_2$1_0.VDD.n428 wind_comp_0.sg13g2_and2_2$1_0.VDD.n375 0.167595
R867 wind_comp_0.sg13g2_and2_2$1_0.VDD.n388 wind_comp_0.sg13g2_and2_2$1_0.VDD.n378 0.167595
R868 wind_comp_0.sg13g2_and2_2$1_0.VDD.n124 wind_comp_0.sg13g2_and2_2$1_0.VDD.n114 0.167595
R869 wind_comp_0.sg13g2_and2_2$1_0.VDD.n96 wind_comp_0.sg13g2_and2_2$1_0.VDD.n90 0.167595
R870 wind_comp_0.sg13g2_and2_2$1_0.VDD.n702 wind_comp_0.sg13g2_and2_2$1_0.VDD.n76 0.167253
R871 wind_comp_0.sg13g2_and2_2$1_0.VDD.n440 wind_comp_0.sg13g2_and2_2$1_0.VDD.n373 0.167253
R872 wind_comp_0.sg13g2_and2_2$1_0.VDD.n533 wind_comp_0.sg13g2_and2_2$1_0.VDD.n522 0.166599
R873 wind_comp_0.sg13g2_and2_2$1_0.VDD.n248 wind_comp_0.sg13g2_and2_2$1_0.VDD.n247 0.1655
R874 wind_comp_0.sg13g2_and2_2$1_0.VDD.n248 wind_comp_0.sg13g2_and2_2$1_0.VDD.n240 0.1655
R875 wind_comp_0.sg13g2_and2_2$1_0.VDD.n248 wind_comp_0.sg13g2_and2_2$1_0.VDD.n233 0.1655
R876 wind_comp_0.sg13g2_and2_2$1_0.VDD.n248 wind_comp_0.sg13g2_and2_2$1_0.VDD.n232 0.1655
R877 wind_comp_0.sg13g2_and2_2$1_0.VDD.n452 wind_comp_0.sg13g2_and2_2$1_0.VDD.n451 0.1655
R878 wind_comp_0.sg13g2_and2_2$1_0.VDD.n404 wind_comp_0.sg13g2_and2_2$1_0.VDD.n396 0.1655
R879 wind_comp_0.sg13g2_and2_2$1_0.VDD.n467 wind_comp_0.sg13g2_and2_2$1_0.VDD.n344 0.1655
R880 wind_comp_0.sg13g2_and2_2$1_0.VDD.n561 wind_comp_0.sg13g2_and2_2$1_0.VDD.n323 0.1655
R881 wind_comp_0.sg13g2_and2_2$1_0.VDD.n559 wind_comp_0.sg13g2_and2_2$1_0.VDD.n330 0.1655
R882 wind_comp_0.sg13g2_and2_2$1_0.VDD.n555 wind_comp_0.sg13g2_and2_2$1_0.VDD.n332 0.1655
R883 wind_comp_0.sg13g2_and2_2$1_0.VDD.n479 wind_comp_0.sg13g2_and2_2$1_0.VDD.n339 0.1655
R884 wind_comp_0.sg13g2_and2_2$1_0.VDD.n533 wind_comp_0.sg13g2_and2_2$1_0.VDD.n519 0.1655
R885 wind_comp_0.sg13g2_and2_2$1_0.VDD.n533 wind_comp_0.sg13g2_and2_2$1_0.VDD.n512 0.1655
R886 wind_comp_0.sg13g2_and2_2$1_0.VDD.n533 wind_comp_0.sg13g2_and2_2$1_0.VDD.n505 0.1655
R887 wind_comp_0.sg13g2_and2_2$1_0.VDD.n533 wind_comp_0.sg13g2_and2_2$1_0.VDD.n504 0.1655
R888 wind_comp_0.sg13g2_and2_2$1_0.VDD.n621 wind_comp_0.sg13g2_and2_2$1_0.VDD.n620 0.1655
R889 wind_comp_0.sg13g2_and2_2$1_0.VDD.n621 wind_comp_0.sg13g2_and2_2$1_0.VDD.n174 0.1655
R890 wind_comp_0.sg13g2_and2_2$1_0.VDD.n621 wind_comp_0.sg13g2_and2_2$1_0.VDD.n166 0.1655
R891 wind_comp_0.sg13g2_and2_2$1_0.VDD.n621 wind_comp_0.sg13g2_and2_2$1_0.VDD.n165 0.1655
R892 wind_comp_0.sg13g2_and2_2$1_0.VDD.n142 wind_comp_0.sg13g2_and2_2$1_0.VDD.n141 0.1655
R893 wind_comp_0.sg13g2_and2_2$1_0.VDD.n145 wind_comp_0.sg13g2_and2_2$1_0.VDD.n144 0.1655
R894 wind_comp_0.sg13g2_and2_2$1_0.VDD.n607 wind_comp_0.sg13g2_and2_2$1_0.VDD.n193 0.1655
R895 wind_comp_0.sg13g2_and2_2$1_0.VDD.n607 wind_comp_0.sg13g2_and2_2$1_0.VDD.n186 0.1655
R896 wind_comp_0.sg13g2_and2_2$1_0.VDD.n607 wind_comp_0.sg13g2_and2_2$1_0.VDD.n179 0.1655
R897 wind_comp_0.sg13g2_and2_2$1_0.VDD.n607 wind_comp_0.sg13g2_and2_2$1_0.VDD.n178 0.1655
R898 wind_comp_0.sg13g2_and2_2$1_0.VDD.n247 wind_comp_0.sg13g2_and2_2$1_0.VDD.n246 0.161833
R899 wind_comp_0.sg13g2_and2_2$1_0.VDD.n246 wind_comp_0.sg13g2_and2_2$1_0.VDD.n242 0.161833
R900 wind_comp_0.sg13g2_and2_2$1_0.VDD.n240 wind_comp_0.sg13g2_and2_2$1_0.VDD.n239 0.161833
R901 wind_comp_0.sg13g2_and2_2$1_0.VDD.n239 wind_comp_0.sg13g2_and2_2$1_0.VDD.n235 0.161833
R902 wind_comp_0.sg13g2_and2_2$1_0.VDD.n238 wind_comp_0.sg13g2_and2_2$1_0.VDD.n233 0.161833
R903 wind_comp_0.sg13g2_and2_2$1_0.VDD.n238 wind_comp_0.sg13g2_and2_2$1_0.VDD.n237 0.161833
R904 wind_comp_0.sg13g2_and2_2$1_0.VDD.n245 wind_comp_0.sg13g2_and2_2$1_0.VDD.n232 0.161833
R905 wind_comp_0.sg13g2_and2_2$1_0.VDD.n245 wind_comp_0.sg13g2_and2_2$1_0.VDD.n244 0.161833
R906 wind_comp_0.sg13g2_and2_2$1_0.VDD.n449 wind_comp_0.sg13g2_and2_2$1_0.VDD.n448 0.161833
R907 wind_comp_0.sg13g2_and2_2$1_0.VDD.n449 wind_comp_0.sg13g2_and2_2$1_0.VDD.n446 0.161833
R908 wind_comp_0.sg13g2_and2_2$1_0.VDD.n450 wind_comp_0.sg13g2_and2_2$1_0.VDD.n355 0.161833
R909 wind_comp_0.sg13g2_and2_2$1_0.VDD.n451 wind_comp_0.sg13g2_and2_2$1_0.VDD.n450 0.161833
R910 wind_comp_0.sg13g2_and2_2$1_0.VDD.n360 wind_comp_0.sg13g2_and2_2$1_0.VDD.n356 0.161833
R911 wind_comp_0.sg13g2_and2_2$1_0.VDD.n360 wind_comp_0.sg13g2_and2_2$1_0.VDD.n359 0.161833
R912 wind_comp_0.sg13g2_and2_2$1_0.VDD.n363 wind_comp_0.sg13g2_and2_2$1_0.VDD.n361 0.161833
R913 wind_comp_0.sg13g2_and2_2$1_0.VDD.n361 wind_comp_0.sg13g2_and2_2$1_0.VDD.n357 0.161833
R914 wind_comp_0.sg13g2_and2_2$1_0.VDD.n351 wind_comp_0.sg13g2_and2_2$1_0.VDD.n350 0.161833
R915 wind_comp_0.sg13g2_and2_2$1_0.VDD.n350 wind_comp_0.sg13g2_and2_2$1_0.VDD.n346 0.161833
R916 wind_comp_0.sg13g2_and2_2$1_0.VDD.n349 wind_comp_0.sg13g2_and2_2$1_0.VDD.n343 0.161833
R917 wind_comp_0.sg13g2_and2_2$1_0.VDD.n349 wind_comp_0.sg13g2_and2_2$1_0.VDD.n348 0.161833
R918 wind_comp_0.sg13g2_and2_2$1_0.VDD.n400 wind_comp_0.sg13g2_and2_2$1_0.VDD.n16 0.161833
R919 wind_comp_0.sg13g2_and2_2$1_0.VDD.n400 wind_comp_0.sg13g2_and2_2$1_0.VDD.n399 0.161833
R920 wind_comp_0.sg13g2_and2_2$1_0.VDD.n403 wind_comp_0.sg13g2_and2_2$1_0.VDD.n401 0.161833
R921 wind_comp_0.sg13g2_and2_2$1_0.VDD.n401 wind_comp_0.sg13g2_and2_2$1_0.VDD.n397 0.161833
R922 wind_comp_0.sg13g2_and2_2$1_0.VDD.n395 wind_comp_0.sg13g2_and2_2$1_0.VDD.n391 0.161833
R923 wind_comp_0.sg13g2_and2_2$1_0.VDD.n396 wind_comp_0.sg13g2_and2_2$1_0.VDD.n395 0.161833
R924 wind_comp_0.sg13g2_and2_2$1_0.VDD.n394 wind_comp_0.sg13g2_and2_2$1_0.VDD.n393 0.161833
R925 wind_comp_0.sg13g2_and2_2$1_0.VDD.n394 wind_comp_0.sg13g2_and2_2$1_0.VDD.n344 0.161833
R926 wind_comp_0.sg13g2_and2_2$1_0.VDD.n436 wind_comp_0.sg13g2_and2_2$1_0.VDD.n435 0.161833
R927 wind_comp_0.sg13g2_and2_2$1_0.VDD.n437 wind_comp_0.sg13g2_and2_2$1_0.VDD.n436 0.161833
R928 wind_comp_0.sg13g2_and2_2$1_0.VDD.n434 wind_comp_0.sg13g2_and2_2$1_0.VDD.n374 0.161833
R929 wind_comp_0.sg13g2_and2_2$1_0.VDD.n439 wind_comp_0.sg13g2_and2_2$1_0.VDD.n374 0.161833
R930 wind_comp_0.sg13g2_and2_2$1_0.VDD.n426 wind_comp_0.sg13g2_and2_2$1_0.VDD.n377 0.161833
R931 wind_comp_0.sg13g2_and2_2$1_0.VDD.n427 wind_comp_0.sg13g2_and2_2$1_0.VDD.n426 0.161833
R932 wind_comp_0.sg13g2_and2_2$1_0.VDD.n425 wind_comp_0.sg13g2_and2_2$1_0.VDD.n424 0.161833
R933 wind_comp_0.sg13g2_and2_2$1_0.VDD.n425 wind_comp_0.sg13g2_and2_2$1_0.VDD.n422 0.161833
R934 wind_comp_0.sg13g2_and2_2$1_0.VDD.n386 wind_comp_0.sg13g2_and2_2$1_0.VDD.n380 0.161833
R935 wind_comp_0.sg13g2_and2_2$1_0.VDD.n387 wind_comp_0.sg13g2_and2_2$1_0.VDD.n386 0.161833
R936 wind_comp_0.sg13g2_and2_2$1_0.VDD.n385 wind_comp_0.sg13g2_and2_2$1_0.VDD.n384 0.161833
R937 wind_comp_0.sg13g2_and2_2$1_0.VDD.n385 wind_comp_0.sg13g2_and2_2$1_0.VDD.n382 0.161833
R938 wind_comp_0.sg13g2_and2_2$1_0.VDD.n327 wind_comp_0.sg13g2_and2_2$1_0.VDD.n323 0.161833
R939 wind_comp_0.sg13g2_and2_2$1_0.VDD.n327 wind_comp_0.sg13g2_and2_2$1_0.VDD.n326 0.161833
R940 wind_comp_0.sg13g2_and2_2$1_0.VDD.n330 wind_comp_0.sg13g2_and2_2$1_0.VDD.n328 0.161833
R941 wind_comp_0.sg13g2_and2_2$1_0.VDD.n328 wind_comp_0.sg13g2_and2_2$1_0.VDD.n324 0.161833
R942 wind_comp_0.sg13g2_and2_2$1_0.VDD.n336 wind_comp_0.sg13g2_and2_2$1_0.VDD.n332 0.161833
R943 wind_comp_0.sg13g2_and2_2$1_0.VDD.n336 wind_comp_0.sg13g2_and2_2$1_0.VDD.n335 0.161833
R944 wind_comp_0.sg13g2_and2_2$1_0.VDD.n339 wind_comp_0.sg13g2_and2_2$1_0.VDD.n337 0.161833
R945 wind_comp_0.sg13g2_and2_2$1_0.VDD.n337 wind_comp_0.sg13g2_and2_2$1_0.VDD.n333 0.161833
R946 wind_comp_0.sg13g2_and2_2$1_0.VDD.n518 wind_comp_0.sg13g2_and2_2$1_0.VDD.n514 0.161833
R947 wind_comp_0.sg13g2_and2_2$1_0.VDD.n519 wind_comp_0.sg13g2_and2_2$1_0.VDD.n518 0.161833
R948 wind_comp_0.sg13g2_and2_2$1_0.VDD.n511 wind_comp_0.sg13g2_and2_2$1_0.VDD.n507 0.161833
R949 wind_comp_0.sg13g2_and2_2$1_0.VDD.n512 wind_comp_0.sg13g2_and2_2$1_0.VDD.n511 0.161833
R950 wind_comp_0.sg13g2_and2_2$1_0.VDD.n510 wind_comp_0.sg13g2_and2_2$1_0.VDD.n509 0.161833
R951 wind_comp_0.sg13g2_and2_2$1_0.VDD.n510 wind_comp_0.sg13g2_and2_2$1_0.VDD.n505 0.161833
R952 wind_comp_0.sg13g2_and2_2$1_0.VDD.n517 wind_comp_0.sg13g2_and2_2$1_0.VDD.n516 0.161833
R953 wind_comp_0.sg13g2_and2_2$1_0.VDD.n517 wind_comp_0.sg13g2_and2_2$1_0.VDD.n504 0.161833
R954 wind_comp_0.sg13g2_and2_2$1_0.VDD.n620 wind_comp_0.sg13g2_and2_2$1_0.VDD.n619 0.161833
R955 wind_comp_0.sg13g2_and2_2$1_0.VDD.n619 wind_comp_0.sg13g2_and2_2$1_0.VDD.n615 0.161833
R956 wind_comp_0.sg13g2_and2_2$1_0.VDD.n174 wind_comp_0.sg13g2_and2_2$1_0.VDD.n173 0.161833
R957 wind_comp_0.sg13g2_and2_2$1_0.VDD.n173 wind_comp_0.sg13g2_and2_2$1_0.VDD.n169 0.161833
R958 wind_comp_0.sg13g2_and2_2$1_0.VDD.n172 wind_comp_0.sg13g2_and2_2$1_0.VDD.n166 0.161833
R959 wind_comp_0.sg13g2_and2_2$1_0.VDD.n172 wind_comp_0.sg13g2_and2_2$1_0.VDD.n171 0.161833
R960 wind_comp_0.sg13g2_and2_2$1_0.VDD.n618 wind_comp_0.sg13g2_and2_2$1_0.VDD.n165 0.161833
R961 wind_comp_0.sg13g2_and2_2$1_0.VDD.n618 wind_comp_0.sg13g2_and2_2$1_0.VDD.n617 0.161833
R962 wind_comp_0.sg13g2_and2_2$1_0.VDD.n675 wind_comp_0.sg13g2_and2_2$1_0.VDD.n674 0.161833
R963 wind_comp_0.sg13g2_and2_2$1_0.VDD.n674 wind_comp_0.sg13g2_and2_2$1_0.VDD.n669 0.161833
R964 wind_comp_0.sg13g2_and2_2$1_0.VDD.n138 wind_comp_0.sg13g2_and2_2$1_0.VDD.n112 0.161833
R965 wind_comp_0.sg13g2_and2_2$1_0.VDD.n138 wind_comp_0.sg13g2_and2_2$1_0.VDD.n137 0.161833
R966 wind_comp_0.sg13g2_and2_2$1_0.VDD.n141 wind_comp_0.sg13g2_and2_2$1_0.VDD.n139 0.161833
R967 wind_comp_0.sg13g2_and2_2$1_0.VDD.n139 wind_comp_0.sg13g2_and2_2$1_0.VDD.n135 0.161833
R968 wind_comp_0.sg13g2_and2_2$1_0.VDD.n107 wind_comp_0.sg13g2_and2_2$1_0.VDD.n106 0.161833
R969 wind_comp_0.sg13g2_and2_2$1_0.VDD.n107 wind_comp_0.sg13g2_and2_2$1_0.VDD.n102 0.161833
R970 wind_comp_0.sg13g2_and2_2$1_0.VDD.n121 wind_comp_0.sg13g2_and2_2$1_0.VDD.n120 0.161833
R971 wind_comp_0.sg13g2_and2_2$1_0.VDD.n121 wind_comp_0.sg13g2_and2_2$1_0.VDD.n118 0.161833
R972 wind_comp_0.sg13g2_and2_2$1_0.VDD.n123 wind_comp_0.sg13g2_and2_2$1_0.VDD.n122 0.161833
R973 wind_comp_0.sg13g2_and2_2$1_0.VDD.n122 wind_comp_0.sg13g2_and2_2$1_0.VDD.n116 0.161833
R974 wind_comp_0.sg13g2_and2_2$1_0.VDD.n683 wind_comp_0.sg13g2_and2_2$1_0.VDD.n679 0.161833
R975 wind_comp_0.sg13g2_and2_2$1_0.VDD.n684 wind_comp_0.sg13g2_and2_2$1_0.VDD.n683 0.161833
R976 wind_comp_0.sg13g2_and2_2$1_0.VDD.n682 wind_comp_0.sg13g2_and2_2$1_0.VDD.n681 0.161833
R977 wind_comp_0.sg13g2_and2_2$1_0.VDD.n682 wind_comp_0.sg13g2_and2_2$1_0.VDD.n113 0.161833
R978 wind_comp_0.sg13g2_and2_2$1_0.VDD.n699 wind_comp_0.sg13g2_and2_2$1_0.VDD.n698 0.161833
R979 wind_comp_0.sg13g2_and2_2$1_0.VDD.n699 wind_comp_0.sg13g2_and2_2$1_0.VDD.n80 0.161833
R980 wind_comp_0.sg13g2_and2_2$1_0.VDD.n701 wind_comp_0.sg13g2_and2_2$1_0.VDD.n700 0.161833
R981 wind_comp_0.sg13g2_and2_2$1_0.VDD.n700 wind_comp_0.sg13g2_and2_2$1_0.VDD.n78 0.161833
R982 wind_comp_0.sg13g2_and2_2$1_0.VDD.n97 wind_comp_0.sg13g2_and2_2$1_0.VDD.n95 0.161833
R983 wind_comp_0.sg13g2_and2_2$1_0.VDD.n95 wind_comp_0.sg13g2_and2_2$1_0.VDD.n94 0.161833
R984 wind_comp_0.sg13g2_and2_2$1_0.VDD.n99 wind_comp_0.sg13g2_and2_2$1_0.VDD.n91 0.161833
R985 wind_comp_0.sg13g2_and2_2$1_0.VDD.n93 wind_comp_0.sg13g2_and2_2$1_0.VDD.n91 0.161833
R986 wind_comp_0.sg13g2_and2_2$1_0.VDD.n149 wind_comp_0.sg13g2_and2_2$1_0.VDD.n134 0.161833
R987 wind_comp_0.sg13g2_and2_2$1_0.VDD.n150 wind_comp_0.sg13g2_and2_2$1_0.VDD.n149 0.161833
R988 wind_comp_0.sg13g2_and2_2$1_0.VDD.n148 wind_comp_0.sg13g2_and2_2$1_0.VDD.n147 0.161833
R989 wind_comp_0.sg13g2_and2_2$1_0.VDD.n148 wind_comp_0.sg13g2_and2_2$1_0.VDD.n145 0.161833
R990 wind_comp_0.sg13g2_and2_2$1_0.VDD.n88 wind_comp_0.sg13g2_and2_2$1_0.VDD.n84 0.161833
R991 wind_comp_0.sg13g2_and2_2$1_0.VDD.n89 wind_comp_0.sg13g2_and2_2$1_0.VDD.n88 0.161833
R992 wind_comp_0.sg13g2_and2_2$1_0.VDD.n87 wind_comp_0.sg13g2_and2_2$1_0.VDD.n86 0.161833
R993 wind_comp_0.sg13g2_and2_2$1_0.VDD.n87 wind_comp_0.sg13g2_and2_2$1_0.VDD.n82 0.161833
R994 wind_comp_0.sg13g2_and2_2$1_0.VDD.n662 wind_comp_0.sg13g2_and2_2$1_0.VDD.n128 0.161833
R995 wind_comp_0.sg13g2_and2_2$1_0.VDD.n663 wind_comp_0.sg13g2_and2_2$1_0.VDD.n662 0.161833
R996 wind_comp_0.sg13g2_and2_2$1_0.VDD.n661 wind_comp_0.sg13g2_and2_2$1_0.VDD.n660 0.161833
R997 wind_comp_0.sg13g2_and2_2$1_0.VDD.n661 wind_comp_0.sg13g2_and2_2$1_0.VDD.n658 0.161833
R998 wind_comp_0.sg13g2_and2_2$1_0.VDD.n192 wind_comp_0.sg13g2_and2_2$1_0.VDD.n188 0.161833
R999 wind_comp_0.sg13g2_and2_2$1_0.VDD.n193 wind_comp_0.sg13g2_and2_2$1_0.VDD.n192 0.161833
R1000 wind_comp_0.sg13g2_and2_2$1_0.VDD.n185 wind_comp_0.sg13g2_and2_2$1_0.VDD.n181 0.161833
R1001 wind_comp_0.sg13g2_and2_2$1_0.VDD.n186 wind_comp_0.sg13g2_and2_2$1_0.VDD.n185 0.161833
R1002 wind_comp_0.sg13g2_and2_2$1_0.VDD.n184 wind_comp_0.sg13g2_and2_2$1_0.VDD.n183 0.161833
R1003 wind_comp_0.sg13g2_and2_2$1_0.VDD.n184 wind_comp_0.sg13g2_and2_2$1_0.VDD.n179 0.161833
R1004 wind_comp_0.sg13g2_and2_2$1_0.VDD.n191 wind_comp_0.sg13g2_and2_2$1_0.VDD.n190 0.161833
R1005 wind_comp_0.sg13g2_and2_2$1_0.VDD.n191 wind_comp_0.sg13g2_and2_2$1_0.VDD.n178 0.161833
R1006 wind_comp_0.sg13g2_and2_2$1_0.VDD.n685 wind_comp_0.sg13g2_and2_2$1_0.VDD.n677 0.16001
R1007 wind_comp_0.sg13g2_and2_2$1_0.VDD.n53 wind_comp_0.sg13g2_and2_2$1_0.VDD.n52 0.159539
R1008 wind_comp_0.sg13g2_and2_2$1_0.VDD.n583 wind_comp_0.sg13g2_and2_2$1_0.VDD.n582 0.159539
R1009 wind_comp_0.sg13g2_and2_2$1_0.VDD.n46 wind_comp_0.sg13g2_and2_2$1_0.VDD.n45 0.157039
R1010 wind_comp_0.sg13g2_and2_2$1_0.VDD.n576 wind_comp_0.sg13g2_and2_2$1_0.VDD.n575 0.157039
R1011 wind_comp_0.sg13g2_and2_2$1_0.VDD.n418 wind_comp_0.sg13g2_and2_2$1_0.VDD.n13 0.15623
R1012 wind_comp_0.sg13g2_and2_2$1_0.VDD.n352 wind_comp_0.sg13g2_and2_2$1_0.VDD.n13 0.15623
R1013 wind_comp_0.sg13g2_and2_2$1_0.VDD.n697 wind_comp_0.sg13g2_and2_2$1_0.VDD.n76 0.148273
R1014 wind_comp_0.sg13g2_and2_2$1_0.VDD.n432 wind_comp_0.sg13g2_and2_2$1_0.VDD.n373 0.148273
R1015 wind_comp_0.sg13g2_and2_2$1_0.VDD.n421 wind_comp_0.sg13g2_and2_2$1_0.VDD.n375 0.147932
R1016 wind_comp_0.sg13g2_and2_2$1_0.VDD.n381 wind_comp_0.sg13g2_and2_2$1_0.VDD.n378 0.147932
R1017 wind_comp_0.sg13g2_and2_2$1_0.VDD.n119 wind_comp_0.sg13g2_and2_2$1_0.VDD.n114 0.147932
R1018 wind_comp_0.sg13g2_and2_2$1_0.VDD.n100 wind_comp_0.sg13g2_and2_2$1_0.VDD.n90 0.147932
R1019 wind_comp_0.sg13g2_and2_2$1_0.VDD.n431 wind_comp_0.sg13g2_and2_2$1_0.VDD.n430 0.146561
R1020 wind_comp_0.sg13g2_and2_2$1_0.VDD.n696 wind_comp_0.sg13g2_and2_2$1_0.VDD.n695 0.146561
R1021 wind_comp_0.sg13g2_and2_2$1_0.VDD.n444 wind_comp_0.sg13g2_and2_2$1_0.VDD.n10 0.146306
R1022 wind_comp_0.sg13g2_and2_2$1_0.VDD.n419 wind_comp_0.sg13g2_and2_2$1_0.VDD.n389 0.146176
R1023 wind_comp_0.sg13g2_and2_2$1_0.VDD.n55 wind_comp_0.sg13g2_and2_2$1_0.VDD.n54 0.144539
R1024 wind_comp_0.sg13g2_and2_2$1_0.VDD.n585 wind_comp_0.sg13g2_and2_2$1_0.VDD.n584 0.144539
R1025 wind_comp_0.sg13g2_and2_2$1_0.VDD.n43 wind_comp_0.sg13g2_and2_2$1_0.VDD.n42 0.140457
R1026 wind_comp_0.sg13g2_and2_2$1_0.VDD.n573 wind_comp_0.sg13g2_and2_2$1_0.VDD.n572 0.140457
R1027 wind_comp_0.sg13g2_and2_2$1_0.VDD.n119 wind_comp_0.sg13g2_and2_2$1_0.VDD.n75 0.136425
R1028 wind_comp_0.sg13g2_and2_2$1_0.VDD.n96 wind_comp_0.sg13g2_and2_2$1_0.VDD.n81 0.136425
R1029 wind_comp_0.sg13g2_and2_2$1_0.VDD.n429 wind_comp_0.sg13g2_and2_2$1_0.VDD.n428 0.136086
R1030 wind_comp_0.sg13g2_and2_2$1_0.VDD.n421 wind_comp_0.sg13g2_and2_2$1_0.VDD.n420 0.136086
R1031 wind_comp_0.sg13g2_and2_2$1_0.VDD.n49 wind_comp_0.sg13g2_and2_2$1_0.VDD.n48 0.129575
R1032 wind_comp_0.sg13g2_and2_2$1_0.VDD.n59 wind_comp_0.sg13g2_and2_2$1_0.VDD.n58 0.129539
R1033 wind_comp_0.sg13g2_and2_2$1_0.VDD.n589 wind_comp_0.sg13g2_and2_2$1_0.VDD.n588 0.129539
R1034 wind_comp_0.comparator_1.dynamic_pcell$7_0.VDD wind_comp_0.sg13g2_and2_2$1_0.VDD.n249 0.129288
R1035 wind_comp_0.comparator_0.dynamic_pcell_0.VDD wind_comp_0.sg13g2_and2_2$1_0.VDD.n68 0.129288
R1036 wind_comp_0.sg13g2_and2_2$1_0.VDD.n579 wind_comp_0.sg13g2_and2_2$1_0.VDD.n578 0.129236
R1037 wind_comp_0.sg13g2_and2_2$1_0.VDD.n580 wind_comp_0.sg13g2_and2_2$1_0.VDD.n579 0.127075
R1038 wind_comp_0.sg13g2_and2_2$1_0.VDD.n707 wind_comp_0.sg13g2_and2_2$1_0.VDD.n706 0.127039
R1039 wind_comp_0.sg13g2_and2_2$1_0.VDD.n59 wind_comp_0.sg13g2_and2_2$1_0.VDD.n57 0.127039
R1040 wind_comp_0.sg13g2_and2_2$1_0.VDD.n569 wind_comp_0.sg13g2_and2_2$1_0.VDD.n568 0.127039
R1041 wind_comp_0.sg13g2_and2_2$1_0.VDD.n589 wind_comp_0.sg13g2_and2_2$1_0.VDD.n587 0.127039
R1042 wind_comp_0.sg13g2_and2_2$1_0.VDD.n50 wind_comp_0.sg13g2_and2_2$1_0.VDD.n49 0.126736
R1043 wind_comp_0.sg13g2_and2_2$1_0.VDD.n65 wind_comp_0.sg13g2_and2_2$1_0.VDD.n42 0.125625
R1044 wind_comp_0.sg13g2_and2_2$1_0.VDD.n572 wind_comp_0.sg13g2_and2_2$1_0.VDD.n571 0.125625
R1045 wind_comp_0.comparator_1.dynamic_pcell$7_0.VDD wind_comp_0.sg13g2_and2_2$1_0.VDD.n17 0.124588
R1046 wind_comp_0.comparator_0.dynamic_pcell_0.VDD wind_comp_0.sg13g2_and2_2$1_0.VDD.n72 0.124588
R1047 wind_comp_0.sg13g2_and2_2$1_0.VDD.n101 wind_comp_0.sg13g2_and2_2$1_0.VDD.n0 0.121082
R1048 wind_comp_0.sg13g2_and2_2$1_0.VDD.n706 wind_comp_0.sg13g2_and2_2$1_0.VDD.n67 0.114539
R1049 wind_comp_0.sg13g2_and2_2$1_0.VDD.n568 wind_comp_0.sg13g2_and2_2$1_0.VDD.n567 0.114539
R1050 wind_comp_0.sg13g2_and2_2$1_0.VDD.n340 wind_comp_0.sg13g2_and2_2$1_0.VDD.n13 0.114352
R1051 wind_comp_0.sg13g2_and2_2$1_0.VDD.n58 wind_comp_0.sg13g2_and2_2$1_0.VDD.n55 0.112039
R1052 wind_comp_0.sg13g2_and2_2$1_0.VDD.n588 wind_comp_0.sg13g2_and2_2$1_0.VDD.n585 0.112039
R1053 wind_comp_0.sg13g2_and2_2$1_0.VDD.n441 wind_comp_0.sg13g2_and2_2$1_0.VDD.n13 0.111824
R1054 wind_comp_0.sg13g2_and2_2$1_0.VDD.n563 wind_comp_0.comparator_1.sg13cmos5l_inv_16_1.VDD 0.107041
R1055 wind_comp_0.sg13g2_and2_2$1_0.VDD.n54 wind_comp_0.sg13g2_and2_2$1_0.VDD.n53 0.097039
R1056 wind_comp_0.sg13g2_and2_2$1_0.VDD.n584 wind_comp_0.sg13g2_and2_2$1_0.VDD.n583 0.097039
R1057 wind_comp_0.sg13g2_and2_2$1_0.VDD.n655 wind_comp_0.sg13g2_and2_2$1_0.VDD.n152 0.092439
R1058 wind_comp_0.sg13g2_and2_2$1_0.VDD.n655 wind_comp_0.sg13g2_and2_2$1_0.VDD.n129 0.092439
R1059 wind_comp_0.comparator_1.dynamic_pcell$7_0.VDD wind_comp_0.sg13g2_and2_2$1_0.VDD.n13 0.0881289
R1060 wind_comp_0.sg13g2_and2_2$1_0.VDD.n47 wind_comp_0.sg13g2_and2_2$1_0.VDD.n46 0.084539
R1061 wind_comp_0.sg13g2_and2_2$1_0.VDD.n577 wind_comp_0.sg13g2_and2_2$1_0.VDD.n576 0.084539
R1062 wind_comp_0.sg13g2_and2_2$1_0.VDD.n67 wind_comp_0.sg13g2_and2_2$1_0.VDD.n66 0.082039
R1063 wind_comp_0.sg13g2_and2_2$1_0.VDD.n52 wind_comp_0.sg13g2_and2_2$1_0.VDD.n51 0.082039
R1064 wind_comp_0.sg13g2_and2_2$1_0.VDD.n570 wind_comp_0.sg13g2_and2_2$1_0.VDD.n567 0.082039
R1065 wind_comp_0.sg13g2_and2_2$1_0.VDD.n582 wind_comp_0.sg13g2_and2_2$1_0.VDD.n581 0.082039
R1066 wind_comp_0.sg13g2_and2_2$1_0.VDD.n125 wind_comp_0.sg13g2_and2_2$1_0.VDD.n0 0.0818395
R1067 wind_comp_0.sg13g2_and2_2$1_0.VDD.n66 wind_comp_0.comparator_0.sg13cmos5l_inv_16_0.VDD 0.0808371
R1068 wind_comp_0.sg13g2_and2_2$1_0.VDD.n30 wind_comp_0.sg13g2_and2_2$1_0.VDD.n29 0.0749924
R1069 wind_comp_0.sg13g2_and2_2$1_0.VDD.n152 wind_comp_0.sg13g2_and2_2$1_0.VDD.n151 0.0741056
R1070 wind_comp_0.sg13g2_and2_2$1_0.VDD.n657 wind_comp_0.sg13g2_and2_2$1_0.VDD.n129 0.0741056
R1071 wind_comp_0.sg13g2_and2_2$1_0.VDD.n708 wind_comp_0.sg13g2_and2_2$1_0.VDD.n707 0.070789
R1072 wind_comp_0.sg13g2_and2_2$1_0.VDD.n569 wind_comp_0.sg13g2_and2_2$1_0.VDD.n566 0.070789
R1073 wind_comp_0.sg13g2_and2_2$1_0.VDD.n655 wind_comp_0.sg13g2_and2_2$1_0.VDD.n154 0.0690952
R1074 wind_comp_0.sg13g2_and2_2$1_0.VDD.n45 wind_comp_0.sg13g2_and2_2$1_0.VDD.n44 0.067039
R1075 wind_comp_0.sg13g2_and2_2$1_0.VDD.n575 wind_comp_0.sg13g2_and2_2$1_0.VDD.n574 0.067039
R1076 wind_comp_0.sg13g2_and2_2$1_0.VDD.n443 wind_comp_0.sg13g2_and2_2$1_0.VDD.n442 0.0660782
R1077 wind_comp_0.sg13g2_and2_2$1_0.VDD.n604 wind_comp_0.sg13g2_and2_2$1_0.VDD.n603 0.0619929
R1078 wind_comp_0.sg13g2_and2_2$1_0.VDD.n31 wind_comp_0.sg13g2_and2_2$1_0.VDD.n30 0.0604054
R1079 wind_comp_0.sg13g2_and2_2$1_0.VDD.n37 wind_comp_0.sg13g2_and2_2$1_0.VDD.n36 0.060239
R1080 wind_comp_0.sg13g2_and2_2$1_0.VDD.n286 wind_comp_0.sg13g2_and2_2$1_0.VDD.n285 0.0596905
R1081 wind_comp_0.sg13g2_and2_2$1_0.VDD.n33 wind_comp_0.sg13g2_and2_2$1_0.VDD.n28 0.0593862
R1082 wind_comp_0.sg13g2_and2_2$1_0.VDD.n64 wind_comp_0.sg13g2_and2_2$1_0.VDD.n63 0.0555
R1083 wind_comp_0.sg13g2_and2_2$1_0.VDD.n591 wind_comp_0.sg13g2_and2_2$1_0.VDD.n590 0.0555
R1084 wind_comp_0.sg13g2_and2_2$1_0.VDD.n693 wind_comp_0.sg13g2_and2_2$1_0.VDD.n3 0.61214
R1085 wind_comp_0.sg13g2_and2_2$1_0.VDD.n39 wind_comp_0.sg13g2_and2_2$1_0.VDD.n38 0.0551227
R1086 wind_comp_0.sg13g2_and2_2$1_0.VDD.n287 wind_comp_0.sg13g2_and2_2$1_0.VDD.n286 0.0540857
R1087 wind_comp_0.sg13g2_and2_2$1_0.VDD.n692 wind_comp_0.sg13g2_and2_2$1_0.VDD.n19 0.0531807
R1088 wind_comp_0.sg13g2_and2_2$1_0.VDD.n605 wind_comp_0.sg13g2_and2_2$1_0.VDD.n604 0.0517991
R1089 wind_comp_0.sg13g2_and2_2$1_0.VDD.n41 wind_comp_0.sg13g2_and2_2$1_0.VDD.n40 0.0500064
R1090 wind_comp_0.sg13g2_and2_2$1_0.VDD.n599 wind_comp_0.sg13g2_and2_2$1_0.VDD.n597 0.0472221
R1091 wind_comp_0.sg13g2_and2_2$1_0.VDD.n194 wind_comp_0.sg13g2_and2_2$1_0.VDD.n64 0.0455
R1092 wind_comp_0.sg13g2_and2_2$1_0.VDD.n592 wind_comp_0.sg13g2_and2_2$1_0.VDD.n591 0.0455
R1093 wind_comp_0.sg13g2_and2_2$1_0.VDD.n692 wind_comp_0.sg13g2_and2_2$1_0.VDD.n103 0.0451237
R1094 wind_comp_0.sg13g2_and2_2$1_0.VDD.n32 wind_comp_0.sg13g2_and2_2$1_0.VDD.n31 0.0444638
R1095 wind_comp_0.sg13g2_and2_2$1_0.VDD.n194 wind_comp_0.comparator_0.sg13g2_inv_1_0.VDD 0.0441207
R1096 wind_comp_0.sg13g2_and2_2$1_0.VDD.n601 wind_comp_0.sg13g2_and2_2$1_0.VDD.n4 0.0434812
R1097 wind_comp_0.sg13g2_and2_2$1_0.VDD.n32 wind_comp_0.comparator_0.sg13cmos5l_inv_16_1.VDD 0.0419056
R1098 wind_comp_0.sg13g2_and2_2$1_0.VDD.n41 wind_comp_0.sg13g2_and2_2$1_0.VDD.n27 0.0389211
R1099 wind_comp_0.sg13g2_and2_2$1_0.VDD.n258 wind_comp_0.sg13g2_and2_2$1_0.VDD.n257 0.034834
R1100 wind_comp_0.sg13g2_and2_2$1_0.VDD.n205 wind_comp_0.sg13g2_and2_2$1_0.VDD.n204 0.034834
R1101 wind_comp_0.sg13g2_and2_2$1_0.VDD.n656 wind_comp_0.sg13g2_and2_2$1_0.VDD.n655 0.0347952
R1102 wind_comp_0.sg13g2_and2_2$1_0.VDD.n40 wind_comp_0.sg13g2_and2_2$1_0.VDD.n39 0.0338049
R1103 wind_comp_0.sg13g2_and2_2$1_0.VDD.n666 wind_comp_0.sg13g2_and2_2$1_0.VDD.n34 0.0337558
R1104 wind_comp_0.sg13g2_and2_2$1_0.VDD.n279 wind_comp_0.sg13g2_and2_2$1_0.VDD.n278 0.0331417
R1105 wind_comp_0.sg13g2_and2_2$1_0.VDD.n226 wind_comp_0.sg13g2_and2_2$1_0.VDD.n225 0.0331417
R1106 wind_comp_0.sg13g2_and2_2$1_0.VDD.n259 wind_comp_0.sg13g2_and2_2$1_0.VDD.n258 0.0327834
R1107 wind_comp_0.sg13g2_and2_2$1_0.VDD.n206 wind_comp_0.sg13g2_and2_2$1_0.VDD.n205 0.0327834
R1108 wind_comp_0.sg13g2_and2_2$1_0.VDD.n66 wind_comp_0.sg13g2_and2_2$1_0.VDD.n65 0.0326348
R1109 wind_comp_0.sg13g2_and2_2$1_0.VDD.n44 wind_comp_0.sg13g2_and2_2$1_0.VDD.n43 0.0326348
R1110 wind_comp_0.sg13g2_and2_2$1_0.VDD.n574 wind_comp_0.sg13g2_and2_2$1_0.VDD.n573 0.0326348
R1111 wind_comp_0.sg13g2_and2_2$1_0.VDD.n571 wind_comp_0.sg13g2_and2_2$1_0.VDD.n570 0.0326348
R1112 wind_comp_0.sg13g2_and2_2$1_0.VDD.n655 wind_comp_0.sg13g2_and2_2$1_0.VDD.n132 0.030526
R1113 wind_comp_0.sg13g2_and2_2$1_0.VDD.n280 wind_comp_0.sg13g2_and2_2$1_0.VDD.n279 0.0302449
R1114 wind_comp_0.sg13g2_and2_2$1_0.VDD.n281 wind_comp_0.sg13g2_and2_2$1_0.VDD.n280 0.0302449
R1115 wind_comp_0.sg13g2_and2_2$1_0.VDD.n228 wind_comp_0.sg13g2_and2_2$1_0.VDD.n227 0.0302449
R1116 wind_comp_0.sg13g2_and2_2$1_0.VDD.n227 wind_comp_0.sg13g2_and2_2$1_0.VDD.n226 0.0302449
R1117 wind_comp_0.sg13g2_and2_2$1_0.VDD.n29 wind_comp_0.sg13g2_and2_2$1_0.VDD.n28 0.0295413
R1118 wind_comp_0.sg13g2_and2_2$1_0.VDD.n606 wind_comp_0.sg13g2_and2_2$1_0.VDD.n605 0.0291366
R1119 wind_comp_0.sg13g2_and2_2$1_0.VDD.n666 wind_comp_0.sg13g2_and2_2$1_0.VDD.n35 0.0291149
R1120 wind_comp_0.sg13g2_and2_2$1_0.VDD.n288 wind_comp_0.sg13g2_and2_2$1_0.VDD.n287 0.0287605
R1121 wind_comp_0.sg13g2_and2_2$1_0.VDD.n38 wind_comp_0.sg13g2_and2_2$1_0.VDD.n37 0.0286886
R1122 wind_comp_0.sg13g2_and2_2$1_0.VDD.n288 wind_comp_0.sg13g2_and2_2$1_0.VDD.n248 0.0257628
R1123 wind_comp_0.sg13g2_and2_2$1_0.VDD.n535 wind_comp_0.sg13g2_and2_2$1_0.VDD.n534 0.0254134
R1124 wind_comp_0.sg13g2_and2_2$1_0.VDD.n607 wind_comp_0.sg13g2_and2_2$1_0.VDD.n606 0.0253871
R1125 wind_comp_0.sg13g2_and2_2$1_0.VDD.n36 wind_comp_0.sg13g2_and2_2$1_0.VDD.n35 0.0235723
R1126 wind_comp_0.sg13g2_and2_2$1_0.VDD.n269 wind_comp_0.sg13g2_and2_2$1_0.VDD.n268 0.0233462
R1127 wind_comp_0.sg13g2_and2_2$1_0.VDD.n267 wind_comp_0.sg13g2_and2_2$1_0.VDD.n266 0.0233462
R1128 wind_comp_0.sg13g2_and2_2$1_0.VDD.n265 wind_comp_0.sg13g2_and2_2$1_0.VDD.n264 0.0233462
R1129 wind_comp_0.sg13g2_and2_2$1_0.VDD.n263 wind_comp_0.sg13g2_and2_2$1_0.VDD.n262 0.0233462
R1130 wind_comp_0.sg13g2_and2_2$1_0.VDD.n261 wind_comp_0.sg13g2_and2_2$1_0.VDD.n260 0.0233462
R1131 wind_comp_0.sg13g2_and2_2$1_0.VDD.n208 wind_comp_0.sg13g2_and2_2$1_0.VDD.n207 0.0233462
R1132 wind_comp_0.sg13g2_and2_2$1_0.VDD.n210 wind_comp_0.sg13g2_and2_2$1_0.VDD.n209 0.0233462
R1133 wind_comp_0.sg13g2_and2_2$1_0.VDD.n212 wind_comp_0.sg13g2_and2_2$1_0.VDD.n211 0.0233462
R1134 wind_comp_0.sg13g2_and2_2$1_0.VDD.n214 wind_comp_0.sg13g2_and2_2$1_0.VDD.n213 0.0233462
R1135 wind_comp_0.sg13g2_and2_2$1_0.VDD.n216 wind_comp_0.sg13g2_and2_2$1_0.VDD.n215 0.0233462
R1136 wind_comp_0.sg13g2_and2_2$1_0.VDD.n8 wind_comp_0.sg13g2_and2_2$1_0.VDD.n7 0.0124074
R1137 wind_comp_0.sg13g2_and2_2$1_0.VDD.n151 wind_comp_0.sg13g2_and2_2$1_0.VDD.n132 0.0231993
R1138 wind_comp_0.sg13g2_and2_2$1_0.VDD.n315 wind_comp_0.sg13g2_and2_2$1_0.VDD.n314 0.0219465
R1139 wind_comp_0.sg13g2_and2_2$1_0.VDD.n311 wind_comp_0.sg13g2_and2_2$1_0.VDD.n310 0.0219465
R1140 wind_comp_0.sg13g2_and2_2$1_0.VDD.n260 wind_comp_0.sg13g2_and2_2$1_0.VDD.n259 0.0212955
R1141 wind_comp_0.sg13g2_and2_2$1_0.VDD.n207 wind_comp_0.sg13g2_and2_2$1_0.VDD.n206 0.0212955
R1142 wind_comp_0.sg13g2_and2_2$1_0.VDD.n708 wind_comp_0.sg13g2_and2_2$1_0.VDD.n27 0.0205388
R1143 wind_comp_0.sg13g2_and2_2$1_0.VDD.n317 wind_comp_0.sg13g2_and2_2$1_0.VDD.n316 0.0203629
R1144 wind_comp_0.sg13g2_and2_2$1_0.VDD.n256 wind_comp_0.sg13g2_and2_2$1_0.VDD.n255 0.0199615
R1145 wind_comp_0.sg13g2_and2_2$1_0.VDD.n254 wind_comp_0.sg13g2_and2_2$1_0.VDD.n253 0.0199615
R1146 wind_comp_0.sg13g2_and2_2$1_0.VDD.n520 wind_comp_0.sg13g2_and2_2$1_0.VDD.n252 0.0199615
R1147 wind_comp_0.sg13g2_and2_2$1_0.VDD.n199 wind_comp_0.sg13g2_and2_2$1_0.VDD.n198 0.0199615
R1148 wind_comp_0.sg13g2_and2_2$1_0.VDD.n201 wind_comp_0.sg13g2_and2_2$1_0.VDD.n200 0.0199615
R1149 wind_comp_0.sg13g2_and2_2$1_0.VDD.n203 wind_comp_0.sg13g2_and2_2$1_0.VDD.n202 0.0199615
R1150 wind_comp_0.sg13g2_and2_2$1_0.VDD.n655 wind_comp_0.sg13g2_and2_2$1_0.VDD.n654 0.0194233
R1151 wind_comp_0.sg13g2_and2_2$1_0.VDD.n297 wind_comp_0.sg13g2_and2_2$1_0.VDD.n296 0.0191792
R1152 wind_comp_0.sg13g2_and2_2$1_0.VDD.n321 wind_comp_0.sg13g2_and2_2$1_0.VDD.n320 0.0189793
R1153 wind_comp_0.sg13g2_and2_2$1_0.VDD.n305 wind_comp_0.sg13g2_and2_2$1_0.VDD.n304 0.0189793
R1154 wind_comp_0.sg13g2_and2_2$1_0.VDD.n309 wind_comp_0.sg13g2_and2_2$1_0.VDD.n308 0.0186334
R1155 wind_comp_0.sg13g2_and2_2$1_0.VDD.n277 wind_comp_0.sg13g2_and2_2$1_0.VDD.n276 0.0182692
R1156 wind_comp_0.sg13g2_and2_2$1_0.VDD.n275 wind_comp_0.sg13g2_and2_2$1_0.VDD.n274 0.0182692
R1157 wind_comp_0.sg13g2_and2_2$1_0.VDD.n273 wind_comp_0.sg13g2_and2_2$1_0.VDD.n272 0.0182692
R1158 wind_comp_0.sg13g2_and2_2$1_0.VDD.n271 wind_comp_0.sg13g2_and2_2$1_0.VDD.n270 0.0182692
R1159 wind_comp_0.sg13g2_and2_2$1_0.VDD.n218 wind_comp_0.sg13g2_and2_2$1_0.VDD.n217 0.0182692
R1160 wind_comp_0.sg13g2_and2_2$1_0.VDD.n220 wind_comp_0.sg13g2_and2_2$1_0.VDD.n219 0.0182692
R1161 wind_comp_0.sg13g2_and2_2$1_0.VDD.n222 wind_comp_0.sg13g2_and2_2$1_0.VDD.n221 0.0182692
R1162 wind_comp_0.sg13g2_and2_2$1_0.VDD.n224 wind_comp_0.sg13g2_and2_2$1_0.VDD.n223 0.0182692
R1163 wind_comp_0.sg13g2_and2_2$1_0.VDD.n302 wind_comp_0.sg13g2_and2_2$1_0.VDD.n301 0.0181415
R1164 wind_comp_0.sg13g2_and2_2$1_0.VDD.n6 wind_comp_0.sg13g2_and2_2$1_0.VDD.n299 0.0181415
R1165 wind_comp_0.sg13g2_and2_2$1_0.VDD.n320 wind_comp_0.sg13g2_and2_2$1_0.VDD.n319 0.0177956
R1166 wind_comp_0.sg13g2_and2_2$1_0.VDD.n306 wind_comp_0.sg13g2_and2_2$1_0.VDD.n305 0.0177956
R1167 wind_comp_0.sg13g2_and2_2$1_0.VDD.n296 wind_comp_0.sg13g2_and2_2$1_0.VDD.n295 0.0175956
R1168 wind_comp_0.sg13g2_and2_2$1_0.VDD.n295 wind_comp_0.sg13g2_and2_2$1_0.VDD.n294 0.0175956
R1169 wind_comp_0.sg13g2_and2_2$1_0.VDD.n648 wind_comp_0.sg13g2_and2_2$1_0.VDD.n622 0.0175173
R1170 wind_comp_0.sg13g2_and2_2$1_0.VDD.n282 wind_comp_0.sg13g2_and2_2$1_0.VDD.n248 0.0165769
R1171 wind_comp_0.sg13g2_and2_2$1_0.VDD.n607 wind_comp_0.sg13g2_and2_2$1_0.VDD.n229 0.0165769
R1172 wind_comp_0.sg13g2_and2_2$1_0.VDD.n307 wind_comp_0.sg13g2_and2_2$1_0.VDD.n306 0.0164119
R1173 wind_comp_0.sg13g2_and2_2$1_0.VDD.n322 wind_comp_0.sg13g2_and2_2$1_0.VDD.n321 0.016212
R1174 wind_comp_0.sg13g2_and2_2$1_0.VDD.n304 wind_comp_0.sg13g2_and2_2$1_0.VDD.n303 0.016212
R1175 wind_comp_0.sg13g2_and2_2$1_0.VDD.n592 wind_comp_0.comparator_1.sg13g2_inv_1_0.VDD 0.0155
R1176 wind_comp_0.sg13g2_and2_2$1_0.VDD.n282 wind_comp_0.sg13g2_and2_2$1_0.VDD.n281 0.0153725
R1177 wind_comp_0.sg13g2_and2_2$1_0.VDD.n229 wind_comp_0.sg13g2_and2_2$1_0.VDD.n228 0.0153725
R1178 wind_comp_0.sg13g2_and2_2$1_0.VDD.n298 wind_comp_0.sg13g2_and2_2$1_0.VDD.n297 0.0150283
R1179 wind_comp_0.sg13g2_and2_2$1_0.VDD.n294 wind_comp_0.sg13g2_and2_2$1_0.VDD.n293 0.0150283
R1180 wind_comp_0.sg13g2_and2_2$1_0.VDD.n292 wind_comp_0.sg13g2_and2_2$1_0.VDD.n291 0.0150283
R1181 wind_comp_0.sg13g2_and2_2$1_0.VDD.n316 wind_comp_0.sg13g2_and2_2$1_0.VDD.n315 0.0148283
R1182 wind_comp_0.sg13g2_and2_2$1_0.VDD.n310 wind_comp_0.sg13g2_and2_2$1_0.VDD.n309 0.0148283
R1183 wind_comp_0.sg13g2_and2_2$1_0.VDD.n602 wind_comp_0.sg13g2_and2_2$1_0.VDD.n60 0.0142742
R1184 wind_comp_0.sg13g2_and2_2$1_0.VDD.n290 wind_comp_0.sg13g2_and2_2$1_0.VDD.n284 0.0142742
R1185 wind_comp_0.sg13g2_and2_2$1_0.VDD.n301 wind_comp_0.sg13g2_and2_2$1_0.VDD.n300 0.0136447
R1186 wind_comp_0.sg13g2_and2_2$1_0.VDD.n442 wind_comp_0.sg13g2_and2_2$1_0.VDD.n11 0.0107798
R1187 wind_comp_0.sg13g2_and2_2$1_0.VDD.n142 wind_comp_0.sg13g2_and2_2$1_0.VDD.n103 0.0126997
R1188 wind_comp_0.sg13g2_and2_2$1_0.VDD.n312 wind_comp_0.sg13g2_and2_2$1_0.VDD.n311 0.012261
R1189 wind_comp_0.sg13g2_and2_2$1_0.VDD.n553 wind_comp_0.sg13g2_and2_2$1_0.VDD.n552 0.0115272
R1190 wind_comp_0.sg13g2_and2_2$1_0.VDD.n278 wind_comp_0.sg13g2_and2_2$1_0.VDD.n277 0.0115
R1191 wind_comp_0.sg13g2_and2_2$1_0.VDD.n276 wind_comp_0.sg13g2_and2_2$1_0.VDD.n275 0.0115
R1192 wind_comp_0.sg13g2_and2_2$1_0.VDD.n274 wind_comp_0.sg13g2_and2_2$1_0.VDD.n273 0.0115
R1193 wind_comp_0.sg13g2_and2_2$1_0.VDD.n272 wind_comp_0.sg13g2_and2_2$1_0.VDD.n271 0.0115
R1194 wind_comp_0.sg13g2_and2_2$1_0.VDD.n270 wind_comp_0.sg13g2_and2_2$1_0.VDD.n269 0.0115
R1195 wind_comp_0.sg13g2_and2_2$1_0.VDD.n217 wind_comp_0.sg13g2_and2_2$1_0.VDD.n216 0.0115
R1196 wind_comp_0.sg13g2_and2_2$1_0.VDD.n219 wind_comp_0.sg13g2_and2_2$1_0.VDD.n218 0.0115
R1197 wind_comp_0.sg13g2_and2_2$1_0.VDD.n221 wind_comp_0.sg13g2_and2_2$1_0.VDD.n220 0.0115
R1198 wind_comp_0.sg13g2_and2_2$1_0.VDD.n223 wind_comp_0.sg13g2_and2_2$1_0.VDD.n222 0.0115
R1199 wind_comp_0.sg13g2_and2_2$1_0.VDD.n225 wind_comp_0.sg13g2_and2_2$1_0.VDD.n224 0.0115
R1200 wind_comp_0.sg13g2_and2_2$1_0.VDD.n300 wind_comp_0.sg13g2_and2_2$1_0.VDD.n8 0.0227848
R1201 wind_comp_0.sg13g2_and2_2$1_0.VDD.n318 wind_comp_0.sg13g2_and2_2$1_0.VDD.n317 0.0105314
R1202 wind_comp_0.sg13g2_and2_2$1_0.VDD.n257 wind_comp_0.sg13g2_and2_2$1_0.VDD.n256 0.00980769
R1203 wind_comp_0.sg13g2_and2_2$1_0.VDD.n255 wind_comp_0.sg13g2_and2_2$1_0.VDD.n254 0.00980769
R1204 wind_comp_0.sg13g2_and2_2$1_0.VDD.n253 wind_comp_0.sg13g2_and2_2$1_0.VDD.n252 0.00980769
R1205 wind_comp_0.sg13g2_and2_2$1_0.VDD.n521 wind_comp_0.sg13g2_and2_2$1_0.VDD.n520 0.00980769
R1206 wind_comp_0.sg13g2_and2_2$1_0.VDD.n198 wind_comp_0.sg13g2_and2_2$1_0.VDD.n197 0.00980769
R1207 wind_comp_0.sg13g2_and2_2$1_0.VDD.n200 wind_comp_0.sg13g2_and2_2$1_0.VDD.n199 0.00980769
R1208 wind_comp_0.sg13g2_and2_2$1_0.VDD.n202 wind_comp_0.sg13g2_and2_2$1_0.VDD.n201 0.00980769
R1209 wind_comp_0.sg13g2_and2_2$1_0.VDD.n204 wind_comp_0.sg13g2_and2_2$1_0.VDD.n203 0.00980769
R1210 wind_comp_0.sg13g2_and2_2$1_0.VDD.n70 wind_comp_0.sg13g2_and2_2$1_0.VDD.n61 0.00966667
R1211 wind_comp_0.sg13g2_and2_2$1_0.VDD.n289 wind_comp_0.sg13g2_and2_2$1_0.VDD.n250 0.00966667
R1212 wind_comp_0.sg13g2_and2_2$1_0.VDD.n299 wind_comp_0.sg13g2_and2_2$1_0.VDD.n298 0.00949371
R1213 wind_comp_0.sg13g2_and2_2$1_0.VDD.n9 wind_comp_0.sg13g2_and2_2$1_0.VDD.n291 0.00949371
R1214 wind_comp_0.sg13g2_and2_2$1_0.VDD.n290 wind_comp_0.sg13g2_and2_2$1_0.VDD.n283 0.00921669
R1215 wind_comp_0.sg13g2_and2_2$1_0.VDD.n69 wind_comp_0.sg13g2_and2_2$1_0.VDD.n60 0.00921669
R1216 wind_comp_0.sg13g2_and2_2$1_0.VDD.n407 wind_comp_0.sg13g2_and2_2$1_0.VDD.n406 0.00885337
R1217 wind_comp_0.sg13g2_and2_2$1_0.VDD.n15 wind_comp_0.sg13g2_and2_2$1_0.VDD.n407 0.00813785
R1218 wind_comp_0.sg13g2_and2_2$1_0.VDD.n564 wind_comp_0.sg13g2_and2_2$1_0.VDD.n322 0.00811006
R1219 wind_comp_0.sg13g2_and2_2$1_0.VDD.n285 wind_comp_0.sg13g2_and2_2$1_0.VDD.n284 0.00795233
R1220 wind_comp_0.sg13g2_and2_2$1_0.VDD.n289 wind_comp_0.sg13g2_and2_2$1_0.VDD.n283 0.00795233
R1221 wind_comp_0.sg13g2_and2_2$1_0.VDD.n69 wind_comp_0.sg13g2_and2_2$1_0.VDD.n61 0.00795232
R1222 wind_comp_0.sg13g2_and2_2$1_0.VDD.n603 wind_comp_0.sg13g2_and2_2$1_0.VDD.n602 0.00795232
R1223 wind_comp_0.sg13g2_and2_2$1_0.VDD.n477 wind_comp_0.sg13g2_and2_2$1_0.VDD.n476 0.00785497
R1224 wind_comp_0.sg13g2_and2_2$1_0.VDD.n26 wind_comp_0.sg13g2_and2_2$1_0.VDD.n25 0.00456857
R1225 wind_comp_0.sg13g2_and2_2$1_0.VDD.n536 wind_comp_0.sg13g2_and2_2$1_0.VDD.n535 0.00703465
R1226 wind_comp_0.sg13g2_and2_2$1_0.VDD.n536 wind_comp_0.sg13g2_and2_2$1_0.VDD.n491 0.00703465
R1227 wind_comp_0.sg13g2_and2_2$1_0.VDD.n540 wind_comp_0.sg13g2_and2_2$1_0.VDD.n491 0.00703465
R1228 wind_comp_0.sg13g2_and2_2$1_0.VDD.n541 wind_comp_0.sg13g2_and2_2$1_0.VDD.n540 0.00703465
R1229 wind_comp_0.sg13g2_and2_2$1_0.VDD.n542 wind_comp_0.sg13g2_and2_2$1_0.VDD.n541 0.00703465
R1230 wind_comp_0.sg13g2_and2_2$1_0.VDD.n542 wind_comp_0.sg13g2_and2_2$1_0.VDD.n486 0.00703465
R1231 wind_comp_0.sg13g2_and2_2$1_0.VDD.n546 wind_comp_0.sg13g2_and2_2$1_0.VDD.n486 0.00703465
R1232 wind_comp_0.sg13g2_and2_2$1_0.VDD.n547 wind_comp_0.sg13g2_and2_2$1_0.VDD.n546 0.00703465
R1233 wind_comp_0.sg13g2_and2_2$1_0.VDD.n548 wind_comp_0.sg13g2_and2_2$1_0.VDD.n547 0.00703465
R1234 wind_comp_0.sg13g2_and2_2$1_0.VDD.n548 wind_comp_0.sg13g2_and2_2$1_0.VDD.n481 0.00703465
R1235 wind_comp_0.sg13g2_and2_2$1_0.VDD.n552 wind_comp_0.sg13g2_and2_2$1_0.VDD.n481 0.00703465
R1236 wind_comp_0.sg13g2_and2_2$1_0.VDD.n654 wind_comp_0.sg13g2_and2_2$1_0.VDD.n155 0.00703465
R1237 wind_comp_0.sg13g2_and2_2$1_0.VDD.n635 wind_comp_0.sg13g2_and2_2$1_0.VDD.n155 0.00703465
R1238 wind_comp_0.sg13g2_and2_2$1_0.VDD.n636 wind_comp_0.sg13g2_and2_2$1_0.VDD.n635 0.00703465
R1239 wind_comp_0.sg13g2_and2_2$1_0.VDD.n636 wind_comp_0.sg13g2_and2_2$1_0.VDD.n628 0.00703465
R1240 wind_comp_0.sg13g2_and2_2$1_0.VDD.n640 wind_comp_0.sg13g2_and2_2$1_0.VDD.n628 0.00703465
R1241 wind_comp_0.sg13g2_and2_2$1_0.VDD.n641 wind_comp_0.sg13g2_and2_2$1_0.VDD.n640 0.00703465
R1242 wind_comp_0.sg13g2_and2_2$1_0.VDD.n642 wind_comp_0.sg13g2_and2_2$1_0.VDD.n641 0.00703465
R1243 wind_comp_0.sg13g2_and2_2$1_0.VDD.n642 wind_comp_0.sg13g2_and2_2$1_0.VDD.n623 0.00703465
R1244 wind_comp_0.sg13g2_and2_2$1_0.VDD.n646 wind_comp_0.sg13g2_and2_2$1_0.VDD.n623 0.00703465
R1245 wind_comp_0.sg13g2_and2_2$1_0.VDD.n647 wind_comp_0.sg13g2_and2_2$1_0.VDD.n646 0.00703465
R1246 wind_comp_0.sg13g2_and2_2$1_0.VDD.n648 wind_comp_0.sg13g2_and2_2$1_0.VDD.n647 0.00703465
R1247 wind_comp_0.sg13g2_and2_2$1_0.VDD.n537 wind_comp_0.sg13g2_and2_2$1_0.VDD.n503 0.00666642
R1248 wind_comp_0.sg13g2_and2_2$1_0.VDD.n538 wind_comp_0.sg13g2_and2_2$1_0.VDD.n537 0.00666642
R1249 wind_comp_0.sg13g2_and2_2$1_0.VDD.n539 wind_comp_0.sg13g2_and2_2$1_0.VDD.n538 0.00666642
R1250 wind_comp_0.sg13g2_and2_2$1_0.VDD.n539 wind_comp_0.sg13g2_and2_2$1_0.VDD.n490 0.00666642
R1251 wind_comp_0.sg13g2_and2_2$1_0.VDD.n543 wind_comp_0.sg13g2_and2_2$1_0.VDD.n490 0.00666642
R1252 wind_comp_0.sg13g2_and2_2$1_0.VDD.n544 wind_comp_0.sg13g2_and2_2$1_0.VDD.n543 0.00666642
R1253 wind_comp_0.sg13g2_and2_2$1_0.VDD.n545 wind_comp_0.sg13g2_and2_2$1_0.VDD.n544 0.00666642
R1254 wind_comp_0.sg13g2_and2_2$1_0.VDD.n545 wind_comp_0.sg13g2_and2_2$1_0.VDD.n485 0.00666642
R1255 wind_comp_0.sg13g2_and2_2$1_0.VDD.n549 wind_comp_0.sg13g2_and2_2$1_0.VDD.n485 0.00666642
R1256 wind_comp_0.sg13g2_and2_2$1_0.VDD.n550 wind_comp_0.sg13g2_and2_2$1_0.VDD.n549 0.00666642
R1257 wind_comp_0.sg13g2_and2_2$1_0.VDD.n551 wind_comp_0.sg13g2_and2_2$1_0.VDD.n550 0.00666642
R1258 wind_comp_0.sg13g2_and2_2$1_0.VDD.n502 wind_comp_0.sg13g2_and2_2$1_0.VDD.n494 0.00666642
R1259 wind_comp_0.sg13g2_and2_2$1_0.VDD.n493 wind_comp_0.sg13g2_and2_2$1_0.VDD.n492 0.00666642
R1260 wind_comp_0.sg13g2_and2_2$1_0.VDD.n496 wind_comp_0.sg13g2_and2_2$1_0.VDD.n489 0.00666642
R1261 wind_comp_0.sg13g2_and2_2$1_0.VDD.n488 wind_comp_0.sg13g2_and2_2$1_0.VDD.n487 0.00666642
R1262 wind_comp_0.sg13g2_and2_2$1_0.VDD.n499 wind_comp_0.sg13g2_and2_2$1_0.VDD.n484 0.00666642
R1263 wind_comp_0.sg13g2_and2_2$1_0.VDD.n484 wind_comp_0.sg13g2_and2_2$1_0.VDD.n483 0.00666642
R1264 wind_comp_0.sg13g2_and2_2$1_0.VDD.n653 wind_comp_0.sg13g2_and2_2$1_0.VDD.n156 0.00666642
R1265 wind_comp_0.sg13g2_and2_2$1_0.VDD.n634 wind_comp_0.sg13g2_and2_2$1_0.VDD.n156 0.00666642
R1266 wind_comp_0.sg13g2_and2_2$1_0.VDD.n637 wind_comp_0.sg13g2_and2_2$1_0.VDD.n634 0.00666642
R1267 wind_comp_0.sg13g2_and2_2$1_0.VDD.n638 wind_comp_0.sg13g2_and2_2$1_0.VDD.n637 0.00666642
R1268 wind_comp_0.sg13g2_and2_2$1_0.VDD.n639 wind_comp_0.sg13g2_and2_2$1_0.VDD.n638 0.00666642
R1269 wind_comp_0.sg13g2_and2_2$1_0.VDD.n639 wind_comp_0.sg13g2_and2_2$1_0.VDD.n627 0.00666642
R1270 wind_comp_0.sg13g2_and2_2$1_0.VDD.n643 wind_comp_0.sg13g2_and2_2$1_0.VDD.n627 0.00666642
R1271 wind_comp_0.sg13g2_and2_2$1_0.VDD.n644 wind_comp_0.sg13g2_and2_2$1_0.VDD.n643 0.00666642
R1272 wind_comp_0.sg13g2_and2_2$1_0.VDD.n645 wind_comp_0.sg13g2_and2_2$1_0.VDD.n644 0.00666642
R1273 wind_comp_0.sg13g2_and2_2$1_0.VDD.n645 wind_comp_0.sg13g2_and2_2$1_0.VDD.n163 0.00666642
R1274 wind_comp_0.sg13g2_and2_2$1_0.VDD.n649 wind_comp_0.sg13g2_and2_2$1_0.VDD.n163 0.00666642
R1275 wind_comp_0.sg13g2_and2_2$1_0.VDD.n633 wind_comp_0.sg13g2_and2_2$1_0.VDD.n157 0.00666642
R1276 wind_comp_0.sg13g2_and2_2$1_0.VDD.n632 wind_comp_0.sg13g2_and2_2$1_0.VDD.n631 0.00666642
R1277 wind_comp_0.sg13g2_and2_2$1_0.VDD.n630 wind_comp_0.sg13g2_and2_2$1_0.VDD.n629 0.00666642
R1278 wind_comp_0.sg13g2_and2_2$1_0.VDD.n626 wind_comp_0.sg13g2_and2_2$1_0.VDD.n625 0.00666642
R1279 wind_comp_0.sg13g2_and2_2$1_0.VDD.n624 wind_comp_0.sg13g2_and2_2$1_0.VDD.n162 0.00666642
R1280 wind_comp_0.sg13g2_and2_2$1_0.VDD.n70 wind_comp_0.sg13g2_and2_2$1_0.VDD.n62 0.00650575
R1281 wind_comp_0.sg13g2_and2_2$1_0.VDD.n594 wind_comp_0.sg13g2_and2_2$1_0.VDD.n250 0.00650575
R1282 wind_comp_0.sg13g2_and2_2$1_0.VDD.n268 wind_comp_0.sg13g2_and2_2$1_0.VDD.n267 0.00642308
R1283 wind_comp_0.sg13g2_and2_2$1_0.VDD.n266 wind_comp_0.sg13g2_and2_2$1_0.VDD.n265 0.00642308
R1284 wind_comp_0.sg13g2_and2_2$1_0.VDD.n264 wind_comp_0.sg13g2_and2_2$1_0.VDD.n263 0.00642308
R1285 wind_comp_0.sg13g2_and2_2$1_0.VDD.n262 wind_comp_0.sg13g2_and2_2$1_0.VDD.n261 0.00642308
R1286 wind_comp_0.sg13g2_and2_2$1_0.VDD.n209 wind_comp_0.sg13g2_and2_2$1_0.VDD.n208 0.00642308
R1287 wind_comp_0.sg13g2_and2_2$1_0.VDD.n211 wind_comp_0.sg13g2_and2_2$1_0.VDD.n210 0.00642308
R1288 wind_comp_0.sg13g2_and2_2$1_0.VDD.n213 wind_comp_0.sg13g2_and2_2$1_0.VDD.n212 0.00642308
R1289 wind_comp_0.sg13g2_and2_2$1_0.VDD.n215 wind_comp_0.sg13g2_and2_2$1_0.VDD.n214 0.00642308
R1290 wind_comp_0.sg13g2_and2_2$1_0.VDD.n372 wind_comp_0.sg13g2_and2_2$1_0.VDD.n371 0.00640727
R1291 wind_comp_0.sg13g2_and2_2$1_0.VDD.n371 wind_comp_0.sg13g2_and2_2$1_0.VDD.n370 0.00640727
R1292 wind_comp_0.sg13g2_and2_2$1_0.VDD.n319 wind_comp_0.sg13g2_and2_2$1_0.VDD.n318 0.0063805
R1293 wind_comp_0.sg13g2_and2_2$1_0.VDD.n314 wind_comp_0.sg13g2_and2_2$1_0.VDD.n313 0.0063805
R1294 wind_comp_0.sg13g2_and2_2$1_0.VDD.n313 wind_comp_0.sg13g2_and2_2$1_0.VDD.n312 0.0063805
R1295 wind_comp_0.sg13g2_and2_2$1_0.VDD.n370 wind_comp_0.sg13g2_and2_2$1_0.VDD.n369 0.00612439
R1296 wind_comp_0.sg13g2_and2_2$1_0.VDD.n365 wind_comp_0.sg13g2_and2_2$1_0.VDD.n364 0.00612439
R1297 wind_comp_0.sg13g2_and2_2$1_0.VDD.n22 wind_comp_0.sg13g2_and2_2$1_0.VDD.n20 0.00612439
R1298 wind_comp_0.sg13g2_and2_2$1_0.VDD.n455 wind_comp_0.sg13g2_and2_2$1_0.VDD.n454 0.00612439
R1299 wind_comp_0.sg13g2_and2_2$1_0.VDD.n457 wind_comp_0.sg13g2_and2_2$1_0.VDD.n456 0.00612439
R1300 wind_comp_0.sg13g2_and2_2$1_0.VDD.n459 wind_comp_0.sg13g2_and2_2$1_0.VDD.n458 0.00612439
R1301 wind_comp_0.sg13g2_and2_2$1_0.VDD.n464 wind_comp_0.sg13g2_and2_2$1_0.VDD.n463 0.00612439
R1302 wind_comp_0.sg13g2_and2_2$1_0.VDD.n465 wind_comp_0.sg13g2_and2_2$1_0.VDD.n464 0.00569174
R1303 wind_comp_0.sg13g2_and2_2$1_0.VDD.n415 wind_comp_0.sg13g2_and2_2$1_0.VDD.n414 0.00569174
R1304 wind_comp_0.sg13g2_and2_2$1_0.VDD.n417 wind_comp_0.sg13g2_and2_2$1_0.VDD.n416 0.00569174
R1305 wind_comp_0.sg13g2_and2_2$1_0.VDD.n413 wind_comp_0.sg13g2_and2_2$1_0.VDD.n412 0.00569174
R1306 wind_comp_0.sg13g2_and2_2$1_0.VDD.n24 wind_comp_0.sg13g2_and2_2$1_0.VDD.n23 0.00547542
R1307 wind_comp_0.sg13g2_and2_2$1_0.VDD.n195 wind_comp_0.sg13g2_and2_2$1_0.VDD.n62 0.00524138
R1308 wind_comp_0.sg13g2_and2_2$1_0.VDD.n594 wind_comp_0.sg13g2_and2_2$1_0.VDD.n593 0.00524138
R1309 wind_comp_0.sg13g2_and2_2$1_0.VDD.n593 wind_comp_0.sg13g2_and2_2$1_0.VDD.n592 0.00524138
R1310 wind_comp_0.sg13g2_and2_2$1_0.VDD.n195 wind_comp_0.sg13g2_and2_2$1_0.VDD.n194 0.00524138
R1311 wind_comp_0.sg13g2_and2_2$1_0.VDD.n231 wind_comp_0.sg13g2_and2_2$1_0.VDD.n230 0.00517851
R1312 wind_comp_0.sg13g2_and2_2$1_0.VDD.n598 wind_comp_0.sg13g2_and2_2$1_0.VDD.n230 0.00493973
R1313 wind_comp_0.sg13g2_and2_2$1_0.VDD.n475 wind_comp_0.sg13g2_and2_2$1_0.VDD.n26 0.00489301
R1314 wind_comp_0.sg13g2_and2_2$1_0.VDD.n476 wind_comp_0.sg13g2_and2_2$1_0.VDD.n475 0.00467669
R1315 wind_comp_0.sg13g2_and2_2$1_0.VDD.n406 wind_comp_0.sg13g2_and2_2$1_0.VDD.n405 0.00467669
R1316 wind_comp_0.sg13g2_and2_2$1_0.VDD.n293 wind_comp_0.sg13g2_and2_2$1_0.VDD.n292 0.00465094
R1317 wind_comp_0.sg13g2_and2_2$1_0.VDD.n453 wind_comp_0.sg13g2_and2_2$1_0.VDD.n452 0.00439381
R1318 wind_comp_0.sg13g2_and2_2$1_0.VDD.n461 wind_comp_0.sg13g2_and2_2$1_0.VDD.n460 0.00439381
R1319 wind_comp_0.sg13g2_and2_2$1_0.VDD.n467 wind_comp_0.sg13g2_and2_2$1_0.VDD.n466 0.00439381
R1320 wind_comp_0.sg13g2_and2_2$1_0.VDD.n471 wind_comp_0.sg13g2_and2_2$1_0.VDD.n470 0.00439381
R1321 wind_comp_0.sg13g2_and2_2$1_0.VDD.n411 wind_comp_0.sg13g2_and2_2$1_0.VDD.n410 0.00439381
R1322 wind_comp_0.sg13g2_and2_2$1_0.VDD.n409 wind_comp_0.sg13g2_and2_2$1_0.VDD.n408 0.00439381
R1323 wind_comp_0.sg13g2_and2_2$1_0.VDD.n404 wind_comp_0.sg13g2_and2_2$1_0.VDD.n341 0.00439381
R1324 wind_comp_0.sg13g2_and2_2$1_0.VDD.n408 wind_comp_0.sg13g2_and2_2$1_0.VDD.n18 0.00439381
R1325 wind_comp_0.sg13g2_and2_2$1_0.VDD.n445 wind_comp_0.sg13g2_and2_2$1_0.VDD.n443 0.00416667
R1326 wind_comp_0.sg13g2_and2_2$1_0.VDD.n495 wind_comp_0.sg13g2_and2_2$1_0.VDD.n493 0.00406536
R1327 wind_comp_0.sg13g2_and2_2$1_0.VDD.n497 wind_comp_0.sg13g2_and2_2$1_0.VDD.n496 0.00406536
R1328 wind_comp_0.sg13g2_and2_2$1_0.VDD.n498 wind_comp_0.sg13g2_and2_2$1_0.VDD.n488 0.00406536
R1329 wind_comp_0.sg13g2_and2_2$1_0.VDD.n500 wind_comp_0.sg13g2_and2_2$1_0.VDD.n499 0.00406536
R1330 wind_comp_0.sg13g2_and2_2$1_0.VDD.n495 wind_comp_0.sg13g2_and2_2$1_0.VDD.n494 0.00406536
R1331 wind_comp_0.sg13g2_and2_2$1_0.VDD.n497 wind_comp_0.sg13g2_and2_2$1_0.VDD.n492 0.00406536
R1332 wind_comp_0.sg13g2_and2_2$1_0.VDD.n498 wind_comp_0.sg13g2_and2_2$1_0.VDD.n489 0.00406536
R1333 wind_comp_0.sg13g2_and2_2$1_0.VDD.n500 wind_comp_0.sg13g2_and2_2$1_0.VDD.n487 0.00406536
R1334 wind_comp_0.sg13g2_and2_2$1_0.VDD.n483 wind_comp_0.sg13g2_and2_2$1_0.VDD.n482 0.00406536
R1335 wind_comp_0.sg13g2_and2_2$1_0.VDD.n652 wind_comp_0.sg13g2_and2_2$1_0.VDD.n157 0.00406536
R1336 wind_comp_0.sg13g2_and2_2$1_0.VDD.n632 wind_comp_0.sg13g2_and2_2$1_0.VDD.n158 0.00406536
R1337 wind_comp_0.sg13g2_and2_2$1_0.VDD.n630 wind_comp_0.sg13g2_and2_2$1_0.VDD.n159 0.00406536
R1338 wind_comp_0.sg13g2_and2_2$1_0.VDD.n626 wind_comp_0.sg13g2_and2_2$1_0.VDD.n160 0.00406536
R1339 wind_comp_0.sg13g2_and2_2$1_0.VDD.n624 wind_comp_0.sg13g2_and2_2$1_0.VDD.n161 0.00406536
R1340 wind_comp_0.sg13g2_and2_2$1_0.VDD.n633 wind_comp_0.sg13g2_and2_2$1_0.VDD.n158 0.00406536
R1341 wind_comp_0.sg13g2_and2_2$1_0.VDD.n631 wind_comp_0.sg13g2_and2_2$1_0.VDD.n159 0.00406536
R1342 wind_comp_0.sg13g2_and2_2$1_0.VDD.n629 wind_comp_0.sg13g2_and2_2$1_0.VDD.n160 0.00406536
R1343 wind_comp_0.sg13g2_and2_2$1_0.VDD.n625 wind_comp_0.sg13g2_and2_2$1_0.VDD.n161 0.00406536
R1344 wind_comp_0.sg13g2_and2_2$1_0.VDD.n650 wind_comp_0.sg13g2_and2_2$1_0.VDD.n162 0.00406536
R1345 wind_comp_0.sg13g2_and2_2$1_0.VDD.n14 wind_comp_0.sg13g2_and2_2$1_0.VDD.n372 0.00396116
R1346 wind_comp_0.sg13g2_and2_2$1_0.VDD.n368 wind_comp_0.sg13g2_and2_2$1_0.VDD.n367 0.00396116
R1347 wind_comp_0.sg13g2_and2_2$1_0.VDD.n412 wind_comp_0.sg13g2_and2_2$1_0.VDD.n411 0.00396116
R1348 wind_comp_0.sg13g2_and2_2$1_0.VDD.n410 wind_comp_0.sg13g2_and2_2$1_0.VDD.n409 0.00396116
R1349 wind_comp_0.sg13g2_and2_2$1_0.VDD.n18 wind_comp_0.sg13g2_and2_2$1_0.VDD.n15 0.00396116
R1350 wind_comp_0.sg13g2_and2_2$1_0.VDD.n405 wind_comp_0.sg13g2_and2_2$1_0.VDD.n404 0.00396116
R1351 wind_comp_0.sg13g2_and2_2$1_0.VDD.n693 wind_comp_0.sg13g2_and2_2$1_0.VDD.n19 0.00392369
R1352 wind_comp_0.sg13g2_and2_2$1_0.VDD.n34 wind_comp_0.sg13g2_and2_2$1_0.VDD.n33 0.0034845
R1353 wind_comp_0.sg13g2_and2_2$1_0.VDD.n303 wind_comp_0.sg13g2_and2_2$1_0.VDD.n302 0.00292138
R1354 wind_comp_0.sg13g2_and2_2$1_0.VDD.n414 wind_comp_0.sg13g2_and2_2$1_0.VDD.n24 0.00287955
R1355 wind_comp_0.sg13g2_and2_2$1_0.VDD.n367 wind_comp_0.sg13g2_and2_2$1_0.VDD.n366 0.00266323
R1356 wind_comp_0.sg13g2_and2_2$1_0.VDD.n466 wind_comp_0.sg13g2_and2_2$1_0.VDD.n465 0.00266323
R1357 wind_comp_0.sg13g2_and2_2$1_0.VDD.n469 wind_comp_0.sg13g2_and2_2$1_0.VDD.n468 0.00266323
R1358 wind_comp_0.sg13g2_and2_2$1_0.VDD.n23 wind_comp_0.sg13g2_and2_2$1_0.VDD.n471 0.00266323
R1359 wind_comp_0.sg13g2_and2_2$1_0.VDD.n416 wind_comp_0.sg13g2_and2_2$1_0.VDD.n415 0.00266323
R1360 wind_comp_0.sg13g2_and2_2$1_0.VDD.n417 wind_comp_0.sg13g2_and2_2$1_0.VDD.n413 0.00266323
R1361 wind_comp_0.sg13g2_and2_2$1_0.VDD.n564 wind_comp_0.sg13g2_and2_2$1_0.VDD.n563 0.00257547
R1362 wind_comp_0.sg13g2_and2_2$1_0.VDD.n534 wind_comp_0.sg13g2_and2_2$1_0.VDD.n533 0.00254208
R1363 wind_comp_0.sg13g2_and2_2$1_0.VDD.n622 wind_comp_0.sg13g2_and2_2$1_0.VDD.n621 0.00254208
R1364 wind_comp_0.sg13g2_and2_2$1_0.VDD.n657 wind_comp_0.sg13g2_and2_2$1_0.VDD.n656 0.0023253
R1365 wind_comp_0.sg13g2_and2_2$1_0.VDD.n599 wind_comp_0.sg13g2_and2_2$1_0.VDD.n598 0.00229088
R1366 wind_comp_0.sg13g2_and2_2$1_0.VDD.n364 wind_comp_0.sg13g2_and2_2$1_0.VDD.n22 0.00223058
R1367 wind_comp_0.sg13g2_and2_2$1_0.VDD.n369 wind_comp_0.sg13g2_and2_2$1_0.VDD.n368 0.00223058
R1368 wind_comp_0.sg13g2_and2_2$1_0.VDD.n366 wind_comp_0.sg13g2_and2_2$1_0.VDD.n365 0.00223058
R1369 wind_comp_0.sg13g2_and2_2$1_0.VDD.n20 wind_comp_0.sg13g2_and2_2$1_0.VDD.n353 0.00223058
R1370 wind_comp_0.sg13g2_and2_2$1_0.VDD.n452 wind_comp_0.sg13g2_and2_2$1_0.VDD.n353 0.00223058
R1371 wind_comp_0.sg13g2_and2_2$1_0.VDD.n454 wind_comp_0.sg13g2_and2_2$1_0.VDD.n453 0.00223058
R1372 wind_comp_0.sg13g2_and2_2$1_0.VDD.n456 wind_comp_0.sg13g2_and2_2$1_0.VDD.n455 0.00223058
R1373 wind_comp_0.sg13g2_and2_2$1_0.VDD.n458 wind_comp_0.sg13g2_and2_2$1_0.VDD.n457 0.00223058
R1374 wind_comp_0.sg13g2_and2_2$1_0.VDD.n460 wind_comp_0.sg13g2_and2_2$1_0.VDD.n459 0.00223058
R1375 wind_comp_0.sg13g2_and2_2$1_0.VDD.n462 wind_comp_0.sg13g2_and2_2$1_0.VDD.n461 0.00223058
R1376 wind_comp_0.sg13g2_and2_2$1_0.VDD.n463 wind_comp_0.sg13g2_and2_2$1_0.VDD.n462 0.00223058
R1377 wind_comp_0.sg13g2_and2_2$1_0.VDD.n308 wind_comp_0.sg13g2_and2_2$1_0.VDD.n307 0.00222956
R1378 wind_comp_0.sg13g2_and2_2$1_0.VDD.n468 wind_comp_0.sg13g2_and2_2$1_0.VDD.n467 0.00179794
R1379 wind_comp_0.sg13g2_and2_2$1_0.VDD.n470 wind_comp_0.sg13g2_and2_2$1_0.VDD.n469 0.00179794
R1380 wind_comp_0.sg13g2_and2_2$1_0.VDD.n607 wind_comp_0.sg13g2_and2_2$1_0.VDD.n601 0.00169392
R1381 wind_comp_0.sg13g2_and2_2$1_0.VDD.n597 wind_comp_0.sg13g2_and2_2$1_0.VDD.n248 0.00169392
R1382 wind_comp_0.sg13g2_and2_2$1_0.VDD.n10 wind_comp_0.sg13g2_and2_2$1_0.VDD.n9 0.0247138
R1383 wind_comp_0.sg13g2_and2_2$1_0.VDD.n7 wind_comp_0.sg13g2_and2_2$1_0.VDD.n6 0.00707233
R1384 wind_comp_0.sg13g2_and2_2$1_0.VDD.n231 wind_comp_0.sg13g2_and2_2$1_0.VDD.n5 0.00703845
R1385 wind_comp_0.sg13g2_and2_2$1_0.VDD.n685 wind_comp_0.sg13g2_and2_2$1_0.VDD.n2 4.48815
R1386 wind_comp_0.sg13g2_and2_2$1_0.VSS.n531 wind_comp_0.sg13g2_and2_2$1_0.VSS.n920 363003
R1387 wind_comp_0.sg13g2_and2_2$1_0.VSS.n2569 wind_comp_0.sg13g2_and2_2$1_0.VSS.n1229 10167.3
R1388 wind_comp_0.sg13g2_and2_2$1_0.VSS.n126 wind_comp_0.sg13g2_and2_2$1_0.VSS.n1229 9818.11
R1389 wind_comp_0.sg13g2_and2_2$1_0.VSS.n2563 wind_comp_0.sg13g2_and2_2$1_0.VSS.n607 88.0445
R1390 wind_comp_0.sg13g2_and2_2$1_0.VSS.n698 wind_comp_0.sg13g2_and2_2$1_0.VSS.t276 26.0005
R1391 wind_comp_0.sg13g2_and2_2$1_0.VSS.n1958 wind_comp_0.sg13g2_and2_2$1_0.VSS.t300 26.0005
R1392 wind_comp_0.sg13g2_and2_2$1_0.VSS.n1957 wind_comp_0.sg13g2_and2_2$1_0.VSS.t302 26.0005
R1393 wind_comp_0.sg13g2_and2_2$1_0.VSS.n1956 wind_comp_0.sg13g2_and2_2$1_0.VSS.t301 26.0005
R1394 wind_comp_0.sg13g2_and2_2$1_0.VSS.n2521 wind_comp_0.sg13g2_and2_2$1_0.VSS.t294 26.0005
R1395 wind_comp_0.sg13g2_and2_2$1_0.VSS.n1567 wind_comp_0.sg13g2_and2_2$1_0.VSS.t3 26.0005
R1396 wind_comp_0.sg13g2_and2_2$1_0.VSS.n699 wind_comp_0.sg13g2_and2_2$1_0.VSS.t278 26.0005
R1397 wind_comp_0.sg13g2_and2_2$1_0.VSS.n700 wind_comp_0.sg13g2_and2_2$1_0.VSS.t277 26.0005
R1398 wind_comp_0.sg13g2_and2_2$1_0.VSS.n2594 wind_comp_0.sg13g2_and2_2$1_0.VSS.n139 18.0005
R1399 wind_comp_0.sg13g2_and2_2$1_0.VSS.n622 wind_comp_0.sg13g2_and2_2$1_0.VSS.n2126 18.0005
R1400 wind_comp_0.sg13g2_and2_2$1_0.VSS.n234 wind_comp_0.sg13g2_and2_2$1_0.VSS.n2291 18.0005
R1401 wind_comp_0.sg13g2_and2_2$1_0.VSS.n2289 wind_comp_0.sg13g2_and2_2$1_0.VSS.n626 18.0005
R1402 wind_comp_0.sg13g2_and2_2$1_0.VSS.n671 wind_comp_0.sg13g2_and2_2$1_0.VSS.n2575 18.0005
R1403 wind_comp_0.sg13g2_and2_2$1_0.VSS.n2283 wind_comp_0.sg13g2_and2_2$1_0.VSS.n670 18.0005
R1404 wind_comp_0.sg13g2_and2_2$1_0.VSS.n2564 wind_comp_0.sg13g2_and2_2$1_0.VSS.t247 17.58
R1405 wind_comp_0.sg13g2_and2_2$1_0.VSS.n1575 wind_comp_0.sg13g2_and2_2$1_0.VSS.t393 17.58
R1406 wind_comp_0.sg13g2_and2_2$1_0.VSS.n1307 wind_comp_0.sg13g2_and2_2$1_0.VSS.t327 17.3368
R1407 wind_comp_0.sg13g2_and2_2$1_0.VSS.n1453 wind_comp_0.sg13g2_and2_2$1_0.VSS.t252 17.2205
R1408 wind_comp_0.sg13g2_and2_2$1_0.VSS.n1490 wind_comp_0.sg13g2_and2_2$1_0.VSS.t337 17.2205
R1409 wind_comp_0.sg13g2_and2_2$1_0.VSS.n1669 wind_comp_0.sg13g2_and2_2$1_0.VSS.t388 17.2205
R1410 wind_comp_0.sg13g2_and2_2$1_0.VSS.n1617 wind_comp_0.sg13g2_and2_2$1_0.VSS.t322 17.2205
R1411 wind_comp_0.sg13g2_and2_2$1_0.VSS.n68 wind_comp_0.sg13g2_and2_2$1_0.VSS.n1786 17.1366
R1412 wind_comp_0.sg13g2_and2_2$1_0.VSS.n124 wind_comp_0.sg13g2_and2_2$1_0.VSS.n1337 17.0054
R1413 wind_comp_0.sg13g2_and2_2$1_0.VSS.n124 wind_comp_0.sg13g2_and2_2$1_0.VSS.n1351 17.0031
R1414 wind_comp_0.sg13g2_and2_2$1_0.VSS.n250 wind_comp_0.sg13g2_and2_2$1_0.VSS.n249 0.0030996
R1415 wind_comp_0.sg13g2_and2_2$1_0.VSS.t52 wind_comp_0.sg13g2_and2_2$1_0.VSS.n678 17.0005
R1416 wind_comp_0.sg13g2_and2_2$1_0.VSS.t52 wind_comp_0.sg13g2_and2_2$1_0.VSS.n2629 17.0005
R1417 wind_comp_0.sg13g2_and2_2$1_0.VSS.t52 wind_comp_0.sg13g2_and2_2$1_0.VSS.n2618 17.0005
R1418 wind_comp_0.sg13g2_and2_2$1_0.VSS.t50 wind_comp_0.sg13g2_and2_2$1_0.VSS.n2599 17.0005
R1419 wind_comp_0.sg13g2_and2_2$1_0.VSS.t50 wind_comp_0.sg13g2_and2_2$1_0.VSS.n2600 17.0005
R1420 wind_comp_0.sg13g2_and2_2$1_0.VSS.t50 wind_comp_0.sg13g2_and2_2$1_0.VSS.n2601 17.0005
R1421 wind_comp_0.sg13g2_and2_2$1_0.VSS.n2127 wind_comp_0.sg13g2_and2_2$1_0.VSS.n4 17.0005
R1422 wind_comp_0.sg13g2_and2_2$1_0.VSS.n4 wind_comp_0.sg13g2_and2_2$1_0.VSS.n620 8.49862
R1423 wind_comp_0.sg13g2_and2_2$1_0.VSS.n8 wind_comp_0.sg13g2_and2_2$1_0.VSS.n610 17.0005
R1424 wind_comp_0.sg13g2_and2_2$1_0.VSS.n2105 wind_comp_0.sg13g2_and2_2$1_0.VSS.n8 17.0005
R1425 wind_comp_0.sg13g2_and2_2$1_0.VSS.n14 wind_comp_0.sg13g2_and2_2$1_0.VSS.n36 0.0913552
R1426 wind_comp_0.sg13g2_and2_2$1_0.VSS.n8 wind_comp_0.sg13g2_and2_2$1_0.VSS.n2591 17.0005
R1427 wind_comp_0.sg13g2_and2_2$1_0.VSS.n732 wind_comp_0.sg13g2_and2_2$1_0.VSS.n8 17.0005
R1428 wind_comp_0.sg13g2_and2_2$1_0.VSS.n738 wind_comp_0.sg13g2_and2_2$1_0.VSS.n8 17.0005
R1429 wind_comp_0.sg13g2_and2_2$1_0.VSS.n8 wind_comp_0.sg13g2_and2_2$1_0.VSS.n527 17.0005
R1430 wind_comp_0.sg13g2_and2_2$1_0.VSS.n8 wind_comp_0.sg13g2_and2_2$1_0.VSS.n227 8.49855
R1431 wind_comp_0.sg13g2_and2_2$1_0.VSS.n225 wind_comp_0.sg13g2_and2_2$1_0.VSS.n227 0.00590029
R1432 wind_comp_0.sg13g2_and2_2$1_0.VSS.n743 wind_comp_0.sg13g2_and2_2$1_0.VSS.n8 17.0005
R1433 wind_comp_0.sg13g2_and2_2$1_0.VSS.n745 wind_comp_0.sg13g2_and2_2$1_0.VSS.n8 17.0005
R1434 wind_comp_0.sg13g2_and2_2$1_0.VSS.n8 wind_comp_0.sg13g2_and2_2$1_0.VSS.n235 8.49956
R1435 wind_comp_0.sg13g2_and2_2$1_0.VSS.n8 wind_comp_0.sg13g2_and2_2$1_0.VSS.n139 8.49855
R1436 wind_comp_0.sg13g2_and2_2$1_0.VSS.n8 wind_comp_0.sg13g2_and2_2$1_0.VSS.n691 17.0005
R1437 wind_comp_0.sg13g2_and2_2$1_0.VSS.n2592 wind_comp_0.sg13g2_and2_2$1_0.VSS.n8 17.0005
R1438 wind_comp_0.sg13g2_and2_2$1_0.VSS.n8 wind_comp_0.sg13g2_and2_2$1_0.VSS.n692 17.0005
R1439 wind_comp_0.sg13g2_and2_2$1_0.VSS.n8 wind_comp_0.sg13g2_and2_2$1_0.VSS.n696 17.0005
R1440 wind_comp_0.sg13g2_and2_2$1_0.VSS.n8 wind_comp_0.sg13g2_and2_2$1_0.VSS.n695 17.0005
R1441 wind_comp_0.sg13g2_and2_2$1_0.VSS.n8 wind_comp_0.sg13g2_and2_2$1_0.VSS.n693 17.0005
R1442 wind_comp_0.sg13g2_and2_2$1_0.VSS.n8 wind_comp_0.sg13g2_and2_2$1_0.VSS.n694 17.0005
R1443 wind_comp_0.sg13g2_and2_2$1_0.VSS.n620 wind_comp_0.sg13g2_and2_2$1_0.VSS.n610 0.0057562
R1444 wind_comp_0.sg13g2_and2_2$1_0.VSS.n28 wind_comp_0.sg13g2_and2_2$1_0.VSS.n4 1.40664
R1445 wind_comp_0.sg13g2_and2_2$1_0.VSS.n14 wind_comp_0.sg13g2_and2_2$1_0.VSS.n38 0.00662751
R1446 wind_comp_0.sg13g2_and2_2$1_0.VSS.n4 wind_comp_0.sg13g2_and2_2$1_0.VSS.n2092 17.0005
R1447 wind_comp_0.sg13g2_and2_2$1_0.VSS.n4 wind_comp_0.sg13g2_and2_2$1_0.VSS.n2116 17.0005
R1448 wind_comp_0.sg13g2_and2_2$1_0.VSS.n4 wind_comp_0.sg13g2_and2_2$1_0.VSS.n2094 17.0005
R1449 wind_comp_0.sg13g2_and2_2$1_0.VSS.n4 wind_comp_0.sg13g2_and2_2$1_0.VSS.n2115 17.0005
R1450 wind_comp_0.sg13g2_and2_2$1_0.VSS.n4 wind_comp_0.sg13g2_and2_2$1_0.VSS.n2093 17.0005
R1451 wind_comp_0.sg13g2_and2_2$1_0.VSS.n4 wind_comp_0.sg13g2_and2_2$1_0.VSS.n352 17.0005
R1452 wind_comp_0.sg13g2_and2_2$1_0.VSS.n4 wind_comp_0.sg13g2_and2_2$1_0.VSS.n2593 17.0005
R1453 wind_comp_0.sg13g2_and2_2$1_0.VSS.n140 wind_comp_0.sg13g2_and2_2$1_0.VSS.n4 4.24438
R1454 wind_comp_0.sg13g2_and2_2$1_0.VSS.n140 wind_comp_0.sg13g2_and2_2$1_0.VSS.n139 0.0127931
R1455 wind_comp_0.sg13g2_and2_2$1_0.VSS.n139 wind_comp_0.sg13g2_and2_2$1_0.VSS.n237 0.00590029
R1456 wind_comp_0.sg13g2_and2_2$1_0.VSS.n4 wind_comp_0.sg13g2_and2_2$1_0.VSS.n748 17.0005
R1457 wind_comp_0.sg13g2_and2_2$1_0.VSS.n4 wind_comp_0.sg13g2_and2_2$1_0.VSS.n746 17.0005
R1458 wind_comp_0.sg13g2_and2_2$1_0.VSS.n4 wind_comp_0.sg13g2_and2_2$1_0.VSS.n744 17.0005
R1459 wind_comp_0.sg13g2_and2_2$1_0.VSS.n4 wind_comp_0.sg13g2_and2_2$1_0.VSS.n226 8.49956
R1460 wind_comp_0.sg13g2_and2_2$1_0.VSS.n4 wind_comp_0.sg13g2_and2_2$1_0.VSS.n525 8.49855
R1461 wind_comp_0.sg13g2_and2_2$1_0.VSS.n4 wind_comp_0.sg13g2_and2_2$1_0.VSS.n733 17.0005
R1462 wind_comp_0.sg13g2_and2_2$1_0.VSS.n2590 wind_comp_0.sg13g2_and2_2$1_0.VSS.n4 17.0005
R1463 wind_comp_0.sg13g2_and2_2$1_0.VSS.n4 wind_comp_0.sg13g2_and2_2$1_0.VSS.n1969 17.0005
R1464 wind_comp_0.sg13g2_and2_2$1_0.VSS.n4 wind_comp_0.sg13g2_and2_2$1_0.VSS.n1967 17.0005
R1465 wind_comp_0.sg13g2_and2_2$1_0.VSS.n4 wind_comp_0.sg13g2_and2_2$1_0.VSS.n172 8.49855
R1466 wind_comp_0.sg13g2_and2_2$1_0.VSS.n172 wind_comp_0.sg13g2_and2_2$1_0.VSS.n170 0.00589388
R1467 wind_comp_0.sg13g2_and2_2$1_0.VSS.n4 wind_comp_0.sg13g2_and2_2$1_0.VSS.n675 17.0005
R1468 wind_comp_0.sg13g2_and2_2$1_0.VSS.n157 wind_comp_0.sg13g2_and2_2$1_0.VSS.n231 0.00589388
R1469 wind_comp_0.sg13g2_and2_2$1_0.VSS.n4 wind_comp_0.sg13g2_and2_2$1_0.VSS.n255 3.3791
R1470 wind_comp_0.sg13g2_and2_2$1_0.VSS.n4 wind_comp_0.sg13g2_and2_2$1_0.VSS.n133 2.82945
R1471 wind_comp_0.sg13g2_and2_2$1_0.VSS.n133 wind_comp_0.sg13g2_and2_2$1_0.VSS.n253 0.0131543
R1472 wind_comp_0.sg13g2_and2_2$1_0.VSS.n4 wind_comp_0.sg13g2_and2_2$1_0.VSS.n251 17.0005
R1473 wind_comp_0.sg13g2_and2_2$1_0.VSS.n152 wind_comp_0.sg13g2_and2_2$1_0.VSS.n165 0.00589388
R1474 wind_comp_0.sg13g2_and2_2$1_0.VSS.n4 wind_comp_0.sg13g2_and2_2$1_0.VSS.n86 2.82822
R1475 wind_comp_0.sg13g2_and2_2$1_0.VSS.n4 wind_comp_0.sg13g2_and2_2$1_0.VSS.n2033 17.0005
R1476 wind_comp_0.sg13g2_and2_2$1_0.VSS.n4 wind_comp_0.sg13g2_and2_2$1_0.VSS.n261 3.35376
R1477 wind_comp_0.sg13g2_and2_2$1_0.VSS.n4 wind_comp_0.sg13g2_and2_2$1_0.VSS.n1970 17.0005
R1478 wind_comp_0.sg13g2_and2_2$1_0.VSS.n4 wind_comp_0.sg13g2_and2_2$1_0.VSS.n674 17.0005
R1479 wind_comp_0.sg13g2_and2_2$1_0.VSS.n4 wind_comp_0.sg13g2_and2_2$1_0.VSS.n1971 17.0005
R1480 wind_comp_0.sg13g2_and2_2$1_0.VSS.n4 wind_comp_0.sg13g2_and2_2$1_0.VSS.n2032 17.0005
R1481 wind_comp_0.sg13g2_and2_2$1_0.VSS.n4 wind_comp_0.sg13g2_and2_2$1_0.VSS.n263 3.38276
R1482 wind_comp_0.sg13g2_and2_2$1_0.VSS.n4 wind_comp_0.sg13g2_and2_2$1_0.VSS.n1972 17.0005
R1483 wind_comp_0.sg13g2_and2_2$1_0.VSS.n4 wind_comp_0.sg13g2_and2_2$1_0.VSS.n2031 17.0005
R1484 wind_comp_0.sg13g2_and2_2$1_0.VSS.n4 wind_comp_0.sg13g2_and2_2$1_0.VSS.n243 8.49855
R1485 wind_comp_0.sg13g2_and2_2$1_0.VSS.n243 wind_comp_0.sg13g2_and2_2$1_0.VSS.n242 0.00589388
R1486 wind_comp_0.sg13g2_and2_2$1_0.VSS.n4 wind_comp_0.sg13g2_and2_2$1_0.VSS.n240 17.0005
R1487 wind_comp_0.sg13g2_and2_2$1_0.VSS.n4 wind_comp_0.sg13g2_and2_2$1_0.VSS.n220 8.49855
R1488 wind_comp_0.sg13g2_and2_2$1_0.VSS.n220 wind_comp_0.sg13g2_and2_2$1_0.VSS.n218 0.00589388
R1489 wind_comp_0.sg13g2_and2_2$1_0.VSS.n4 wind_comp_0.sg13g2_and2_2$1_0.VSS.n2029 17.0005
R1490 wind_comp_0.sg13g2_and2_2$1_0.VSS.n4 wind_comp_0.sg13g2_and2_2$1_0.VSS.n1973 17.0005
R1491 wind_comp_0.sg13g2_and2_2$1_0.VSS.n4 wind_comp_0.sg13g2_and2_2$1_0.VSS.n159 8.4996
R1492 wind_comp_0.sg13g2_and2_2$1_0.VSS.n8 wind_comp_0.sg13g2_and2_2$1_0.VSS.n524 3.33989
R1493 wind_comp_0.sg13g2_and2_2$1_0.VSS.n8 wind_comp_0.sg13g2_and2_2$1_0.VSS.n523 3.35356
R1494 wind_comp_0.sg13g2_and2_2$1_0.VSS.n8 wind_comp_0.sg13g2_and2_2$1_0.VSS.n522 3.35299
R1495 wind_comp_0.sg13g2_and2_2$1_0.VSS.n8 wind_comp_0.sg13g2_and2_2$1_0.VSS.n521 3.35241
R1496 wind_comp_0.sg13g2_and2_2$1_0.VSS.n8 wind_comp_0.sg13g2_and2_2$1_0.VSS.n652 4.24651
R1497 wind_comp_0.sg13g2_and2_2$1_0.VSS.n8 wind_comp_0.sg13g2_and2_2$1_0.VSS.n650 5.66349
R1498 wind_comp_0.sg13g2_and2_2$1_0.VSS.n8 wind_comp_0.sg13g2_and2_2$1_0.VSS.n517 3.36963
R1499 wind_comp_0.sg13g2_and2_2$1_0.VSS.n8 wind_comp_0.sg13g2_and2_2$1_0.VSS.n516 3.35181
R1500 wind_comp_0.sg13g2_and2_2$1_0.VSS.n8 wind_comp_0.sg13g2_and2_2$1_0.VSS.n648 5.66349
R1501 wind_comp_0.sg13g2_and2_2$1_0.VSS.n8 wind_comp_0.sg13g2_and2_2$1_0.VSS.n514 3.35121
R1502 wind_comp_0.sg13g2_and2_2$1_0.VSS.n8 wind_comp_0.sg13g2_and2_2$1_0.VSS.n513 3.35059
R1503 wind_comp_0.sg13g2_and2_2$1_0.VSS.n8 wind_comp_0.sg13g2_and2_2$1_0.VSS.n512 3.34995
R1504 wind_comp_0.sg13g2_and2_2$1_0.VSS.n8 wind_comp_0.sg13g2_and2_2$1_0.VSS.n646 5.66349
R1505 wind_comp_0.sg13g2_and2_2$1_0.VSS.n8 wind_comp_0.sg13g2_and2_2$1_0.VSS.n511 3.3493
R1506 wind_comp_0.sg13g2_and2_2$1_0.VSS.n8 wind_comp_0.sg13g2_and2_2$1_0.VSS.n510 3.33812
R1507 wind_comp_0.sg13g2_and2_2$1_0.VSS.n8 wind_comp_0.sg13g2_and2_2$1_0.VSS.n644 5.66349
R1508 wind_comp_0.sg13g2_and2_2$1_0.VSS.n8 wind_comp_0.sg13g2_and2_2$1_0.VSS.n507 3.34864
R1509 wind_comp_0.sg13g2_and2_2$1_0.VSS.n8 wind_comp_0.sg13g2_and2_2$1_0.VSS.n506 3.34795
R1510 wind_comp_0.sg13g2_and2_2$1_0.VSS.n8 wind_comp_0.sg13g2_and2_2$1_0.VSS.n642 5.66349
R1511 wind_comp_0.sg13g2_and2_2$1_0.VSS.n8 wind_comp_0.sg13g2_and2_2$1_0.VSS.n505 3.34726
R1512 wind_comp_0.sg13g2_and2_2$1_0.VSS.n8 wind_comp_0.sg13g2_and2_2$1_0.VSS.n504 3.33594
R1513 wind_comp_0.sg13g2_and2_2$1_0.VSS.n8 wind_comp_0.sg13g2_and2_2$1_0.VSS.n503 3.34654
R1514 wind_comp_0.sg13g2_and2_2$1_0.VSS.n8 wind_comp_0.sg13g2_and2_2$1_0.VSS.n640 5.66349
R1515 wind_comp_0.sg13g2_and2_2$1_0.VSS.n8 wind_comp_0.sg13g2_and2_2$1_0.VSS.n502 3.34581
R1516 wind_comp_0.sg13g2_and2_2$1_0.VSS.n8 wind_comp_0.sg13g2_and2_2$1_0.VSS.n638 5.66349
R1517 wind_comp_0.sg13g2_and2_2$1_0.VSS.n8 wind_comp_0.sg13g2_and2_2$1_0.VSS.n499 3.33005
R1518 wind_comp_0.sg13g2_and2_2$1_0.VSS.n8 wind_comp_0.sg13g2_and2_2$1_0.VSS.n497 3.34506
R1519 wind_comp_0.sg13g2_and2_2$1_0.VSS.n8 wind_comp_0.sg13g2_and2_2$1_0.VSS.n636 5.66349
R1520 wind_comp_0.sg13g2_and2_2$1_0.VSS.n8 wind_comp_0.sg13g2_and2_2$1_0.VSS.n496 3.34428
R1521 wind_comp_0.sg13g2_and2_2$1_0.VSS.n8 wind_comp_0.sg13g2_and2_2$1_0.VSS.n495 3.34349
R1522 wind_comp_0.sg13g2_and2_2$1_0.VSS.n8 wind_comp_0.sg13g2_and2_2$1_0.VSS.n494 3.34268
R1523 wind_comp_0.sg13g2_and2_2$1_0.VSS.n8 wind_comp_0.sg13g2_and2_2$1_0.VSS.n634 5.66349
R1524 wind_comp_0.sg13g2_and2_2$1_0.VSS.n8 wind_comp_0.sg13g2_and2_2$1_0.VSS.n493 3.34184
R1525 wind_comp_0.sg13g2_and2_2$1_0.VSS.n8 wind_comp_0.sg13g2_and2_2$1_0.VSS.n491 3.34098
R1526 wind_comp_0.sg13g2_and2_2$1_0.VSS.n8 wind_comp_0.sg13g2_and2_2$1_0.VSS.n632 5.66349
R1527 wind_comp_0.sg13g2_and2_2$1_0.VSS.n8 wind_comp_0.sg13g2_and2_2$1_0.VSS.n490 3.33307
R1528 wind_comp_0.sg13g2_and2_2$1_0.VSS.n8 wind_comp_0.sg13g2_and2_2$1_0.VSS.n489 3.3401
R1529 wind_comp_0.sg13g2_and2_2$1_0.VSS.n8 wind_comp_0.sg13g2_and2_2$1_0.VSS.n630 5.66349
R1530 wind_comp_0.sg13g2_and2_2$1_0.VSS.n8 wind_comp_0.sg13g2_and2_2$1_0.VSS.n487 3.34008
R1531 wind_comp_0.sg13g2_and2_2$1_0.VSS.n8 wind_comp_0.sg13g2_and2_2$1_0.VSS.n2208 17.0005
R1532 wind_comp_0.sg13g2_and2_2$1_0.VSS.n8 wind_comp_0.sg13g2_and2_2$1_0.VSS.n2206 17.0005
R1533 wind_comp_0.sg13g2_and2_2$1_0.VSS.n8 wind_comp_0.sg13g2_and2_2$1_0.VSS.n486 3.33908
R1534 wind_comp_0.sg13g2_and2_2$1_0.VSS.n8 wind_comp_0.sg13g2_and2_2$1_0.VSS.n2204 17.0005
R1535 wind_comp_0.sg13g2_and2_2$1_0.VSS.n8 wind_comp_0.sg13g2_and2_2$1_0.VSS.n485 3.33814
R1536 wind_comp_0.sg13g2_and2_2$1_0.VSS.n8 wind_comp_0.sg13g2_and2_2$1_0.VSS.n2202 17.0005
R1537 wind_comp_0.sg13g2_and2_2$1_0.VSS.n8 wind_comp_0.sg13g2_and2_2$1_0.VSS.n2200 17.0005
R1538 wind_comp_0.sg13g2_and2_2$1_0.VSS.n8 wind_comp_0.sg13g2_and2_2$1_0.VSS.n484 3.38677
R1539 wind_comp_0.sg13g2_and2_2$1_0.VSS.n8 wind_comp_0.sg13g2_and2_2$1_0.VSS.n2198 17.0005
R1540 wind_comp_0.sg13g2_and2_2$1_0.VSS.n8 wind_comp_0.sg13g2_and2_2$1_0.VSS.n483 3.4004
R1541 wind_comp_0.sg13g2_and2_2$1_0.VSS.n8 wind_comp_0.sg13g2_and2_2$1_0.VSS.n2196 17.0005
R1542 wind_comp_0.sg13g2_and2_2$1_0.VSS.n8 wind_comp_0.sg13g2_and2_2$1_0.VSS.t334 3.40045
R1543 wind_comp_0.sg13g2_and2_2$1_0.VSS.n8 wind_comp_0.sg13g2_and2_2$1_0.VSS.n2194 17.0005
R1544 wind_comp_0.sg13g2_and2_2$1_0.VSS.n8 wind_comp_0.sg13g2_and2_2$1_0.VSS.n482 3.40017
R1545 wind_comp_0.sg13g2_and2_2$1_0.VSS.n8 wind_comp_0.sg13g2_and2_2$1_0.VSS.n2192 17.0005
R1546 wind_comp_0.sg13g2_and2_2$1_0.VSS.n8 wind_comp_0.sg13g2_and2_2$1_0.VSS.n481 3.39994
R1547 wind_comp_0.sg13g2_and2_2$1_0.VSS.n8 wind_comp_0.sg13g2_and2_2$1_0.VSS.n2190 17.0005
R1548 wind_comp_0.sg13g2_and2_2$1_0.VSS.n8 wind_comp_0.sg13g2_and2_2$1_0.VSS.n480 3.40033
R1549 wind_comp_0.sg13g2_and2_2$1_0.VSS.n8 wind_comp_0.sg13g2_and2_2$1_0.VSS.n2188 17.0005
R1550 wind_comp_0.sg13g2_and2_2$1_0.VSS.n8 wind_comp_0.sg13g2_and2_2$1_0.VSS.n479 3.39994
R1551 wind_comp_0.sg13g2_and2_2$1_0.VSS.n8 wind_comp_0.sg13g2_and2_2$1_0.VSS.n2186 17.0005
R1552 wind_comp_0.sg13g2_and2_2$1_0.VSS.n8 wind_comp_0.sg13g2_and2_2$1_0.VSS.n478 3.39946
R1553 wind_comp_0.sg13g2_and2_2$1_0.VSS.n8 wind_comp_0.sg13g2_and2_2$1_0.VSS.n2184 17.0005
R1554 wind_comp_0.sg13g2_and2_2$1_0.VSS.n8 wind_comp_0.sg13g2_and2_2$1_0.VSS.n477 3.39983
R1555 wind_comp_0.sg13g2_and2_2$1_0.VSS.n8 wind_comp_0.sg13g2_and2_2$1_0.VSS.n2182 17.0005
R1556 wind_comp_0.sg13g2_and2_2$1_0.VSS.n8 wind_comp_0.sg13g2_and2_2$1_0.VSS.n476 3.39883
R1557 wind_comp_0.sg13g2_and2_2$1_0.VSS.n8 wind_comp_0.sg13g2_and2_2$1_0.VSS.n2180 17.0005
R1558 wind_comp_0.sg13g2_and2_2$1_0.VSS.n8 wind_comp_0.sg13g2_and2_2$1_0.VSS.n475 3.39832
R1559 wind_comp_0.sg13g2_and2_2$1_0.VSS.n8 wind_comp_0.sg13g2_and2_2$1_0.VSS.n2178 17.0005
R1560 wind_comp_0.sg13g2_and2_2$1_0.VSS.n8 wind_comp_0.sg13g2_and2_2$1_0.VSS.n474 3.39254
R1561 wind_comp_0.sg13g2_and2_2$1_0.VSS.n8 wind_comp_0.sg13g2_and2_2$1_0.VSS.n2176 17.0005
R1562 wind_comp_0.sg13g2_and2_2$1_0.VSS.n8 wind_comp_0.sg13g2_and2_2$1_0.VSS.n473 3.3984
R1563 wind_comp_0.sg13g2_and2_2$1_0.VSS.n8 wind_comp_0.sg13g2_and2_2$1_0.VSS.n2174 17.0005
R1564 wind_comp_0.sg13g2_and2_2$1_0.VSS.n8 wind_comp_0.sg13g2_and2_2$1_0.VSS.n472 3.39292
R1565 wind_comp_0.sg13g2_and2_2$1_0.VSS.n8 wind_comp_0.sg13g2_and2_2$1_0.VSS.n2172 17.0005
R1566 wind_comp_0.sg13g2_and2_2$1_0.VSS.n8 wind_comp_0.sg13g2_and2_2$1_0.VSS.n471 3.39915
R1567 wind_comp_0.sg13g2_and2_2$1_0.VSS.n8 wind_comp_0.sg13g2_and2_2$1_0.VSS.n2170 17.0005
R1568 wind_comp_0.sg13g2_and2_2$1_0.VSS.n8 wind_comp_0.sg13g2_and2_2$1_0.VSS.n470 3.3989
R1569 wind_comp_0.sg13g2_and2_2$1_0.VSS.n8 wind_comp_0.sg13g2_and2_2$1_0.VSS.n2168 17.0005
R1570 wind_comp_0.sg13g2_and2_2$1_0.VSS.n8 wind_comp_0.sg13g2_and2_2$1_0.VSS.n469 3.39861
R1571 wind_comp_0.sg13g2_and2_2$1_0.VSS.n8 wind_comp_0.sg13g2_and2_2$1_0.VSS.n2166 17.0005
R1572 wind_comp_0.sg13g2_and2_2$1_0.VSS.n8 wind_comp_0.sg13g2_and2_2$1_0.VSS.n468 3.40003
R1573 wind_comp_0.sg13g2_and2_2$1_0.VSS.n8 wind_comp_0.sg13g2_and2_2$1_0.VSS.n2164 17.0005
R1574 wind_comp_0.sg13g2_and2_2$1_0.VSS.n8 wind_comp_0.sg13g2_and2_2$1_0.VSS.n467 3.3993
R1575 wind_comp_0.sg13g2_and2_2$1_0.VSS.n8 wind_comp_0.sg13g2_and2_2$1_0.VSS.n2162 17.0005
R1576 wind_comp_0.sg13g2_and2_2$1_0.VSS.n8 wind_comp_0.sg13g2_and2_2$1_0.VSS.n466 3.40038
R1577 wind_comp_0.sg13g2_and2_2$1_0.VSS.n8 wind_comp_0.sg13g2_and2_2$1_0.VSS.n2160 17.0005
R1578 wind_comp_0.sg13g2_and2_2$1_0.VSS.n8 wind_comp_0.sg13g2_and2_2$1_0.VSS.n465 3.39382
R1579 wind_comp_0.sg13g2_and2_2$1_0.VSS.n8 wind_comp_0.sg13g2_and2_2$1_0.VSS.n2158 17.0005
R1580 wind_comp_0.sg13g2_and2_2$1_0.VSS.n8 wind_comp_0.sg13g2_and2_2$1_0.VSS.n2156 17.0005
R1581 wind_comp_0.sg13g2_and2_2$1_0.VSS.n8 wind_comp_0.sg13g2_and2_2$1_0.VSS.n399 8.49855
R1582 wind_comp_0.sg13g2_and2_2$1_0.VSS.n8 wind_comp_0.sg13g2_and2_2$1_0.VSS.n462 3.39373
R1583 wind_comp_0.sg13g2_and2_2$1_0.VSS.n399 wind_comp_0.sg13g2_and2_2$1_0.VSS.n398 0.00589388
R1584 wind_comp_0.sg13g2_and2_2$1_0.VSS.n8 wind_comp_0.sg13g2_and2_2$1_0.VSS.n461 3.39986
R1585 wind_comp_0.sg13g2_and2_2$1_0.VSS.n8 wind_comp_0.sg13g2_and2_2$1_0.VSS.n396 17.0005
R1586 wind_comp_0.sg13g2_and2_2$1_0.VSS.n8 wind_comp_0.sg13g2_and2_2$1_0.VSS.n460 3.39892
R1587 wind_comp_0.sg13g2_and2_2$1_0.VSS.n8 wind_comp_0.sg13g2_and2_2$1_0.VSS.n285 8.49855
R1588 wind_comp_0.sg13g2_and2_2$1_0.VSS.n8 wind_comp_0.sg13g2_and2_2$1_0.VSS.n459 3.39875
R1589 wind_comp_0.sg13g2_and2_2$1_0.VSS.n285 wind_comp_0.sg13g2_and2_2$1_0.VSS.n284 0.00589388
R1590 wind_comp_0.sg13g2_and2_2$1_0.VSS.n8 wind_comp_0.sg13g2_and2_2$1_0.VSS.n458 3.39858
R1591 wind_comp_0.sg13g2_and2_2$1_0.VSS.n8 wind_comp_0.sg13g2_and2_2$1_0.VSS.n282 17.0005
R1592 wind_comp_0.sg13g2_and2_2$1_0.VSS.n8 wind_comp_0.sg13g2_and2_2$1_0.VSS.n457 3.3984
R1593 wind_comp_0.sg13g2_and2_2$1_0.VSS.n8 wind_comp_0.sg13g2_and2_2$1_0.VSS.n1961 17.0005
R1594 wind_comp_0.sg13g2_and2_2$1_0.VSS.n8 wind_comp_0.sg13g2_and2_2$1_0.VSS.n456 3.39822
R1595 wind_comp_0.sg13g2_and2_2$1_0.VSS.n8 wind_comp_0.sg13g2_and2_2$1_0.VSS.n1960 17.0005
R1596 wind_comp_0.sg13g2_and2_2$1_0.VSS.n8 wind_comp_0.sg13g2_and2_2$1_0.VSS.n455 3.39803
R1597 wind_comp_0.sg13g2_and2_2$1_0.VSS.n8 wind_comp_0.sg13g2_and2_2$1_0.VSS.n629 17.0005
R1598 wind_comp_0.sg13g2_and2_2$1_0.VSS.n8 wind_comp_0.sg13g2_and2_2$1_0.VSS.n1959 17.0005
R1599 wind_comp_0.sg13g2_and2_2$1_0.VSS.n8 wind_comp_0.sg13g2_and2_2$1_0.VSS.n361 8.49855
R1600 wind_comp_0.sg13g2_and2_2$1_0.VSS.n361 wind_comp_0.sg13g2_and2_2$1_0.VSS.n360 0.00589388
R1601 wind_comp_0.sg13g2_and2_2$1_0.VSS.n8 wind_comp_0.sg13g2_and2_2$1_0.VSS.n358 17.0005
R1602 wind_comp_0.sg13g2_and2_2$1_0.VSS.n199 wind_comp_0.sg13g2_and2_2$1_0.VSS.n8 2.12308
R1603 wind_comp_0.sg13g2_and2_2$1_0.VSS.n8 wind_comp_0.comparator_0.dynamic_pcell$1_0.VSS 0.687319
R1604 wind_comp_0.sg13g2_and2_2$1_0.VSS.n10 wind_comp_0.sg13g2_and2_2$1_0.VSS.n155 0.0190445
R1605 wind_comp_0.sg13g2_and2_2$1_0.VSS.n299 wind_comp_0.sg13g2_and2_2$1_0.VSS.n296 0.00211768
R1606 wind_comp_0.sg13g2_and2_2$1_0.VSS.n299 wind_comp_0.sg13g2_and2_2$1_0.VSS.n8 8.50044
R1607 wind_comp_0.sg13g2_and2_2$1_0.VSS.n295 wind_comp_0.sg13g2_and2_2$1_0.VSS.n294 0.00356841
R1608 wind_comp_0.sg13g2_and2_2$1_0.VSS.n8 wind_comp_0.sg13g2_and2_2$1_0.VSS.n295 5.66678
R1609 wind_comp_0.sg13g2_and2_2$1_0.VSS.n199 wind_comp_0.sg13g2_and2_2$1_0.VSS.n198 0.00395797
R1610 wind_comp_0.sg13g2_and2_2$1_0.VSS.n68 wind_comp_0.sg13g2_and2_2$1_0.VSS.n151 0.0989581
R1611 wind_comp_0.sg13g2_and2_2$1_0.VSS.n156 wind_comp_0.sg13g2_and2_2$1_0.VSS.n68 3.39705
R1612 wind_comp_0.sg13g2_and2_2$1_0.VSS.n194 wind_comp_0.sg13g2_and2_2$1_0.VSS.n193 0.00817735
R1613 wind_comp_0.sg13g2_and2_2$1_0.VSS.n148 wind_comp_0.sg13g2_and2_2$1_0.VSS.n294 0.00562886
R1614 wind_comp_0.sg13g2_and2_2$1_0.VSS.n149 wind_comp_0.sg13g2_and2_2$1_0.VSS.n148 0.00645022
R1615 wind_comp_0.sg13g2_and2_2$1_0.VSS.n85 wind_comp_0.sg13g2_and2_2$1_0.VSS.n363 17.0005
R1616 wind_comp_0.sg13g2_and2_2$1_0.VSS.n85 wind_comp_0.sg13g2_and2_2$1_0.VSS.n393 17.0005
R1617 wind_comp_0.sg13g2_and2_2$1_0.VSS.n2568 wind_comp_0.sg13g2_and2_2$1_0.VSS.n81 17.0005
R1618 wind_comp_0.sg13g2_and2_2$1_0.VSS.n1304 wind_comp_0.sg13g2_and2_2$1_0.VSS.n81 17.0005
R1619 wind_comp_0.sg13g2_and2_2$1_0.VSS.n74 wind_comp_0.sg13g2_and2_2$1_0.VSS.n73 0.00658373
R1620 wind_comp_0.sg13g2_and2_2$1_0.VSS.n1303 wind_comp_0.sg13g2_and2_2$1_0.VSS.n81 17.0005
R1621 wind_comp_0.sg13g2_and2_2$1_0.VSS.n192 wind_comp_0.sg13g2_and2_2$1_0.VSS.n81 17.0005
R1622 wind_comp_0.sg13g2_and2_2$1_0.VSS.n81 wind_comp_0.sg13g2_and2_2$1_0.VSS.n1230 17.0005
R1623 wind_comp_0.sg13g2_and2_2$1_0.VSS.n81 wind_comp_0.sg13g2_and2_2$1_0.VSS.n1258 17.0005
R1624 wind_comp_0.sg13g2_and2_2$1_0.VSS.n81 wind_comp_0.sg13g2_and2_2$1_0.VSS.n1231 17.0005
R1625 wind_comp_0.sg13g2_and2_2$1_0.VSS.n1295 wind_comp_0.sg13g2_and2_2$1_0.VSS.n81 17.0005
R1626 wind_comp_0.sg13g2_and2_2$1_0.VSS.n81 wind_comp_0.sg13g2_and2_2$1_0.VSS.n1257 17.0005
R1627 wind_comp_0.sg13g2_and2_2$1_0.VSS.n81 wind_comp_0.sg13g2_and2_2$1_0.VSS.n1232 17.0005
R1628 wind_comp_0.sg13g2_and2_2$1_0.VSS.n1289 wind_comp_0.sg13g2_and2_2$1_0.VSS.n81 17.0005
R1629 wind_comp_0.sg13g2_and2_2$1_0.VSS.n81 wind_comp_0.sg13g2_and2_2$1_0.VSS.n1256 17.0005
R1630 wind_comp_0.sg13g2_and2_2$1_0.VSS.n81 wind_comp_0.sg13g2_and2_2$1_0.VSS.n1233 17.0005
R1631 wind_comp_0.sg13g2_and2_2$1_0.VSS.n1284 wind_comp_0.sg13g2_and2_2$1_0.VSS.n81 17.0005
R1632 wind_comp_0.sg13g2_and2_2$1_0.VSS.n81 wind_comp_0.sg13g2_and2_2$1_0.VSS.n1255 17.0005
R1633 wind_comp_0.sg13g2_and2_2$1_0.VSS.n81 wind_comp_0.sg13g2_and2_2$1_0.VSS.n1234 17.0005
R1634 wind_comp_0.sg13g2_and2_2$1_0.VSS.n1280 wind_comp_0.sg13g2_and2_2$1_0.VSS.n81 17.0005
R1635 wind_comp_0.sg13g2_and2_2$1_0.VSS.n81 wind_comp_0.sg13g2_and2_2$1_0.VSS.n1254 17.0005
R1636 wind_comp_0.sg13g2_and2_2$1_0.VSS.n81 wind_comp_0.sg13g2_and2_2$1_0.VSS.n1235 17.0005
R1637 wind_comp_0.sg13g2_and2_2$1_0.VSS.n81 wind_comp_0.sg13g2_and2_2$1_0.VSS.n1253 17.0005
R1638 wind_comp_0.sg13g2_and2_2$1_0.VSS.n81 wind_comp_0.sg13g2_and2_2$1_0.VSS.n1236 17.0005
R1639 wind_comp_0.sg13g2_and2_2$1_0.VSS.n1272 wind_comp_0.sg13g2_and2_2$1_0.VSS.n81 17.0005
R1640 wind_comp_0.sg13g2_and2_2$1_0.VSS.n81 wind_comp_0.sg13g2_and2_2$1_0.VSS.n1252 17.0005
R1641 wind_comp_0.sg13g2_and2_2$1_0.VSS.n81 wind_comp_0.sg13g2_and2_2$1_0.VSS.n1237 17.0005
R1642 wind_comp_0.sg13g2_and2_2$1_0.VSS.n1268 wind_comp_0.sg13g2_and2_2$1_0.VSS.n81 17.0005
R1643 wind_comp_0.sg13g2_and2_2$1_0.VSS.n81 wind_comp_0.sg13g2_and2_2$1_0.VSS.n1251 17.0005
R1644 wind_comp_0.sg13g2_and2_2$1_0.VSS.n81 wind_comp_0.sg13g2_and2_2$1_0.VSS.n1238 17.0005
R1645 wind_comp_0.sg13g2_and2_2$1_0.VSS.n1404 wind_comp_0.sg13g2_and2_2$1_0.VSS.n81 17.0005
R1646 wind_comp_0.sg13g2_and2_2$1_0.VSS.n81 wind_comp_0.sg13g2_and2_2$1_0.VSS.n1250 17.0005
R1647 wind_comp_0.sg13g2_and2_2$1_0.VSS.n81 wind_comp_0.sg13g2_and2_2$1_0.VSS.n1239 17.0005
R1648 wind_comp_0.sg13g2_and2_2$1_0.VSS.n1511 wind_comp_0.sg13g2_and2_2$1_0.VSS.n81 17.0005
R1649 wind_comp_0.sg13g2_and2_2$1_0.VSS.n81 wind_comp_0.sg13g2_and2_2$1_0.VSS.n1249 17.0005
R1650 wind_comp_0.sg13g2_and2_2$1_0.VSS.n81 wind_comp_0.sg13g2_and2_2$1_0.VSS.n1240 17.0005
R1651 wind_comp_0.sg13g2_and2_2$1_0.VSS.n1264 wind_comp_0.sg13g2_and2_2$1_0.VSS.n81 17.0005
R1652 wind_comp_0.sg13g2_and2_2$1_0.VSS.n81 wind_comp_0.sg13g2_and2_2$1_0.VSS.n1248 17.0005
R1653 wind_comp_0.sg13g2_and2_2$1_0.VSS.n81 wind_comp_0.sg13g2_and2_2$1_0.VSS.n1241 17.0005
R1654 wind_comp_0.sg13g2_and2_2$1_0.VSS.n1413 wind_comp_0.sg13g2_and2_2$1_0.VSS.n81 17.0005
R1655 wind_comp_0.sg13g2_and2_2$1_0.VSS.n81 wind_comp_0.sg13g2_and2_2$1_0.VSS.n1247 17.0005
R1656 wind_comp_0.sg13g2_and2_2$1_0.VSS.n81 wind_comp_0.sg13g2_and2_2$1_0.VSS.n1242 17.0005
R1657 wind_comp_0.sg13g2_and2_2$1_0.VSS.n1262 wind_comp_0.sg13g2_and2_2$1_0.VSS.n81 17.0005
R1658 wind_comp_0.sg13g2_and2_2$1_0.VSS.n81 wind_comp_0.sg13g2_and2_2$1_0.VSS.n1246 17.0005
R1659 wind_comp_0.sg13g2_and2_2$1_0.VSS.n81 wind_comp_0.sg13g2_and2_2$1_0.VSS.n1243 17.0005
R1660 wind_comp_0.sg13g2_and2_2$1_0.VSS.n1502 wind_comp_0.sg13g2_and2_2$1_0.VSS.n81 8.50034
R1661 wind_comp_0.sg13g2_and2_2$1_0.VSS.n81 wind_comp_0.sg13g2_and2_2$1_0.VSS.n1245 17.0005
R1662 wind_comp_0.sg13g2_and2_2$1_0.VSS.n81 wind_comp_0.sg13g2_and2_2$1_0.VSS.n1244 17.0005
R1663 wind_comp_0.sg13g2_and2_2$1_0.VSS.n8 wind_comp_0.sg13g2_and2_2$1_0.VSS.n463 3.38593
R1664 wind_comp_0.sg13g2_and2_2$1_0.VSS.n8 wind_comp_0.sg13g2_and2_2$1_0.VSS.t338 3.33912
R1665 wind_comp_0.sg13g2_and2_2$1_0.VSS.n8 wind_comp_0.sg13g2_and2_2$1_0.VSS.t341 3.38498
R1666 wind_comp_0.sg13g2_and2_2$1_0.VSS.n8 wind_comp_0.sg13g2_and2_2$1_0.VSS.n488 3.33662
R1667 wind_comp_0.sg13g2_and2_2$1_0.VSS.n8 wind_comp_0.sg13g2_and2_2$1_0.VSS.n492 3.36946
R1668 wind_comp_0.sg13g2_and2_2$1_0.VSS.n8 wind_comp_0.sg13g2_and2_2$1_0.VSS.n703 17.0005
R1669 wind_comp_0.sg13g2_and2_2$1_0.VSS.n8 wind_comp_0.sg13g2_and2_2$1_0.VSS.n704 17.0005
R1670 wind_comp_0.sg13g2_and2_2$1_0.VSS.n8 wind_comp_0.sg13g2_and2_2$1_0.VSS.n705 17.0005
R1671 wind_comp_0.sg13g2_and2_2$1_0.VSS.n8 wind_comp_0.sg13g2_and2_2$1_0.VSS.n706 17.0005
R1672 wind_comp_0.sg13g2_and2_2$1_0.VSS.n8 wind_comp_0.sg13g2_and2_2$1_0.VSS.n707 17.0005
R1673 wind_comp_0.sg13g2_and2_2$1_0.VSS.n8 wind_comp_0.sg13g2_and2_2$1_0.VSS.n708 17.0005
R1674 wind_comp_0.sg13g2_and2_2$1_0.VSS.n8 wind_comp_0.sg13g2_and2_2$1_0.VSS.n501 3.38801
R1675 wind_comp_0.sg13g2_and2_2$1_0.VSS.n8 wind_comp_0.sg13g2_and2_2$1_0.VSS.n709 17.0005
R1676 wind_comp_0.sg13g2_and2_2$1_0.VSS.n8 wind_comp_0.sg13g2_and2_2$1_0.VSS.n710 17.0005
R1677 wind_comp_0.sg13g2_and2_2$1_0.VSS.n8 wind_comp_0.sg13g2_and2_2$1_0.VSS.n711 17.0005
R1678 wind_comp_0.sg13g2_and2_2$1_0.VSS.n8 wind_comp_0.sg13g2_and2_2$1_0.VSS.n712 17.0005
R1679 wind_comp_0.sg13g2_and2_2$1_0.VSS.n8 wind_comp_0.sg13g2_and2_2$1_0.VSS.n713 17.0005
R1680 wind_comp_0.sg13g2_and2_2$1_0.VSS.n8 wind_comp_0.sg13g2_and2_2$1_0.VSS.n714 17.0005
R1681 wind_comp_0.sg13g2_and2_2$1_0.VSS.n8 wind_comp_0.sg13g2_and2_2$1_0.VSS.n715 17.0005
R1682 wind_comp_0.sg13g2_and2_2$1_0.VSS.n8 wind_comp_0.sg13g2_and2_2$1_0.VSS.n508 3.39127
R1683 wind_comp_0.sg13g2_and2_2$1_0.VSS.n8 wind_comp_0.sg13g2_and2_2$1_0.VSS.n716 17.0005
R1684 wind_comp_0.sg13g2_and2_2$1_0.VSS.n8 wind_comp_0.sg13g2_and2_2$1_0.VSS.n509 3.37609
R1685 wind_comp_0.sg13g2_and2_2$1_0.VSS.n8 wind_comp_0.sg13g2_and2_2$1_0.VSS.n717 17.0005
R1686 wind_comp_0.sg13g2_and2_2$1_0.VSS.n8 wind_comp_0.sg13g2_and2_2$1_0.VSS.n718 17.0005
R1687 wind_comp_0.sg13g2_and2_2$1_0.VSS.n8 wind_comp_0.sg13g2_and2_2$1_0.VSS.n719 17.0005
R1688 wind_comp_0.sg13g2_and2_2$1_0.VSS.n8 wind_comp_0.sg13g2_and2_2$1_0.VSS.n721 17.0005
R1689 wind_comp_0.sg13g2_and2_2$1_0.VSS.n8 wind_comp_0.sg13g2_and2_2$1_0.VSS.n515 3.33161
R1690 wind_comp_0.sg13g2_and2_2$1_0.VSS.n8 wind_comp_0.sg13g2_and2_2$1_0.VSS.n722 17.0005
R1691 wind_comp_0.sg13g2_and2_2$1_0.VSS.n8 wind_comp_0.sg13g2_and2_2$1_0.VSS.n723 17.0005
R1692 wind_comp_0.sg13g2_and2_2$1_0.VSS.n8 wind_comp_0.sg13g2_and2_2$1_0.VSS.n724 17.0005
R1693 wind_comp_0.sg13g2_and2_2$1_0.VSS.n8 wind_comp_0.sg13g2_and2_2$1_0.VSS.n518 3.33612
R1694 wind_comp_0.sg13g2_and2_2$1_0.VSS.n8 wind_comp_0.sg13g2_and2_2$1_0.VSS.n725 17.0005
R1695 wind_comp_0.sg13g2_and2_2$1_0.VSS.n8 wind_comp_0.sg13g2_and2_2$1_0.VSS.n519 3.38886
R1696 wind_comp_0.sg13g2_and2_2$1_0.VSS.n8 wind_comp_0.sg13g2_and2_2$1_0.VSS.n726 17.0005
R1697 wind_comp_0.sg13g2_and2_2$1_0.VSS.n8 wind_comp_0.sg13g2_and2_2$1_0.VSS.n520 3.32792
R1698 wind_comp_0.sg13g2_and2_2$1_0.VSS.n8 wind_comp_0.sg13g2_and2_2$1_0.VSS.n727 17.0005
R1699 wind_comp_0.sg13g2_and2_2$1_0.VSS.n8 wind_comp_0.sg13g2_and2_2$1_0.VSS.n728 17.0005
R1700 wind_comp_0.sg13g2_and2_2$1_0.VSS.n8 wind_comp_0.sg13g2_and2_2$1_0.VSS.n729 17.0005
R1701 wind_comp_0.sg13g2_and2_2$1_0.VSS.n8 wind_comp_0.sg13g2_and2_2$1_0.VSS.n730 17.0005
R1702 wind_comp_0.sg13g2_and2_2$1_0.VSS.n8 wind_comp_0.sg13g2_and2_2$1_0.VSS.n731 17.0005
R1703 wind_comp_0.sg13g2_and2_2$1_0.VSS.n701 wind_comp_0.sg13g2_and2_2$1_0.VSS.t274 17.0005
R1704 wind_comp_0.sg13g2_and2_2$1_0.VSS.n201 wind_comp_0.sg13g2_and2_2$1_0.VSS.n230 8.49855
R1705 wind_comp_0.sg13g2_and2_2$1_0.VSS.n230 wind_comp_0.sg13g2_and2_2$1_0.VSS.n229 0.00589388
R1706 wind_comp_0.sg13g2_and2_2$1_0.VSS.n201 wind_comp_0.sg13g2_and2_2$1_0.VSS.n657 17.0005
R1707 wind_comp_0.sg13g2_and2_2$1_0.VSS.n144 wind_comp_0.sg13g2_and2_2$1_0.VSS.n239 0.00589388
R1708 wind_comp_0.sg13g2_and2_2$1_0.VSS.n137 wind_comp_0.sg13g2_and2_2$1_0.VSS.n138 0.00691157
R1709 wind_comp_0.sg13g2_and2_2$1_0.VSS.n119 wind_comp_0.sg13g2_and2_2$1_0.VSS.n137 0.00610573
R1710 wind_comp_0.sg13g2_and2_2$1_0.VSS.n104 wind_comp_0.sg13g2_and2_2$1_0.VSS.n105 0.00940508
R1711 wind_comp_0.sg13g2_and2_2$1_0.VSS.n201 wind_comp_0.sg13g2_and2_2$1_0.VSS.n104 2.41883
R1712 wind_comp_0.sg13g2_and2_2$1_0.VSS.n201 wind_comp_0.sg13g2_and2_2$1_0.VSS.n2453 17.0005
R1713 wind_comp_0.sg13g2_and2_2$1_0.VSS.n201 wind_comp_0.sg13g2_and2_2$1_0.VSS.n2454 17.0005
R1714 wind_comp_0.sg13g2_and2_2$1_0.VSS.n201 wind_comp_0.sg13g2_and2_2$1_0.VSS.n2455 17.0005
R1715 wind_comp_0.sg13g2_and2_2$1_0.VSS.n201 wind_comp_0.sg13g2_and2_2$1_0.VSS.n2456 17.0005
R1716 wind_comp_0.sg13g2_and2_2$1_0.VSS.n201 wind_comp_0.sg13g2_and2_2$1_0.VSS.n2457 17.0005
R1717 wind_comp_0.sg13g2_and2_2$1_0.VSS.n201 wind_comp_0.sg13g2_and2_2$1_0.VSS.n2458 17.0005
R1718 wind_comp_0.sg13g2_and2_2$1_0.VSS.n201 wind_comp_0.sg13g2_and2_2$1_0.VSS.n2459 17.0005
R1719 wind_comp_0.sg13g2_and2_2$1_0.VSS.n201 wind_comp_0.sg13g2_and2_2$1_0.VSS.n2460 17.0005
R1720 wind_comp_0.sg13g2_and2_2$1_0.VSS.n201 wind_comp_0.sg13g2_and2_2$1_0.VSS.n2461 17.0005
R1721 wind_comp_0.sg13g2_and2_2$1_0.VSS.n201 wind_comp_0.sg13g2_and2_2$1_0.VSS.n2462 17.0005
R1722 wind_comp_0.sg13g2_and2_2$1_0.VSS.n201 wind_comp_0.sg13g2_and2_2$1_0.VSS.n2463 17.0005
R1723 wind_comp_0.sg13g2_and2_2$1_0.VSS.n201 wind_comp_0.sg13g2_and2_2$1_0.VSS.n2464 17.0005
R1724 wind_comp_0.sg13g2_and2_2$1_0.VSS.n201 wind_comp_0.sg13g2_and2_2$1_0.VSS.n2465 17.0005
R1725 wind_comp_0.sg13g2_and2_2$1_0.VSS.n201 wind_comp_0.sg13g2_and2_2$1_0.VSS.n2466 17.0005
R1726 wind_comp_0.sg13g2_and2_2$1_0.VSS.n201 wind_comp_0.sg13g2_and2_2$1_0.VSS.n2467 17.0005
R1727 wind_comp_0.sg13g2_and2_2$1_0.VSS.n201 wind_comp_0.sg13g2_and2_2$1_0.VSS.n2468 17.0005
R1728 wind_comp_0.sg13g2_and2_2$1_0.VSS.n201 wind_comp_0.sg13g2_and2_2$1_0.VSS.n2469 17.0005
R1729 wind_comp_0.sg13g2_and2_2$1_0.VSS.n201 wind_comp_0.sg13g2_and2_2$1_0.VSS.n2470 17.0005
R1730 wind_comp_0.sg13g2_and2_2$1_0.VSS.n201 wind_comp_0.sg13g2_and2_2$1_0.VSS.n2471 17.0005
R1731 wind_comp_0.sg13g2_and2_2$1_0.VSS.n201 wind_comp_0.sg13g2_and2_2$1_0.VSS.n2472 17.0005
R1732 wind_comp_0.sg13g2_and2_2$1_0.VSS.n201 wind_comp_0.sg13g2_and2_2$1_0.VSS.n2473 17.0005
R1733 wind_comp_0.sg13g2_and2_2$1_0.VSS.n201 wind_comp_0.sg13g2_and2_2$1_0.VSS.n2474 17.0005
R1734 wind_comp_0.sg13g2_and2_2$1_0.VSS.n201 wind_comp_0.sg13g2_and2_2$1_0.VSS.n2475 17.0005
R1735 wind_comp_0.sg13g2_and2_2$1_0.VSS.n201 wind_comp_0.sg13g2_and2_2$1_0.VSS.n2476 17.0005
R1736 wind_comp_0.sg13g2_and2_2$1_0.VSS.n201 wind_comp_0.sg13g2_and2_2$1_0.VSS.n2477 17.0005
R1737 wind_comp_0.sg13g2_and2_2$1_0.VSS.n201 wind_comp_0.sg13g2_and2_2$1_0.VSS.n2478 17.0005
R1738 wind_comp_0.sg13g2_and2_2$1_0.VSS.n201 wind_comp_0.sg13g2_and2_2$1_0.VSS.n2479 17.0005
R1739 wind_comp_0.sg13g2_and2_2$1_0.VSS.n201 wind_comp_0.sg13g2_and2_2$1_0.VSS.n2480 17.0005
R1740 wind_comp_0.sg13g2_and2_2$1_0.VSS.n201 wind_comp_0.sg13g2_and2_2$1_0.VSS.n2481 17.0005
R1741 wind_comp_0.sg13g2_and2_2$1_0.VSS.n201 wind_comp_0.sg13g2_and2_2$1_0.VSS.n2482 17.0005
R1742 wind_comp_0.sg13g2_and2_2$1_0.VSS.n201 wind_comp_0.sg13g2_and2_2$1_0.VSS.n2483 17.0005
R1743 wind_comp_0.sg13g2_and2_2$1_0.VSS.n201 wind_comp_0.sg13g2_and2_2$1_0.VSS.n2484 17.0005
R1744 wind_comp_0.sg13g2_and2_2$1_0.VSS.n201 wind_comp_0.sg13g2_and2_2$1_0.VSS.n2485 17.0005
R1745 wind_comp_0.sg13g2_and2_2$1_0.VSS.n201 wind_comp_0.sg13g2_and2_2$1_0.VSS.n2486 17.0005
R1746 wind_comp_0.sg13g2_and2_2$1_0.VSS.n201 wind_comp_0.sg13g2_and2_2$1_0.VSS.n2487 17.0005
R1747 wind_comp_0.sg13g2_and2_2$1_0.VSS.n201 wind_comp_0.sg13g2_and2_2$1_0.VSS.n2488 17.0005
R1748 wind_comp_0.sg13g2_and2_2$1_0.VSS.n201 wind_comp_0.sg13g2_and2_2$1_0.VSS.n2489 17.0005
R1749 wind_comp_0.sg13g2_and2_2$1_0.VSS.n201 wind_comp_0.sg13g2_and2_2$1_0.VSS.n2490 17.0005
R1750 wind_comp_0.sg13g2_and2_2$1_0.VSS.n201 wind_comp_0.sg13g2_and2_2$1_0.VSS.n2491 17.0005
R1751 wind_comp_0.sg13g2_and2_2$1_0.VSS.n201 wind_comp_0.sg13g2_and2_2$1_0.VSS.n2492 17.0005
R1752 wind_comp_0.sg13g2_and2_2$1_0.VSS.n201 wind_comp_0.sg13g2_and2_2$1_0.VSS.n2493 17.0005
R1753 wind_comp_0.sg13g2_and2_2$1_0.VSS.n201 wind_comp_0.sg13g2_and2_2$1_0.VSS.n2494 17.0005
R1754 wind_comp_0.sg13g2_and2_2$1_0.VSS.n201 wind_comp_0.sg13g2_and2_2$1_0.VSS.n2495 17.0005
R1755 wind_comp_0.sg13g2_and2_2$1_0.VSS.n201 wind_comp_0.sg13g2_and2_2$1_0.VSS.n2496 17.0005
R1756 wind_comp_0.sg13g2_and2_2$1_0.VSS.n201 wind_comp_0.sg13g2_and2_2$1_0.VSS.n2497 17.0005
R1757 wind_comp_0.sg13g2_and2_2$1_0.VSS.n201 wind_comp_0.sg13g2_and2_2$1_0.VSS.n2498 17.0005
R1758 wind_comp_0.sg13g2_and2_2$1_0.VSS.n201 wind_comp_0.sg13g2_and2_2$1_0.VSS.n2499 17.0005
R1759 wind_comp_0.sg13g2_and2_2$1_0.VSS.n201 wind_comp_0.sg13g2_and2_2$1_0.VSS.n2500 17.0005
R1760 wind_comp_0.sg13g2_and2_2$1_0.VSS.n201 wind_comp_0.sg13g2_and2_2$1_0.VSS.n2501 17.0005
R1761 wind_comp_0.sg13g2_and2_2$1_0.VSS.n201 wind_comp_0.sg13g2_and2_2$1_0.VSS.n2502 17.0005
R1762 wind_comp_0.sg13g2_and2_2$1_0.VSS.n201 wind_comp_0.sg13g2_and2_2$1_0.VSS.n2503 17.0005
R1763 wind_comp_0.sg13g2_and2_2$1_0.VSS.n201 wind_comp_0.sg13g2_and2_2$1_0.VSS.n2504 17.0005
R1764 wind_comp_0.sg13g2_and2_2$1_0.VSS.n201 wind_comp_0.sg13g2_and2_2$1_0.VSS.n2505 17.0005
R1765 wind_comp_0.sg13g2_and2_2$1_0.VSS.n201 wind_comp_0.sg13g2_and2_2$1_0.VSS.n2506 17.0005
R1766 wind_comp_0.sg13g2_and2_2$1_0.VSS.n201 wind_comp_0.sg13g2_and2_2$1_0.VSS.n2507 17.0005
R1767 wind_comp_0.sg13g2_and2_2$1_0.VSS.n201 wind_comp_0.sg13g2_and2_2$1_0.VSS.n2508 17.0005
R1768 wind_comp_0.sg13g2_and2_2$1_0.VSS.n201 wind_comp_0.sg13g2_and2_2$1_0.VSS.n2509 17.0005
R1769 wind_comp_0.sg13g2_and2_2$1_0.VSS.n201 wind_comp_0.sg13g2_and2_2$1_0.VSS.n2510 17.0005
R1770 wind_comp_0.sg13g2_and2_2$1_0.VSS.n201 wind_comp_0.sg13g2_and2_2$1_0.VSS.n2511 17.0005
R1771 wind_comp_0.sg13g2_and2_2$1_0.VSS.n201 wind_comp_0.sg13g2_and2_2$1_0.VSS.n2512 17.0005
R1772 wind_comp_0.sg13g2_and2_2$1_0.VSS.n201 wind_comp_0.sg13g2_and2_2$1_0.VSS.n2513 17.0005
R1773 wind_comp_0.sg13g2_and2_2$1_0.VSS.n201 wind_comp_0.sg13g2_and2_2$1_0.VSS.n2514 17.0005
R1774 wind_comp_0.sg13g2_and2_2$1_0.VSS.n201 wind_comp_0.sg13g2_and2_2$1_0.VSS.n2515 17.0005
R1775 wind_comp_0.sg13g2_and2_2$1_0.VSS.n201 wind_comp_0.sg13g2_and2_2$1_0.VSS.n2516 17.0005
R1776 wind_comp_0.sg13g2_and2_2$1_0.VSS.n68 wind_comp_0.sg13g2_and2_2$1_0.VSS.n1815 17.0005
R1777 wind_comp_0.sg13g2_and2_2$1_0.VSS.n68 wind_comp_0.sg13g2_and2_2$1_0.VSS.n1753 17.0005
R1778 wind_comp_0.sg13g2_and2_2$1_0.VSS.n68 wind_comp_0.sg13g2_and2_2$1_0.VSS.n1814 17.0005
R1779 wind_comp_0.sg13g2_and2_2$1_0.VSS.n68 wind_comp_0.sg13g2_and2_2$1_0.VSS.n1754 17.0005
R1780 wind_comp_0.sg13g2_and2_2$1_0.VSS.n68 wind_comp_0.sg13g2_and2_2$1_0.VSS.n1813 17.0005
R1781 wind_comp_0.sg13g2_and2_2$1_0.VSS.n68 wind_comp_0.sg13g2_and2_2$1_0.VSS.n1755 17.0005
R1782 wind_comp_0.sg13g2_and2_2$1_0.VSS.n68 wind_comp_0.sg13g2_and2_2$1_0.VSS.n1812 17.0005
R1783 wind_comp_0.sg13g2_and2_2$1_0.VSS.n68 wind_comp_0.sg13g2_and2_2$1_0.VSS.n1756 17.0005
R1784 wind_comp_0.sg13g2_and2_2$1_0.VSS.n68 wind_comp_0.sg13g2_and2_2$1_0.VSS.n1811 17.0005
R1785 wind_comp_0.sg13g2_and2_2$1_0.VSS.n68 wind_comp_0.sg13g2_and2_2$1_0.VSS.n1757 17.0005
R1786 wind_comp_0.sg13g2_and2_2$1_0.VSS.n68 wind_comp_0.sg13g2_and2_2$1_0.VSS.n1810 17.0005
R1787 wind_comp_0.sg13g2_and2_2$1_0.VSS.n68 wind_comp_0.sg13g2_and2_2$1_0.VSS.n1759 17.0005
R1788 wind_comp_0.sg13g2_and2_2$1_0.VSS.n68 wind_comp_0.sg13g2_and2_2$1_0.VSS.n1809 17.0005
R1789 wind_comp_0.sg13g2_and2_2$1_0.VSS.n68 wind_comp_0.sg13g2_and2_2$1_0.VSS.n1760 17.0005
R1790 wind_comp_0.sg13g2_and2_2$1_0.VSS.n68 wind_comp_0.sg13g2_and2_2$1_0.VSS.n1808 17.0005
R1791 wind_comp_0.sg13g2_and2_2$1_0.VSS.n68 wind_comp_0.sg13g2_and2_2$1_0.VSS.n1761 17.0005
R1792 wind_comp_0.sg13g2_and2_2$1_0.VSS.n68 wind_comp_0.sg13g2_and2_2$1_0.VSS.n1807 17.0005
R1793 wind_comp_0.sg13g2_and2_2$1_0.VSS.n68 wind_comp_0.sg13g2_and2_2$1_0.VSS.n1762 17.0005
R1794 wind_comp_0.sg13g2_and2_2$1_0.VSS.n68 wind_comp_0.sg13g2_and2_2$1_0.VSS.n1806 17.0005
R1795 wind_comp_0.sg13g2_and2_2$1_0.VSS.n68 wind_comp_0.sg13g2_and2_2$1_0.VSS.n1763 17.0005
R1796 wind_comp_0.sg13g2_and2_2$1_0.VSS.n68 wind_comp_0.sg13g2_and2_2$1_0.VSS.n1805 17.0005
R1797 wind_comp_0.sg13g2_and2_2$1_0.VSS.n68 wind_comp_0.sg13g2_and2_2$1_0.VSS.n1764 17.0005
R1798 wind_comp_0.sg13g2_and2_2$1_0.VSS.n68 wind_comp_0.sg13g2_and2_2$1_0.VSS.n1804 17.0005
R1799 wind_comp_0.sg13g2_and2_2$1_0.VSS.n68 wind_comp_0.sg13g2_and2_2$1_0.VSS.n1765 17.0005
R1800 wind_comp_0.sg13g2_and2_2$1_0.VSS.n68 wind_comp_0.sg13g2_and2_2$1_0.VSS.n1803 17.0005
R1801 wind_comp_0.sg13g2_and2_2$1_0.VSS.n68 wind_comp_0.sg13g2_and2_2$1_0.VSS.n1766 17.0005
R1802 wind_comp_0.sg13g2_and2_2$1_0.VSS.n68 wind_comp_0.sg13g2_and2_2$1_0.VSS.n1802 17.0005
R1803 wind_comp_0.sg13g2_and2_2$1_0.VSS.n68 wind_comp_0.sg13g2_and2_2$1_0.VSS.n1767 17.0005
R1804 wind_comp_0.sg13g2_and2_2$1_0.VSS.n68 wind_comp_0.sg13g2_and2_2$1_0.VSS.n1801 17.0005
R1805 wind_comp_0.sg13g2_and2_2$1_0.VSS.n68 wind_comp_0.sg13g2_and2_2$1_0.VSS.n1768 17.0005
R1806 wind_comp_0.sg13g2_and2_2$1_0.VSS.n68 wind_comp_0.sg13g2_and2_2$1_0.VSS.n1800 17.0005
R1807 wind_comp_0.sg13g2_and2_2$1_0.VSS.n68 wind_comp_0.sg13g2_and2_2$1_0.VSS.n1769 17.0005
R1808 wind_comp_0.sg13g2_and2_2$1_0.VSS.n68 wind_comp_0.sg13g2_and2_2$1_0.VSS.n1799 17.0005
R1809 wind_comp_0.sg13g2_and2_2$1_0.VSS.n68 wind_comp_0.sg13g2_and2_2$1_0.VSS.n1770 17.0005
R1810 wind_comp_0.sg13g2_and2_2$1_0.VSS.n68 wind_comp_0.sg13g2_and2_2$1_0.VSS.n1798 17.0005
R1811 wind_comp_0.sg13g2_and2_2$1_0.VSS.n68 wind_comp_0.sg13g2_and2_2$1_0.VSS.n1771 17.0005
R1812 wind_comp_0.sg13g2_and2_2$1_0.VSS.n68 wind_comp_0.sg13g2_and2_2$1_0.VSS.n1797 17.0005
R1813 wind_comp_0.sg13g2_and2_2$1_0.VSS.n68 wind_comp_0.sg13g2_and2_2$1_0.VSS.n1772 17.0005
R1814 wind_comp_0.sg13g2_and2_2$1_0.VSS.n68 wind_comp_0.sg13g2_and2_2$1_0.VSS.n1796 17.0005
R1815 wind_comp_0.sg13g2_and2_2$1_0.VSS.n68 wind_comp_0.sg13g2_and2_2$1_0.VSS.n1773 17.0005
R1816 wind_comp_0.sg13g2_and2_2$1_0.VSS.n68 wind_comp_0.sg13g2_and2_2$1_0.VSS.n1795 17.0005
R1817 wind_comp_0.sg13g2_and2_2$1_0.VSS.n68 wind_comp_0.sg13g2_and2_2$1_0.VSS.n1774 17.0005
R1818 wind_comp_0.sg13g2_and2_2$1_0.VSS.n68 wind_comp_0.sg13g2_and2_2$1_0.VSS.n1794 17.0005
R1819 wind_comp_0.sg13g2_and2_2$1_0.VSS.n68 wind_comp_0.sg13g2_and2_2$1_0.VSS.n1775 17.0005
R1820 wind_comp_0.sg13g2_and2_2$1_0.VSS.n68 wind_comp_0.sg13g2_and2_2$1_0.VSS.n1793 17.0005
R1821 wind_comp_0.sg13g2_and2_2$1_0.VSS.n68 wind_comp_0.sg13g2_and2_2$1_0.VSS.n1777 17.0005
R1822 wind_comp_0.sg13g2_and2_2$1_0.VSS.n68 wind_comp_0.sg13g2_and2_2$1_0.VSS.n1792 17.0005
R1823 wind_comp_0.sg13g2_and2_2$1_0.VSS.n68 wind_comp_0.sg13g2_and2_2$1_0.VSS.n1778 17.0005
R1824 wind_comp_0.sg13g2_and2_2$1_0.VSS.n68 wind_comp_0.sg13g2_and2_2$1_0.VSS.n1791 17.0005
R1825 wind_comp_0.sg13g2_and2_2$1_0.VSS.n68 wind_comp_0.sg13g2_and2_2$1_0.VSS.n1779 17.0005
R1826 wind_comp_0.sg13g2_and2_2$1_0.VSS.n68 wind_comp_0.sg13g2_and2_2$1_0.VSS.n1790 17.0005
R1827 wind_comp_0.sg13g2_and2_2$1_0.VSS.n68 wind_comp_0.sg13g2_and2_2$1_0.VSS.n1780 17.0005
R1828 wind_comp_0.sg13g2_and2_2$1_0.VSS.n68 wind_comp_0.sg13g2_and2_2$1_0.VSS.n1789 17.0005
R1829 wind_comp_0.sg13g2_and2_2$1_0.VSS.n68 wind_comp_0.sg13g2_and2_2$1_0.VSS.n1781 17.0005
R1830 wind_comp_0.sg13g2_and2_2$1_0.VSS.n68 wind_comp_0.sg13g2_and2_2$1_0.VSS.n1788 17.0005
R1831 wind_comp_0.sg13g2_and2_2$1_0.VSS.n68 wind_comp_0.sg13g2_and2_2$1_0.VSS.n1782 17.0005
R1832 wind_comp_0.sg13g2_and2_2$1_0.VSS.n68 wind_comp_0.sg13g2_and2_2$1_0.VSS.n1787 17.0005
R1833 wind_comp_0.sg13g2_and2_2$1_0.VSS.n68 wind_comp_0.sg13g2_and2_2$1_0.VSS.n1783 17.0005
R1834 wind_comp_0.sg13g2_and2_2$1_0.VSS.n2518 wind_comp_0.sg13g2_and2_2$1_0.VSS.n68 17.0005
R1835 wind_comp_0.sg13g2_and2_2$1_0.VSS.n68 wind_comp_0.sg13g2_and2_2$1_0.VSS.n609 17.0005
R1836 wind_comp_0.sg13g2_and2_2$1_0.VSS.n85 wind_comp_0.sg13g2_and2_2$1_0.VSS.n1819 17.0005
R1837 wind_comp_0.sg13g2_and2_2$1_0.VSS.n85 wind_comp_0.sg13g2_and2_2$1_0.VSS.n1865 17.0005
R1838 wind_comp_0.sg13g2_and2_2$1_0.VSS.n1866 wind_comp_0.sg13g2_and2_2$1_0.VSS.n85 17.0005
R1839 wind_comp_0.sg13g2_and2_2$1_0.VSS.n93 wind_comp_0.sg13g2_and2_2$1_0.VSS.n85 4.24575
R1840 wind_comp_0.sg13g2_and2_2$1_0.VSS.n120 wind_comp_0.sg13g2_and2_2$1_0.VSS.n187 0.00729396
R1841 wind_comp_0.sg13g2_and2_2$1_0.VSS.n85 wind_comp_0.sg13g2_and2_2$1_0.VSS.n1850 17.0005
R1842 wind_comp_0.sg13g2_and2_2$1_0.VSS.n1848 wind_comp_0.sg13g2_and2_2$1_0.VSS.n83 17.0005
R1843 wind_comp_0.sg13g2_and2_2$1_0.VSS.n97 wind_comp_0.sg13g2_and2_2$1_0.VSS.n91 0.00749741
R1844 wind_comp_0.sg13g2_and2_2$1_0.VSS.n97 wind_comp_0.sg13g2_and2_2$1_0.VSS.n136 0.0114676
R1845 wind_comp_0.sg13g2_and2_2$1_0.VSS.n136 wind_comp_0.sg13g2_and2_2$1_0.VSS.n191 0.0112712
R1846 wind_comp_0.sg13g2_and2_2$1_0.VSS.n50 wind_comp_0.sg13g2_and2_2$1_0.VSS.n183 0.0142242
R1847 wind_comp_0.sg13g2_and2_2$1_0.VSS.n50 wind_comp_0.sg13g2_and2_2$1_0.VSS.n51 0.00797564
R1848 wind_comp_0.sg13g2_and2_2$1_0.VSS.n83 wind_comp_0.sg13g2_and2_2$1_0.VSS.n51 4.24297
R1849 wind_comp_0.sg13g2_and2_2$1_0.VSS.n83 wind_comp_0.sg13g2_and2_2$1_0.VSS.n1594 17.0005
R1850 wind_comp_0.sg13g2_and2_2$1_0.VSS.n83 wind_comp_0.sg13g2_and2_2$1_0.VSS.n619 8.49846
R1851 wind_comp_0.sg13g2_and2_2$1_0.VSS.n619 wind_comp_0.sg13g2_and2_2$1_0.VSS.n618 0.0136016
R1852 wind_comp_0.sg13g2_and2_2$1_0.VSS.n83 wind_comp_0.sg13g2_and2_2$1_0.VSS.n363 8.49299
R1853 wind_comp_0.sg13g2_and2_2$1_0.VSS.n83 wind_comp_0.sg13g2_and2_2$1_0.VSS.n364 8.49323
R1854 wind_comp_0.sg13g2_and2_2$1_0.VSS.n83 wind_comp_0.sg13g2_and2_2$1_0.VSS.n366 8.49347
R1855 wind_comp_0.sg13g2_and2_2$1_0.VSS.n83 wind_comp_0.sg13g2_and2_2$1_0.VSS.n367 8.49372
R1856 wind_comp_0.sg13g2_and2_2$1_0.VSS.n83 wind_comp_0.sg13g2_and2_2$1_0.VSS.n368 8.49396
R1857 wind_comp_0.sg13g2_and2_2$1_0.VSS.n83 wind_comp_0.sg13g2_and2_2$1_0.VSS.n369 8.4942
R1858 wind_comp_0.sg13g2_and2_2$1_0.VSS.n83 wind_comp_0.sg13g2_and2_2$1_0.VSS.n370 8.49445
R1859 wind_comp_0.sg13g2_and2_2$1_0.VSS.n83 wind_comp_0.sg13g2_and2_2$1_0.VSS.n372 8.49964
R1860 wind_comp_0.sg13g2_and2_2$1_0.VSS.n83 wind_comp_0.sg13g2_and2_2$1_0.VSS.n373 8.49469
R1861 wind_comp_0.sg13g2_and2_2$1_0.VSS.n83 wind_comp_0.sg13g2_and2_2$1_0.VSS.n374 8.49494
R1862 wind_comp_0.sg13g2_and2_2$1_0.VSS.n83 wind_comp_0.sg13g2_and2_2$1_0.VSS.n375 8.49519
R1863 wind_comp_0.sg13g2_and2_2$1_0.VSS.n83 wind_comp_0.sg13g2_and2_2$1_0.VSS.n84 0.0295156
R1864 wind_comp_0.sg13g2_and2_2$1_0.VSS.n83 wind_comp_0.sg13g2_and2_2$1_0.VSS.n377 8.49543
R1865 wind_comp_0.sg13g2_and2_2$1_0.VSS.n83 wind_comp_0.sg13g2_and2_2$1_0.VSS.n378 8.49568
R1866 wind_comp_0.sg13g2_and2_2$1_0.VSS.n83 wind_comp_0.sg13g2_and2_2$1_0.VSS.n379 8.49593
R1867 wind_comp_0.sg13g2_and2_2$1_0.VSS.n83 wind_comp_0.sg13g2_and2_2$1_0.VSS.n380 8.49617
R1868 wind_comp_0.sg13g2_and2_2$1_0.VSS.n83 wind_comp_0.sg13g2_and2_2$1_0.VSS.n381 8.49642
R1869 wind_comp_0.sg13g2_and2_2$1_0.VSS.n83 wind_comp_0.sg13g2_and2_2$1_0.VSS.n382 8.49667
R1870 wind_comp_0.sg13g2_and2_2$1_0.VSS.n83 wind_comp_0.sg13g2_and2_2$1_0.VSS.n383 8.49691
R1871 wind_comp_0.sg13g2_and2_2$1_0.VSS.n83 wind_comp_0.sg13g2_and2_2$1_0.VSS.n384 5.65823
R1872 wind_comp_0.sg13g2_and2_2$1_0.VSS.n83 wind_comp_0.sg13g2_and2_2$1_0.VSS.n386 8.50003
R1873 wind_comp_0.sg13g2_and2_2$1_0.VSS.n83 wind_comp_0.sg13g2_and2_2$1_0.VSS.n387 8.49716
R1874 wind_comp_0.sg13g2_and2_2$1_0.VSS.n83 wind_comp_0.sg13g2_and2_2$1_0.VSS.n388 8.49741
R1875 wind_comp_0.sg13g2_and2_2$1_0.VSS.n83 wind_comp_0.sg13g2_and2_2$1_0.VSS.n389 8.49766
R1876 wind_comp_0.sg13g2_and2_2$1_0.VSS.n83 wind_comp_0.sg13g2_and2_2$1_0.VSS.n390 8.49791
R1877 wind_comp_0.sg13g2_and2_2$1_0.VSS.n83 wind_comp_0.sg13g2_and2_2$1_0.VSS.n391 8.49816
R1878 wind_comp_0.sg13g2_and2_2$1_0.VSS.n83 wind_comp_0.sg13g2_and2_2$1_0.VSS.n392 8.49978
R1879 wind_comp_0.sg13g2_and2_2$1_0.VSS.n365 wind_comp_0.sg13g2_and2_2$1_0.VSS.n83 5.66789
R1880 wind_comp_0.sg13g2_and2_2$1_0.VSS.n371 wind_comp_0.sg13g2_and2_2$1_0.VSS.n83 5.66632
R1881 wind_comp_0.sg13g2_and2_2$1_0.VSS.n91 wind_comp_0.sg13g2_and2_2$1_0.VSS.n95 2.44721
R1882 wind_comp_0.sg13g2_and2_2$1_0.VSS.n85 wind_comp_0.sg13g2_and2_2$1_0.VSS.n392 17.0005
R1883 wind_comp_0.sg13g2_and2_2$1_0.VSS.n85 wind_comp_0.sg13g2_and2_2$1_0.VSS.n1820 17.0005
R1884 wind_comp_0.sg13g2_and2_2$1_0.VSS.n85 wind_comp_0.sg13g2_and2_2$1_0.VSS.n391 17.0005
R1885 wind_comp_0.sg13g2_and2_2$1_0.VSS.n85 wind_comp_0.sg13g2_and2_2$1_0.VSS.n1821 17.0005
R1886 wind_comp_0.sg13g2_and2_2$1_0.VSS.n85 wind_comp_0.sg13g2_and2_2$1_0.VSS.n390 17.0005
R1887 wind_comp_0.sg13g2_and2_2$1_0.VSS.n85 wind_comp_0.sg13g2_and2_2$1_0.VSS.n1822 17.0005
R1888 wind_comp_0.sg13g2_and2_2$1_0.VSS.n85 wind_comp_0.sg13g2_and2_2$1_0.VSS.n389 17.0005
R1889 wind_comp_0.sg13g2_and2_2$1_0.VSS.n85 wind_comp_0.sg13g2_and2_2$1_0.VSS.n1823 17.0005
R1890 wind_comp_0.sg13g2_and2_2$1_0.VSS.n85 wind_comp_0.sg13g2_and2_2$1_0.VSS.n388 17.0005
R1891 wind_comp_0.sg13g2_and2_2$1_0.VSS.n85 wind_comp_0.sg13g2_and2_2$1_0.VSS.n1824 17.0005
R1892 wind_comp_0.sg13g2_and2_2$1_0.VSS.n85 wind_comp_0.sg13g2_and2_2$1_0.VSS.n387 17.0005
R1893 wind_comp_0.sg13g2_and2_2$1_0.VSS.n85 wind_comp_0.sg13g2_and2_2$1_0.VSS.n1825 17.0005
R1894 wind_comp_0.sg13g2_and2_2$1_0.VSS.n85 wind_comp_0.sg13g2_and2_2$1_0.VSS.n386 17.0005
R1895 wind_comp_0.sg13g2_and2_2$1_0.VSS.n85 wind_comp_0.sg13g2_and2_2$1_0.VSS.n1826 17.0005
R1896 wind_comp_0.sg13g2_and2_2$1_0.VSS.n85 wind_comp_0.sg13g2_and2_2$1_0.VSS.n385 5.65847
R1897 wind_comp_0.sg13g2_and2_2$1_0.VSS.n85 wind_comp_0.sg13g2_and2_2$1_0.VSS.n1827 17.0005
R1898 wind_comp_0.sg13g2_and2_2$1_0.VSS.n85 wind_comp_0.sg13g2_and2_2$1_0.VSS.n1828 17.0005
R1899 wind_comp_0.sg13g2_and2_2$1_0.VSS.n85 wind_comp_0.sg13g2_and2_2$1_0.VSS.n383 17.0005
R1900 wind_comp_0.sg13g2_and2_2$1_0.VSS.n85 wind_comp_0.sg13g2_and2_2$1_0.VSS.n1829 17.0005
R1901 wind_comp_0.sg13g2_and2_2$1_0.VSS.n85 wind_comp_0.sg13g2_and2_2$1_0.VSS.n382 17.0005
R1902 wind_comp_0.sg13g2_and2_2$1_0.VSS.n85 wind_comp_0.sg13g2_and2_2$1_0.VSS.n1830 17.0005
R1903 wind_comp_0.sg13g2_and2_2$1_0.VSS.n85 wind_comp_0.sg13g2_and2_2$1_0.VSS.n381 17.0005
R1904 wind_comp_0.sg13g2_and2_2$1_0.VSS.n85 wind_comp_0.sg13g2_and2_2$1_0.VSS.n1831 17.0005
R1905 wind_comp_0.sg13g2_and2_2$1_0.VSS.n85 wind_comp_0.sg13g2_and2_2$1_0.VSS.n380 17.0005
R1906 wind_comp_0.sg13g2_and2_2$1_0.VSS.n85 wind_comp_0.sg13g2_and2_2$1_0.VSS.n1832 17.0005
R1907 wind_comp_0.sg13g2_and2_2$1_0.VSS.n85 wind_comp_0.sg13g2_and2_2$1_0.VSS.n379 17.0005
R1908 wind_comp_0.sg13g2_and2_2$1_0.VSS.n85 wind_comp_0.sg13g2_and2_2$1_0.VSS.n1833 17.0005
R1909 wind_comp_0.sg13g2_and2_2$1_0.VSS.n85 wind_comp_0.sg13g2_and2_2$1_0.VSS.n378 17.0005
R1910 wind_comp_0.sg13g2_and2_2$1_0.VSS.n85 wind_comp_0.sg13g2_and2_2$1_0.VSS.n1834 17.0005
R1911 wind_comp_0.sg13g2_and2_2$1_0.VSS.n85 wind_comp_0.sg13g2_and2_2$1_0.VSS.n377 17.0005
R1912 wind_comp_0.sg13g2_and2_2$1_0.VSS.n85 wind_comp_0.sg13g2_and2_2$1_0.VSS.n1835 17.0005
R1913 wind_comp_0.sg13g2_and2_2$1_0.VSS.n84 wind_comp_0.sg13g2_and2_2$1_0.VSS.n376 5.65797
R1914 wind_comp_0.sg13g2_and2_2$1_0.VSS.n85 wind_comp_0.sg13g2_and2_2$1_0.VSS.n1836 17.0005
R1915 wind_comp_0.sg13g2_and2_2$1_0.VSS.n85 wind_comp_0.sg13g2_and2_2$1_0.VSS.n375 17.0005
R1916 wind_comp_0.sg13g2_and2_2$1_0.VSS.n85 wind_comp_0.sg13g2_and2_2$1_0.VSS.n1837 17.0005
R1917 wind_comp_0.sg13g2_and2_2$1_0.VSS.n85 wind_comp_0.sg13g2_and2_2$1_0.VSS.n374 17.0005
R1918 wind_comp_0.sg13g2_and2_2$1_0.VSS.n85 wind_comp_0.sg13g2_and2_2$1_0.VSS.n1838 17.0005
R1919 wind_comp_0.sg13g2_and2_2$1_0.VSS.n85 wind_comp_0.sg13g2_and2_2$1_0.VSS.n373 17.0005
R1920 wind_comp_0.sg13g2_and2_2$1_0.VSS.n85 wind_comp_0.sg13g2_and2_2$1_0.VSS.n1839 17.0005
R1921 wind_comp_0.sg13g2_and2_2$1_0.VSS.n85 wind_comp_0.sg13g2_and2_2$1_0.VSS.n372 17.0005
R1922 wind_comp_0.sg13g2_and2_2$1_0.VSS.n85 wind_comp_0.sg13g2_and2_2$1_0.VSS.n1840 17.0005
R1923 wind_comp_0.sg13g2_and2_2$1_0.VSS.n85 wind_comp_0.sg13g2_and2_2$1_0.VSS.n1841 17.0005
R1924 wind_comp_0.sg13g2_and2_2$1_0.VSS.n85 wind_comp_0.sg13g2_and2_2$1_0.VSS.n370 17.0005
R1925 wind_comp_0.sg13g2_and2_2$1_0.VSS.n85 wind_comp_0.sg13g2_and2_2$1_0.VSS.n1842 17.0005
R1926 wind_comp_0.sg13g2_and2_2$1_0.VSS.n85 wind_comp_0.sg13g2_and2_2$1_0.VSS.n369 17.0005
R1927 wind_comp_0.sg13g2_and2_2$1_0.VSS.n85 wind_comp_0.sg13g2_and2_2$1_0.VSS.n1843 17.0005
R1928 wind_comp_0.sg13g2_and2_2$1_0.VSS.n85 wind_comp_0.sg13g2_and2_2$1_0.VSS.n368 17.0005
R1929 wind_comp_0.sg13g2_and2_2$1_0.VSS.n85 wind_comp_0.sg13g2_and2_2$1_0.VSS.n1844 17.0005
R1930 wind_comp_0.sg13g2_and2_2$1_0.VSS.n85 wind_comp_0.sg13g2_and2_2$1_0.VSS.n367 17.0005
R1931 wind_comp_0.sg13g2_and2_2$1_0.VSS.n85 wind_comp_0.sg13g2_and2_2$1_0.VSS.n1845 17.0005
R1932 wind_comp_0.sg13g2_and2_2$1_0.VSS.n85 wind_comp_0.sg13g2_and2_2$1_0.VSS.n366 17.0005
R1933 wind_comp_0.sg13g2_and2_2$1_0.VSS.n85 wind_comp_0.sg13g2_and2_2$1_0.VSS.n1846 17.0005
R1934 wind_comp_0.sg13g2_and2_2$1_0.VSS.n85 wind_comp_0.sg13g2_and2_2$1_0.VSS.n1847 17.0005
R1935 wind_comp_0.sg13g2_and2_2$1_0.VSS.n85 wind_comp_0.sg13g2_and2_2$1_0.VSS.n364 17.0005
R1936 wind_comp_0.sg13g2_and2_2$1_0.VSS.n617 wind_comp_0.sg13g2_and2_2$1_0.VSS.n616 0.0136016
R1937 wind_comp_0.sg13g2_and2_2$1_0.VSS.n70 wind_comp_0.sg13g2_and2_2$1_0.VSS.n207 5.43906
R1938 wind_comp_0.sg13g2_and2_2$1_0.VSS.n70 wind_comp_0.sg13g2_and2_2$1_0.VSS.n617 8.49846
R1939 wind_comp_0.sg13g2_and2_2$1_0.VSS.n70 wind_comp_0.sg13g2_and2_2$1_0.VSS.n1276 17.0005
R1940 wind_comp_0.sg13g2_and2_2$1_0.VSS.n70 wind_comp_0.sg13g2_and2_2$1_0.VSS.n212 5.18784
R1941 wind_comp_0.sg13g2_and2_2$1_0.VSS.n70 wind_comp_0.sg13g2_and2_2$1_0.VSS.n209 5.18784
R1942 wind_comp_0.sg13g2_and2_2$1_0.VSS.n70 wind_comp_0.sg13g2_and2_2$1_0.VSS.n1290 8.50075
R1943 wind_comp_0.sg13g2_and2_2$1_0.VSS.n1285 wind_comp_0.sg13g2_and2_2$1_0.VSS.n70 8.50154
R1944 wind_comp_0.sg13g2_and2_2$1_0.VSS.n1298 wind_comp_0.sg13g2_and2_2$1_0.VSS.n70 8.50045
R1945 wind_comp_0.sg13g2_and2_2$1_0.VSS.n70 wind_comp_0.sg13g2_and2_2$1_0.VSS.n1302 8.49995
R1946 wind_comp_0.sg13g2_and2_2$1_0.VSS.n1502 wind_comp_0.sg13g2_and2_2$1_0.VSS.n70 17.0005
R1947 wind_comp_0.sg13g2_and2_2$1_0.VSS.n74 wind_comp_0.sg13g2_and2_2$1_0.VSS.n71 0.0013818
R1948 wind_comp_0.sg13g2_and2_2$1_0.VSS.n71 wind_comp_0.sg13g2_and2_2$1_0.VSS.n70 0.00176358
R1949 wind_comp_0.sg13g2_and2_2$1_0.VSS.n70 wind_comp_0.sg13g2_and2_2$1_0.VSS.n1268 17.0005
R1950 wind_comp_0.sg13g2_and2_2$1_0.VSS.n70 wind_comp_0.sg13g2_and2_2$1_0.VSS.n1270 17.0005
R1951 wind_comp_0.sg13g2_and2_2$1_0.VSS.n1284 wind_comp_0.sg13g2_and2_2$1_0.VSS.n70 17.0005
R1952 wind_comp_0.sg13g2_and2_2$1_0.VSS.n1289 wind_comp_0.sg13g2_and2_2$1_0.VSS.n70 17.0005
R1953 wind_comp_0.sg13g2_and2_2$1_0.VSS.n1295 wind_comp_0.sg13g2_and2_2$1_0.VSS.n297 2.85662
R1954 wind_comp_0.sg13g2_and2_2$1_0.VSS.n1297 wind_comp_0.sg13g2_and2_2$1_0.VSS.n70 17.0005
R1955 wind_comp_0.sg13g2_and2_2$1_0.VSS.n1900 wind_comp_0.sg13g2_and2_2$1_0.VSS.n70 17.0005
R1956 wind_comp_0.sg13g2_and2_2$1_0.VSS.n1418 wind_comp_0.sg13g2_and2_2$1_0.VSS.n74 5.66707
R1957 wind_comp_0.sg13g2_and2_2$1_0.VSS.n1262 wind_comp_0.sg13g2_and2_2$1_0.VSS.n74 8.50027
R1958 wind_comp_0.sg13g2_and2_2$1_0.VSS.n1505 wind_comp_0.sg13g2_and2_2$1_0.VSS.n74 5.6674
R1959 wind_comp_0.sg13g2_and2_2$1_0.VSS.n1413 wind_comp_0.sg13g2_and2_2$1_0.VSS.n74 8.50063
R1960 wind_comp_0.sg13g2_and2_2$1_0.VSS.n1508 wind_comp_0.sg13g2_and2_2$1_0.VSS.n74 5.66752
R1961 wind_comp_0.sg13g2_and2_2$1_0.VSS.n1264 wind_comp_0.sg13g2_and2_2$1_0.VSS.n74 8.50072
R1962 wind_comp_0.sg13g2_and2_2$1_0.VSS.n1407 wind_comp_0.sg13g2_and2_2$1_0.VSS.n74 5.66754
R1963 wind_comp_0.sg13g2_and2_2$1_0.VSS.n1511 wind_comp_0.sg13g2_and2_2$1_0.VSS.n74 8.50074
R1964 wind_comp_0.sg13g2_and2_2$1_0.VSS.n1266 wind_comp_0.sg13g2_and2_2$1_0.VSS.n74 5.66749
R1965 wind_comp_0.sg13g2_and2_2$1_0.VSS.n1404 wind_comp_0.sg13g2_and2_2$1_0.VSS.n74 8.50068
R1966 wind_comp_0.sg13g2_and2_2$1_0.VSS.n1515 wind_comp_0.sg13g2_and2_2$1_0.VSS.n71 5.66748
R1967 wind_comp_0.sg13g2_and2_2$1_0.VSS.n1268 wind_comp_0.sg13g2_and2_2$1_0.VSS.n74 17.0005
R1968 wind_comp_0.sg13g2_and2_2$1_0.VSS.n1270 wind_comp_0.sg13g2_and2_2$1_0.VSS.n74 8.50054
R1969 wind_comp_0.sg13g2_and2_2$1_0.VSS.n1272 wind_comp_0.sg13g2_and2_2$1_0.VSS.n74 17.0005
R1970 wind_comp_0.sg13g2_and2_2$1_0.VSS.n1273 wind_comp_0.sg13g2_and2_2$1_0.VSS.n74 8.50032
R1971 wind_comp_0.sg13g2_and2_2$1_0.VSS.n1275 wind_comp_0.sg13g2_and2_2$1_0.VSS.n74 8.50009
R1972 wind_comp_0.sg13g2_and2_2$1_0.VSS.n1278 wind_comp_0.sg13g2_and2_2$1_0.VSS.n74 8.4999
R1973 wind_comp_0.sg13g2_and2_2$1_0.VSS.n1280 wind_comp_0.sg13g2_and2_2$1_0.VSS.n74 17.0005
R1974 wind_comp_0.sg13g2_and2_2$1_0.VSS.n1282 wind_comp_0.sg13g2_and2_2$1_0.VSS.n74 8.49905
R1975 wind_comp_0.sg13g2_and2_2$1_0.VSS.n1284 wind_comp_0.sg13g2_and2_2$1_0.VSS.n74 17.0005
R1976 wind_comp_0.sg13g2_and2_2$1_0.VSS.n1287 wind_comp_0.sg13g2_and2_2$1_0.VSS.n74 8.49734
R1977 wind_comp_0.sg13g2_and2_2$1_0.VSS.n1289 wind_comp_0.sg13g2_and2_2$1_0.VSS.n74 17.0005
R1978 wind_comp_0.sg13g2_and2_2$1_0.VSS.n1292 wind_comp_0.sg13g2_and2_2$1_0.VSS.n74 8.50026
R1979 wind_comp_0.sg13g2_and2_2$1_0.VSS.n1295 wind_comp_0.sg13g2_and2_2$1_0.VSS.n74 17.0005
R1980 wind_comp_0.sg13g2_and2_2$1_0.VSS.n1297 wind_comp_0.sg13g2_and2_2$1_0.VSS.n74 8.49977
R1981 wind_comp_0.sg13g2_and2_2$1_0.VSS.n1300 wind_comp_0.sg13g2_and2_2$1_0.VSS.n74 8.50075
R1982 wind_comp_0.sg13g2_and2_2$1_0.VSS.n1301 wind_comp_0.sg13g2_and2_2$1_0.VSS.n74 5.6661
R1983 wind_comp_0.sg13g2_and2_2$1_0.VSS.n1303 wind_comp_0.sg13g2_and2_2$1_0.VSS.n74 17.0005
R1984 wind_comp_0.sg13g2_and2_2$1_0.VSS.n1900 wind_comp_0.sg13g2_and2_2$1_0.VSS.n74 8.49959
R1985 wind_comp_0.sg13g2_and2_2$1_0.VSS.n1304 wind_comp_0.sg13g2_and2_2$1_0.VSS.n74 17.0005
R1986 wind_comp_0.sg13g2_and2_2$1_0.VSS.n1305 wind_comp_0.sg13g2_and2_2$1_0.VSS.n74 3.39675
R1987 wind_comp_0.sg13g2_and2_2$1_0.VSS.n2568 wind_comp_0.sg13g2_and2_2$1_0.VSS.n74 4.25087
R1988 wind_comp_0.sg13g2_and2_2$1_0.VSS.n124 wind_comp_0.sg13g2_and2_2$1_0.VSS.n1315 17.0005
R1989 wind_comp_0.sg13g2_and2_2$1_0.VSS.n124 wind_comp_0.sg13g2_and2_2$1_0.VSS.n1318 17.0005
R1990 wind_comp_0.sg13g2_and2_2$1_0.VSS.n124 wind_comp_0.sg13g2_and2_2$1_0.VSS.n1320 17.0005
R1991 wind_comp_0.sg13g2_and2_2$1_0.VSS.n124 wind_comp_0.sg13g2_and2_2$1_0.VSS.n1335 17.0005
R1992 wind_comp_0.sg13g2_and2_2$1_0.VSS.n1314 wind_comp_0.sg13g2_and2_2$1_0.VSS.n124 5.66544
R1993 wind_comp_0.sg13g2_and2_2$1_0.VSS.n1355 wind_comp_0.sg13g2_and2_2$1_0.VSS.n124 5.66654
R1994 wind_comp_0.sg13g2_and2_2$1_0.VSS.t251 wind_comp_0.sg13g2_and2_2$1_0.VSS.n124 5.66521
R1995 wind_comp_0.sg13g2_and2_2$1_0.VSS.n1357 wind_comp_0.sg13g2_and2_2$1_0.VSS.n124 5.66499
R1996 wind_comp_0.sg13g2_and2_2$1_0.VSS.n1359 wind_comp_0.sg13g2_and2_2$1_0.VSS.n124 5.66477
R1997 wind_comp_0.sg13g2_and2_2$1_0.VSS.t254 wind_comp_0.sg13g2_and2_2$1_0.VSS.n124 5.66455
R1998 wind_comp_0.sg13g2_and2_2$1_0.VSS.n1361 wind_comp_0.sg13g2_and2_2$1_0.VSS.n124 5.66699
R1999 wind_comp_0.sg13g2_and2_2$1_0.VSS.t257 wind_comp_0.sg13g2_and2_2$1_0.VSS.n124 5.66433
R2000 wind_comp_0.sg13g2_and2_2$1_0.VSS.n1364 wind_comp_0.sg13g2_and2_2$1_0.VSS.n124 5.66411
R2001 wind_comp_0.sg13g2_and2_2$1_0.VSS.n1366 wind_comp_0.sg13g2_and2_2$1_0.VSS.n124 5.66389
R2002 wind_comp_0.sg13g2_and2_2$1_0.VSS.t260 wind_comp_0.sg13g2_and2_2$1_0.VSS.n124 5.66367
R2003 wind_comp_0.sg13g2_and2_2$1_0.VSS.n1368 wind_comp_0.sg13g2_and2_2$1_0.VSS.n124 5.66921
R2004 wind_comp_0.sg13g2_and2_2$1_0.VSS.n1370 wind_comp_0.sg13g2_and2_2$1_0.VSS.n124 5.66345
R2005 wind_comp_0.sg13g2_and2_2$1_0.VSS.t263 wind_comp_0.sg13g2_and2_2$1_0.VSS.n124 5.66324
R2006 wind_comp_0.sg13g2_and2_2$1_0.VSS.n101 wind_comp_0.sg13g2_and2_2$1_0.VSS.n102 0.685992
R2007 wind_comp_0.sg13g2_and2_2$1_0.VSS.n101 wind_comp_0.sg13g2_and2_2$1_0.VSS.n1719 17.0005
R2008 wind_comp_0.sg13g2_and2_2$1_0.VSS.n101 wind_comp_0.sg13g2_and2_2$1_0.VSS.n2519 17.0005
R2009 wind_comp_0.sg13g2_and2_2$1_0.VSS.n101 wind_comp_0.sg13g2_and2_2$1_0.VSS.n1720 17.0005
R2010 wind_comp_0.sg13g2_and2_2$1_0.VSS.n101 wind_comp_0.sg13g2_and2_2$1_0.VSS.n1752 17.0005
R2011 wind_comp_0.sg13g2_and2_2$1_0.VSS.n101 wind_comp_0.sg13g2_and2_2$1_0.VSS.n1721 17.0005
R2012 wind_comp_0.sg13g2_and2_2$1_0.VSS.n101 wind_comp_0.sg13g2_and2_2$1_0.VSS.n1751 17.0005
R2013 wind_comp_0.sg13g2_and2_2$1_0.VSS.n101 wind_comp_0.sg13g2_and2_2$1_0.VSS.n1722 17.0005
R2014 wind_comp_0.sg13g2_and2_2$1_0.VSS.n101 wind_comp_0.sg13g2_and2_2$1_0.VSS.n1750 17.0005
R2015 wind_comp_0.sg13g2_and2_2$1_0.VSS.n101 wind_comp_0.sg13g2_and2_2$1_0.VSS.n1723 17.0005
R2016 wind_comp_0.sg13g2_and2_2$1_0.VSS.n101 wind_comp_0.sg13g2_and2_2$1_0.VSS.n1749 17.0005
R2017 wind_comp_0.sg13g2_and2_2$1_0.VSS.n101 wind_comp_0.sg13g2_and2_2$1_0.VSS.n1724 17.0005
R2018 wind_comp_0.sg13g2_and2_2$1_0.VSS.n101 wind_comp_0.sg13g2_and2_2$1_0.VSS.n1748 17.0005
R2019 wind_comp_0.sg13g2_and2_2$1_0.VSS.n101 wind_comp_0.sg13g2_and2_2$1_0.VSS.n1725 17.0005
R2020 wind_comp_0.sg13g2_and2_2$1_0.VSS.n101 wind_comp_0.sg13g2_and2_2$1_0.VSS.n1747 17.0005
R2021 wind_comp_0.sg13g2_and2_2$1_0.VSS.n101 wind_comp_0.sg13g2_and2_2$1_0.VSS.n1726 17.0005
R2022 wind_comp_0.sg13g2_and2_2$1_0.VSS.n101 wind_comp_0.sg13g2_and2_2$1_0.VSS.n1746 17.0005
R2023 wind_comp_0.sg13g2_and2_2$1_0.VSS.n101 wind_comp_0.sg13g2_and2_2$1_0.VSS.n1727 17.0005
R2024 wind_comp_0.sg13g2_and2_2$1_0.VSS.n101 wind_comp_0.sg13g2_and2_2$1_0.VSS.n1745 17.0005
R2025 wind_comp_0.sg13g2_and2_2$1_0.VSS.n101 wind_comp_0.sg13g2_and2_2$1_0.VSS.n1728 17.0005
R2026 wind_comp_0.sg13g2_and2_2$1_0.VSS.n101 wind_comp_0.sg13g2_and2_2$1_0.VSS.n1744 17.0005
R2027 wind_comp_0.sg13g2_and2_2$1_0.VSS.n101 wind_comp_0.sg13g2_and2_2$1_0.VSS.n1729 17.0005
R2028 wind_comp_0.sg13g2_and2_2$1_0.VSS.n101 wind_comp_0.sg13g2_and2_2$1_0.VSS.n1743 17.0005
R2029 wind_comp_0.sg13g2_and2_2$1_0.VSS.n101 wind_comp_0.sg13g2_and2_2$1_0.VSS.n1730 17.0005
R2030 wind_comp_0.sg13g2_and2_2$1_0.VSS.n101 wind_comp_0.sg13g2_and2_2$1_0.VSS.n1742 17.0005
R2031 wind_comp_0.sg13g2_and2_2$1_0.VSS.n101 wind_comp_0.sg13g2_and2_2$1_0.VSS.n1731 17.0005
R2032 wind_comp_0.sg13g2_and2_2$1_0.VSS.n101 wind_comp_0.sg13g2_and2_2$1_0.VSS.n1741 17.0005
R2033 wind_comp_0.sg13g2_and2_2$1_0.VSS.n101 wind_comp_0.sg13g2_and2_2$1_0.VSS.n1732 17.0005
R2034 wind_comp_0.sg13g2_and2_2$1_0.VSS.n101 wind_comp_0.sg13g2_and2_2$1_0.VSS.n1740 17.0005
R2035 wind_comp_0.sg13g2_and2_2$1_0.VSS.n101 wind_comp_0.sg13g2_and2_2$1_0.VSS.n1733 17.0005
R2036 wind_comp_0.sg13g2_and2_2$1_0.VSS.n101 wind_comp_0.sg13g2_and2_2$1_0.VSS.n1739 17.0005
R2037 wind_comp_0.sg13g2_and2_2$1_0.VSS.n101 wind_comp_0.sg13g2_and2_2$1_0.VSS.n1734 17.0005
R2038 wind_comp_0.sg13g2_and2_2$1_0.VSS.n101 wind_comp_0.sg13g2_and2_2$1_0.VSS.n1738 17.0005
R2039 wind_comp_0.sg13g2_and2_2$1_0.VSS.n101 wind_comp_0.sg13g2_and2_2$1_0.VSS.n1735 17.0005
R2040 wind_comp_0.sg13g2_and2_2$1_0.VSS.n101 wind_comp_0.sg13g2_and2_2$1_0.VSS.n1736 17.0005
R2041 wind_comp_0.sg13g2_and2_2$1_0.VSS.n101 wind_comp_0.sg13g2_and2_2$1_0.VSS.n91 17.0005
R2042 wind_comp_0.sg13g2_and2_2$1_0.VSS.n1849 wind_comp_0.sg13g2_and2_2$1_0.VSS.n101 17.0005
R2043 wind_comp_0.sg13g2_and2_2$1_0.VSS.n188 wind_comp_0.sg13g2_and2_2$1_0.VSS.n101 8.49975
R2044 wind_comp_0.sg13g2_and2_2$1_0.VSS.n101 wind_comp_0.sg13g2_and2_2$1_0.VSS.n94 5.66476
R2045 wind_comp_0.sg13g2_and2_2$1_0.VSS.n101 wind_comp_0.sg13g2_and2_2$1_0.VSS.n1737 17.0005
R2046 wind_comp_0.sg13g2_and2_2$1_0.VSS.n2523 wind_comp_0.sg13g2_and2_2$1_0.VSS.n101 17.0005
R2047 wind_comp_0.sg13g2_and2_2$1_0.VSS.n101 wind_comp_0.sg13g2_and2_2$1_0.VSS.t386 5.661
R2048 wind_comp_0.sg13g2_and2_2$1_0.VSS.n101 wind_comp_0.sg13g2_and2_2$1_0.VSS.n424 5.66625
R2049 wind_comp_0.sg13g2_and2_2$1_0.VSS.n101 wind_comp_0.sg13g2_and2_2$1_0.VSS.n400 5.66121
R2050 wind_comp_0.sg13g2_and2_2$1_0.VSS.n101 wind_comp_0.sg13g2_and2_2$1_0.VSS.t389 5.66603
R2051 wind_comp_0.sg13g2_and2_2$1_0.VSS.n101 wind_comp_0.sg13g2_and2_2$1_0.VSS.n401 5.66143
R2052 wind_comp_0.sg13g2_and2_2$1_0.VSS.n101 wind_comp_0.sg13g2_and2_2$1_0.VSS.n423 5.66581
R2053 wind_comp_0.sg13g2_and2_2$1_0.VSS.n101 wind_comp_0.sg13g2_and2_2$1_0.VSS.n402 5.66164
R2054 wind_comp_0.sg13g2_and2_2$1_0.VSS.n101 wind_comp_0.sg13g2_and2_2$1_0.VSS.n422 5.66558
R2055 wind_comp_0.sg13g2_and2_2$1_0.VSS.n101 wind_comp_0.sg13g2_and2_2$1_0.VSS.n403 5.66713
R2056 wind_comp_0.sg13g2_and2_2$1_0.VSS.n101 wind_comp_0.sg13g2_and2_2$1_0.VSS.n421 5.66536
R2057 wind_comp_0.sg13g2_and2_2$1_0.VSS.n101 wind_comp_0.sg13g2_and2_2$1_0.VSS.n404 5.66186
R2058 wind_comp_0.sg13g2_and2_2$1_0.VSS.n101 wind_comp_0.sg13g2_and2_2$1_0.VSS.n420 5.66514
R2059 wind_comp_0.sg13g2_and2_2$1_0.VSS.n101 wind_comp_0.sg13g2_and2_2$1_0.VSS.n405 5.66208
R2060 wind_comp_0.sg13g2_and2_2$1_0.VSS.n101 wind_comp_0.sg13g2_and2_2$1_0.VSS.n418 5.66492
R2061 wind_comp_0.sg13g2_and2_2$1_0.VSS.n101 wind_comp_0.sg13g2_and2_2$1_0.VSS.n407 5.66229
R2062 wind_comp_0.sg13g2_and2_2$1_0.VSS.n101 wind_comp_0.sg13g2_and2_2$1_0.VSS.t311 5.6647
R2063 wind_comp_0.sg13g2_and2_2$1_0.VSS.n101 wind_comp_0.sg13g2_and2_2$1_0.VSS.n408 5.66251
R2064 wind_comp_0.sg13g2_and2_2$1_0.VSS.n101 wind_comp_0.sg13g2_and2_2$1_0.VSS.n417 5.66709
R2065 wind_comp_0.sg13g2_and2_2$1_0.VSS.n101 wind_comp_0.sg13g2_and2_2$1_0.VSS.t314 5.66273
R2066 wind_comp_0.sg13g2_and2_2$1_0.VSS.n101 wind_comp_0.sg13g2_and2_2$1_0.VSS.n416 5.66448
R2067 wind_comp_0.sg13g2_and2_2$1_0.VSS.n101 wind_comp_0.sg13g2_and2_2$1_0.VSS.n409 5.66295
R2068 wind_comp_0.sg13g2_and2_2$1_0.VSS.n101 wind_comp_0.sg13g2_and2_2$1_0.VSS.t317 5.66426
R2069 wind_comp_0.sg13g2_and2_2$1_0.VSS.n101 wind_comp_0.sg13g2_and2_2$1_0.VSS.n410 5.66316
R2070 wind_comp_0.sg13g2_and2_2$1_0.VSS.n101 wind_comp_0.sg13g2_and2_2$1_0.VSS.n415 5.66404
R2071 wind_comp_0.sg13g2_and2_2$1_0.VSS.n101 wind_comp_0.sg13g2_and2_2$1_0.VSS.t320 5.66691
R2072 wind_comp_0.sg13g2_and2_2$1_0.VSS.n101 wind_comp_0.sg13g2_and2_2$1_0.VSS.n414 5.66702
R2073 wind_comp_0.sg13g2_and2_2$1_0.VSS.n101 wind_comp_0.sg13g2_and2_2$1_0.VSS.n411 5.66338
R2074 wind_comp_0.sg13g2_and2_2$1_0.VSS.n101 wind_comp_0.sg13g2_and2_2$1_0.VSS.t323 5.66681
R2075 wind_comp_0.sg13g2_and2_2$1_0.VSS.n101 wind_comp_0.sg13g2_and2_2$1_0.VSS.n412 5.6636
R2076 wind_comp_0.sg13g2_and2_2$1_0.VSS.n101 wind_comp_0.sg13g2_and2_2$1_0.VSS.n413 5.66382
R2077 wind_comp_0.sg13g2_and2_2$1_0.VSS.n50 wind_comp_0.sg13g2_and2_2$1_0.VSS.n101 8.49785
R2078 wind_comp_0.sg13g2_and2_2$1_0.VSS.n101 wind_comp_0.sg13g2_and2_2$1_0.VSS.n184 4.24589
R2079 wind_comp_0.sg13g2_and2_2$1_0.VSS.n184 wind_comp_0.sg13g2_and2_2$1_0.VSS.n183 0.011724
R2080 wind_comp_0.sg13g2_and2_2$1_0.VSS.n184 wind_comp_0.sg13g2_and2_2$1_0.VSS.n191 0.0144726
R2081 wind_comp_0.sg13g2_and2_2$1_0.VSS.n101 wind_comp_0.sg13g2_and2_2$1_0.VSS.n136 8.49926
R2082 wind_comp_0.sg13g2_and2_2$1_0.VSS.n2527 wind_comp_0.sg13g2_and2_2$1_0.VSS.n2526 17.0005
R2083 wind_comp_0.sg13g2_and2_2$1_0.VSS.n2527 wind_comp_0.sg13g2_and2_2$1_0.VSS.n668 17.0005
R2084 wind_comp_0.sg13g2_and2_2$1_0.VSS.n2527 wind_comp_0.sg13g2_and2_2$1_0.VSS.n1614 17.0005
R2085 wind_comp_0.sg13g2_and2_2$1_0.VSS.n2527 wind_comp_0.sg13g2_and2_2$1_0.VSS.t198 17.0005
R2086 wind_comp_0.sg13g2_and2_2$1_0.VSS.n2527 wind_comp_0.sg13g2_and2_2$1_0.VSS.n1616 17.0005
R2087 wind_comp_0.sg13g2_and2_2$1_0.VSS.n2527 wind_comp_0.sg13g2_and2_2$1_0.VSS.n1692 17.0005
R2088 wind_comp_0.sg13g2_and2_2$1_0.VSS.n2527 wind_comp_0.sg13g2_and2_2$1_0.VSS.n1619 17.0005
R2089 wind_comp_0.sg13g2_and2_2$1_0.VSS.n2527 wind_comp_0.sg13g2_and2_2$1_0.VSS.n1691 17.0005
R2090 wind_comp_0.sg13g2_and2_2$1_0.VSS.n2527 wind_comp_0.sg13g2_and2_2$1_0.VSS.n1622 17.0005
R2091 wind_comp_0.sg13g2_and2_2$1_0.VSS.n2527 wind_comp_0.sg13g2_and2_2$1_0.VSS.n544 17.0005
R2092 wind_comp_0.sg13g2_and2_2$1_0.VSS.n2527 wind_comp_0.sg13g2_and2_2$1_0.VSS.n1625 17.0005
R2093 wind_comp_0.sg13g2_and2_2$1_0.VSS.n2527 wind_comp_0.sg13g2_and2_2$1_0.VSS.n1690 17.0005
R2094 wind_comp_0.sg13g2_and2_2$1_0.VSS.n2527 wind_comp_0.sg13g2_and2_2$1_0.VSS.n1626 17.0005
R2095 wind_comp_0.sg13g2_and2_2$1_0.VSS.n2527 wind_comp_0.sg13g2_and2_2$1_0.VSS.n1686 17.0005
R2096 wind_comp_0.sg13g2_and2_2$1_0.VSS.n2527 wind_comp_0.sg13g2_and2_2$1_0.VSS.n1627 17.0005
R2097 wind_comp_0.sg13g2_and2_2$1_0.VSS.n2527 wind_comp_0.sg13g2_and2_2$1_0.VSS.n1090 17.0005
R2098 wind_comp_0.sg13g2_and2_2$1_0.VSS.n2527 wind_comp_0.sg13g2_and2_2$1_0.VSS.n1628 17.0005
R2099 wind_comp_0.sg13g2_and2_2$1_0.VSS.n2527 wind_comp_0.sg13g2_and2_2$1_0.VSS.n1681 17.0005
R2100 wind_comp_0.sg13g2_and2_2$1_0.VSS.n2527 wind_comp_0.sg13g2_and2_2$1_0.VSS.n1629 17.0005
R2101 wind_comp_0.sg13g2_and2_2$1_0.VSS.n2527 wind_comp_0.sg13g2_and2_2$1_0.VSS.n1678 17.0005
R2102 wind_comp_0.sg13g2_and2_2$1_0.VSS.n2527 wind_comp_0.sg13g2_and2_2$1_0.VSS.n1630 17.0005
R2103 wind_comp_0.sg13g2_and2_2$1_0.VSS.n2527 wind_comp_0.sg13g2_and2_2$1_0.VSS.n1677 17.0005
R2104 wind_comp_0.sg13g2_and2_2$1_0.VSS.n2527 wind_comp_0.sg13g2_and2_2$1_0.VSS.n1676 17.0005
R2105 wind_comp_0.sg13g2_and2_2$1_0.VSS.n2527 wind_comp_0.sg13g2_and2_2$1_0.VSS.n1631 17.0005
R2106 wind_comp_0.sg13g2_and2_2$1_0.VSS.n2527 wind_comp_0.sg13g2_and2_2$1_0.VSS.n1632 17.0005
R2107 wind_comp_0.sg13g2_and2_2$1_0.VSS.n2527 wind_comp_0.sg13g2_and2_2$1_0.VSS.n1671 17.0005
R2108 wind_comp_0.sg13g2_and2_2$1_0.VSS.n2527 wind_comp_0.sg13g2_and2_2$1_0.VSS.n1633 17.0005
R2109 wind_comp_0.sg13g2_and2_2$1_0.VSS.n2527 wind_comp_0.sg13g2_and2_2$1_0.VSS.n1667 17.0005
R2110 wind_comp_0.sg13g2_and2_2$1_0.VSS.n2528 wind_comp_0.sg13g2_and2_2$1_0.VSS.n2527 17.0005
R2111 wind_comp_0.sg13g2_and2_2$1_0.VSS.n2527 wind_comp_0.sg13g2_and2_2$1_0.VSS.n1663 17.0005
R2112 wind_comp_0.sg13g2_and2_2$1_0.VSS.n2527 wind_comp_0.sg13g2_and2_2$1_0.VSS.n1634 17.0005
R2113 wind_comp_0.sg13g2_and2_2$1_0.VSS.n2527 wind_comp_0.sg13g2_and2_2$1_0.VSS.n1660 17.0005
R2114 wind_comp_0.sg13g2_and2_2$1_0.VSS.n2527 wind_comp_0.sg13g2_and2_2$1_0.VSS.n1635 17.0005
R2115 wind_comp_0.sg13g2_and2_2$1_0.VSS.n2527 wind_comp_0.sg13g2_and2_2$1_0.VSS.n1659 17.0005
R2116 wind_comp_0.sg13g2_and2_2$1_0.VSS.n2527 wind_comp_0.sg13g2_and2_2$1_0.VSS.n1138 17.0005
R2117 wind_comp_0.sg13g2_and2_2$1_0.VSS.n2527 wind_comp_0.sg13g2_and2_2$1_0.VSS.n1658 17.0005
R2118 wind_comp_0.sg13g2_and2_2$1_0.VSS.n2527 wind_comp_0.sg13g2_and2_2$1_0.VSS.n1639 17.0005
R2119 wind_comp_0.sg13g2_and2_2$1_0.VSS.n2527 wind_comp_0.sg13g2_and2_2$1_0.VSS.n1657 17.0005
R2120 wind_comp_0.sg13g2_and2_2$1_0.VSS.n2527 wind_comp_0.sg13g2_and2_2$1_0.VSS.n1642 17.0005
R2121 wind_comp_0.sg13g2_and2_2$1_0.VSS.n2527 wind_comp_0.sg13g2_and2_2$1_0.VSS.n1656 17.0005
R2122 wind_comp_0.sg13g2_and2_2$1_0.VSS.n2527 wind_comp_0.sg13g2_and2_2$1_0.VSS.n1648 17.0005
R2123 wind_comp_0.sg13g2_and2_2$1_0.VSS.n2527 wind_comp_0.sg13g2_and2_2$1_0.VSS.n1655 17.0005
R2124 wind_comp_0.sg13g2_and2_2$1_0.VSS.n2527 wind_comp_0.sg13g2_and2_2$1_0.VSS.t397 17.0005
R2125 wind_comp_0.sg13g2_and2_2$1_0.VSS.n2527 wind_comp_0.sg13g2_and2_2$1_0.VSS.n589 17.0005
R2126 wind_comp_0.sg13g2_and2_2$1_0.VSS.n2527 wind_comp_0.sg13g2_and2_2$1_0.VSS.n1650 17.0005
R2127 wind_comp_0.sg13g2_and2_2$1_0.VSS.n2527 wind_comp_0.sg13g2_and2_2$1_0.VSS.n618 8.49749
R2128 wind_comp_0.sg13g2_and2_2$1_0.VSS.n2527 wind_comp_0.sg13g2_and2_2$1_0.VSS.n1654 17.0005
R2129 wind_comp_0.sg13g2_and2_2$1_0.VSS.n2527 wind_comp_0.sg13g2_and2_2$1_0.VSS.n1653 17.0005
R2130 wind_comp_0.sg13g2_and2_2$1_0.VSS.n2527 wind_comp_0.sg13g2_and2_2$1_0.VSS.n1651 17.0005
R2131 wind_comp_0.sg13g2_and2_2$1_0.VSS.n2527 wind_comp_0.sg13g2_and2_2$1_0.VSS.n1652 17.0005
R2132 wind_comp_0.sg13g2_and2_2$1_0.VSS.n1587 wind_comp_0.sg13g2_and2_2$1_0.VSS.n1586 17.0005
R2133 wind_comp_0.sg13g2_and2_2$1_0.VSS.n1588 wind_comp_0.sg13g2_and2_2$1_0.VSS.n1587 17.0005
R2134 wind_comp_0.sg13g2_and2_2$1_0.VSS.n1587 wind_comp_0.sg13g2_and2_2$1_0.VSS.t328 17.0005
R2135 wind_comp_0.sg13g2_and2_2$1_0.VSS.n1587 wind_comp_0.sg13g2_and2_2$1_0.VSS.n1584 17.0005
R2136 wind_comp_0.sg13g2_and2_2$1_0.VSS.n1587 wind_comp_0.sg13g2_and2_2$1_0.VSS.n1578 17.0005
R2137 wind_comp_0.sg13g2_and2_2$1_0.VSS.n1587 wind_comp_0.sg13g2_and2_2$1_0.VSS.n1581 17.0005
R2138 wind_comp_0.sg13g2_and2_2$1_0.VSS.n1522 wind_comp_0.sg13g2_and2_2$1_0.VSS.n1521 17.0005
R2139 wind_comp_0.sg13g2_and2_2$1_0.VSS.n1522 wind_comp_0.sg13g2_and2_2$1_0.VSS.n1518 17.0005
R2140 wind_comp_0.sg13g2_and2_2$1_0.VSS.n1522 wind_comp_0.sg13g2_and2_2$1_0.VSS.n1401 17.0005
R2141 wind_comp_0.sg13g2_and2_2$1_0.VSS.n1522 wind_comp_0.sg13g2_and2_2$1_0.VSS.n1402 17.0005
R2142 wind_comp_0.sg13g2_and2_2$1_0.VSS.n1522 wind_comp_0.sg13g2_and2_2$1_0.VSS.n1517 17.0005
R2143 wind_comp_0.sg13g2_and2_2$1_0.VSS.n1522 wind_comp_0.sg13g2_and2_2$1_0.VSS.n616 8.49749
R2144 wind_comp_0.sg13g2_and2_2$1_0.VSS.n1522 wind_comp_0.sg13g2_and2_2$1_0.VSS.n508 17.0005
R2145 wind_comp_0.sg13g2_and2_2$1_0.VSS.n1522 wind_comp_0.sg13g2_and2_2$1_0.VSS.t395 17.0005
R2146 wind_comp_0.sg13g2_and2_2$1_0.VSS.n1522 wind_comp_0.sg13g2_and2_2$1_0.VSS.n1405 17.0005
R2147 wind_comp_0.sg13g2_and2_2$1_0.VSS.n1522 wind_comp_0.sg13g2_and2_2$1_0.VSS.n1512 17.0005
R2148 wind_comp_0.sg13g2_and2_2$1_0.VSS.n1522 wind_comp_0.sg13g2_and2_2$1_0.VSS.n1408 17.0005
R2149 wind_comp_0.sg13g2_and2_2$1_0.VSS.n1522 wind_comp_0.sg13g2_and2_2$1_0.VSS.n1509 17.0005
R2150 wind_comp_0.sg13g2_and2_2$1_0.VSS.n1522 wind_comp_0.sg13g2_and2_2$1_0.VSS.n1414 17.0005
R2151 wind_comp_0.sg13g2_and2_2$1_0.VSS.n1522 wind_comp_0.sg13g2_and2_2$1_0.VSS.n1506 17.0005
R2152 wind_comp_0.sg13g2_and2_2$1_0.VSS.n1522 wind_comp_0.sg13g2_and2_2$1_0.VSS.n1419 17.0005
R2153 wind_comp_0.sg13g2_and2_2$1_0.VSS.n1522 wind_comp_0.sg13g2_and2_2$1_0.VSS.n1503 17.0005
R2154 wind_comp_0.sg13g2_and2_2$1_0.VSS.n1522 wind_comp_0.sg13g2_and2_2$1_0.VSS.n1423 17.0005
R2155 wind_comp_0.sg13g2_and2_2$1_0.VSS.n1522 wind_comp_0.sg13g2_and2_2$1_0.VSS.n1500 17.0005
R2156 wind_comp_0.sg13g2_and2_2$1_0.VSS.n1522 wind_comp_0.sg13g2_and2_2$1_0.VSS.n1427 17.0005
R2157 wind_comp_0.sg13g2_and2_2$1_0.VSS.n1522 wind_comp_0.sg13g2_and2_2$1_0.VSS.n1498 17.0005
R2158 wind_comp_0.sg13g2_and2_2$1_0.VSS.n1522 wind_comp_0.sg13g2_and2_2$1_0.VSS.n1431 17.0005
R2159 wind_comp_0.sg13g2_and2_2$1_0.VSS.n1523 wind_comp_0.sg13g2_and2_2$1_0.VSS.n1522 17.0005
R2160 wind_comp_0.sg13g2_and2_2$1_0.VSS.n1522 wind_comp_0.sg13g2_and2_2$1_0.VSS.n1432 17.0005
R2161 wind_comp_0.sg13g2_and2_2$1_0.VSS.n1522 wind_comp_0.sg13g2_and2_2$1_0.VSS.n1493 17.0005
R2162 wind_comp_0.sg13g2_and2_2$1_0.VSS.n1522 wind_comp_0.sg13g2_and2_2$1_0.VSS.n1433 17.0005
R2163 wind_comp_0.sg13g2_and2_2$1_0.VSS.n1522 wind_comp_0.sg13g2_and2_2$1_0.VSS.n1489 17.0005
R2164 wind_comp_0.sg13g2_and2_2$1_0.VSS.n1522 wind_comp_0.sg13g2_and2_2$1_0.VSS.n1487 17.0005
R2165 wind_comp_0.sg13g2_and2_2$1_0.VSS.n1522 wind_comp_0.sg13g2_and2_2$1_0.VSS.n1434 17.0005
R2166 wind_comp_0.sg13g2_and2_2$1_0.VSS.n1522 wind_comp_0.sg13g2_and2_2$1_0.VSS.n1435 17.0005
R2167 wind_comp_0.sg13g2_and2_2$1_0.VSS.n1522 wind_comp_0.sg13g2_and2_2$1_0.VSS.n1485 17.0005
R2168 wind_comp_0.sg13g2_and2_2$1_0.VSS.n1522 wind_comp_0.sg13g2_and2_2$1_0.VSS.n1437 17.0005
R2169 wind_comp_0.sg13g2_and2_2$1_0.VSS.n1522 wind_comp_0.sg13g2_and2_2$1_0.VSS.n1483 17.0005
R2170 wind_comp_0.sg13g2_and2_2$1_0.VSS.n1522 wind_comp_0.sg13g2_and2_2$1_0.VSS.n1438 17.0005
R2171 wind_comp_0.sg13g2_and2_2$1_0.VSS.n1522 wind_comp_0.sg13g2_and2_2$1_0.VSS.n1477 17.0005
R2172 wind_comp_0.sg13g2_and2_2$1_0.VSS.n1522 wind_comp_0.sg13g2_and2_2$1_0.VSS.n1440 17.0005
R2173 wind_comp_0.sg13g2_and2_2$1_0.VSS.n1522 wind_comp_0.sg13g2_and2_2$1_0.VSS.n1474 17.0005
R2174 wind_comp_0.sg13g2_and2_2$1_0.VSS.n1522 wind_comp_0.sg13g2_and2_2$1_0.VSS.n1442 17.0005
R2175 wind_comp_0.sg13g2_and2_2$1_0.VSS.n1522 wind_comp_0.sg13g2_and2_2$1_0.VSS.n1470 17.0005
R2176 wind_comp_0.sg13g2_and2_2$1_0.VSS.n1522 wind_comp_0.sg13g2_and2_2$1_0.VSS.n1443 17.0005
R2177 wind_comp_0.sg13g2_and2_2$1_0.VSS.n1522 wind_comp_0.sg13g2_and2_2$1_0.VSS.n1466 17.0005
R2178 wind_comp_0.sg13g2_and2_2$1_0.VSS.n1522 wind_comp_0.sg13g2_and2_2$1_0.VSS.n466 17.0005
R2179 wind_comp_0.sg13g2_and2_2$1_0.VSS.n1522 wind_comp_0.sg13g2_and2_2$1_0.VSS.n1463 17.0005
R2180 wind_comp_0.sg13g2_and2_2$1_0.VSS.n1522 wind_comp_0.sg13g2_and2_2$1_0.VSS.n1445 17.0005
R2181 wind_comp_0.sg13g2_and2_2$1_0.VSS.n1522 wind_comp_0.sg13g2_and2_2$1_0.VSS.n1461 17.0005
R2182 wind_comp_0.sg13g2_and2_2$1_0.VSS.n1522 wind_comp_0.sg13g2_and2_2$1_0.VSS.n1448 17.0005
R2183 wind_comp_0.sg13g2_and2_2$1_0.VSS.n1522 wind_comp_0.sg13g2_and2_2$1_0.VSS.n1460 17.0005
R2184 wind_comp_0.sg13g2_and2_2$1_0.VSS.n1522 wind_comp_0.sg13g2_and2_2$1_0.VSS.n1452 17.0005
R2185 wind_comp_0.sg13g2_and2_2$1_0.VSS.n1522 wind_comp_0.sg13g2_and2_2$1_0.VSS.n1459 17.0005
R2186 wind_comp_0.sg13g2_and2_2$1_0.VSS.n1522 wind_comp_0.sg13g2_and2_2$1_0.VSS.n1455 17.0005
R2187 wind_comp_0.sg13g2_and2_2$1_0.VSS.n1522 wind_comp_0.sg13g2_and2_2$1_0.VSS.n1457 17.0005
R2188 wind_comp_0.sg13g2_and2_2$1_0.VSS.n1377 wind_comp_0.sg13g2_and2_2$1_0.VSS.n124 5.66566
R2189 wind_comp_0.sg13g2_and2_2$1_0.VSS.n1379 wind_comp_0.sg13g2_and2_2$1_0.VSS.n124 5.66302
R2190 wind_comp_0.sg13g2_and2_2$1_0.VSS.n1381 wind_comp_0.sg13g2_and2_2$1_0.VSS.n124 5.66704
R2191 wind_comp_0.sg13g2_and2_2$1_0.VSS.n1384 wind_comp_0.sg13g2_and2_2$1_0.VSS.n124 5.6628
R2192 wind_comp_0.sg13g2_and2_2$1_0.VSS.n1386 wind_comp_0.sg13g2_and2_2$1_0.VSS.n124 5.66258
R2193 wind_comp_0.sg13g2_and2_2$1_0.VSS.n1387 wind_comp_0.sg13g2_and2_2$1_0.VSS.n124 5.66689
R2194 wind_comp_0.sg13g2_and2_2$1_0.VSS.n1388 wind_comp_0.sg13g2_and2_2$1_0.VSS.n124 5.6661
R2195 wind_comp_0.sg13g2_and2_2$1_0.VSS.n1390 wind_comp_0.sg13g2_and2_2$1_0.VSS.n124 5.66236
R2196 wind_comp_0.sg13g2_and2_2$1_0.VSS.n1392 wind_comp_0.sg13g2_and2_2$1_0.VSS.n124 5.66215
R2197 wind_comp_0.sg13g2_and2_2$1_0.VSS.t336 wind_comp_0.sg13g2_and2_2$1_0.VSS.n124 5.66682
R2198 wind_comp_0.sg13g2_and2_2$1_0.VSS.n1396 wind_comp_0.sg13g2_and2_2$1_0.VSS.n124 5.66701
R2199 wind_comp_0.sg13g2_and2_2$1_0.VSS.n1398 wind_comp_0.sg13g2_and2_2$1_0.VSS.n124 5.66684
R2200 wind_comp_0.sg13g2_and2_2$1_0.VSS.n124 wind_comp_0.sg13g2_and2_2$1_0.VSS.n1339 17.0005
R2201 wind_comp_0.sg13g2_and2_2$1_0.VSS.n124 wind_comp_0.sg13g2_and2_2$1_0.VSS.n1340 17.0005
R2202 wind_comp_0.sg13g2_and2_2$1_0.VSS.n124 wind_comp_0.sg13g2_and2_2$1_0.VSS.n1353 17.0005
R2203 wind_comp_0.sg13g2_and2_2$1_0.VSS.n124 wind_comp_0.sg13g2_and2_2$1_0.VSS.n1354 17.0005
R2204 wind_comp_0.sg13g2_and2_2$1_0.VSS.n79 wind_comp_0.sg13g2_and2_2$1_0.VSS.n291 8.49855
R2205 wind_comp_0.sg13g2_and2_2$1_0.VSS.n79 wind_comp_0.sg13g2_and2_2$1_0.VSS.n659 17.0005
R2206 wind_comp_0.sg13g2_and2_2$1_0.VSS.n79 wind_comp_0.sg13g2_and2_2$1_0.VSS.n658 17.0005
R2207 wind_comp_0.sg13g2_and2_2$1_0.VSS.n79 wind_comp_0.sg13g2_and2_2$1_0.VSS.n910 17.0005
R2208 wind_comp_0.sg13g2_and2_2$1_0.VSS.n79 wind_comp_0.sg13g2_and2_2$1_0.VSS.n613 17.0005
R2209 wind_comp_0.sg13g2_and2_2$1_0.VSS.n79 wind_comp_0.sg13g2_and2_2$1_0.VSS.n911 17.0005
R2210 wind_comp_0.sg13g2_and2_2$1_0.VSS.n79 wind_comp_0.sg13g2_and2_2$1_0.VSS.n912 17.0005
R2211 wind_comp_0.sg13g2_and2_2$1_0.VSS.n79 wind_comp_0.sg13g2_and2_2$1_0.VSS.n913 17.0005
R2212 wind_comp_0.sg13g2_and2_2$1_0.VSS.n288 wind_comp_0.sg13g2_and2_2$1_0.VSS.n286 0.00589388
R2213 wind_comp_0.sg13g2_and2_2$1_0.VSS.n79 wind_comp_0.sg13g2_and2_2$1_0.VSS.n288 8.49855
R2214 wind_comp_0.sg13g2_and2_2$1_0.VSS.n79 wind_comp_0.sg13g2_and2_2$1_0.VSS.n90 4.24832
R2215 wind_comp_0.sg13g2_and2_2$1_0.VSS.n79 wind_comp_0.sg13g2_and2_2$1_0.VSS.n354 8.49902
R2216 wind_comp_0.sg13g2_and2_2$1_0.VSS.n79 wind_comp_0.sg13g2_and2_2$1_0.VSS.n914 17.0005
R2217 wind_comp_0.sg13g2_and2_2$1_0.VSS.n79 wind_comp_0.sg13g2_and2_2$1_0.VSS.n661 17.0005
R2218 wind_comp_0.sg13g2_and2_2$1_0.VSS.n79 wind_comp_0.sg13g2_and2_2$1_0.VSS.n663 17.0005
R2219 wind_comp_0.sg13g2_and2_2$1_0.VSS.n79 wind_comp_0.sg13g2_and2_2$1_0.VSS.n915 17.0005
R2220 wind_comp_0.sg13g2_and2_2$1_0.VSS.n79 wind_comp_0.sg13g2_and2_2$1_0.VSS.n615 17.0005
R2221 wind_comp_0.sg13g2_and2_2$1_0.VSS.n79 wind_comp_0.sg13g2_and2_2$1_0.VSS.n916 17.0005
R2222 wind_comp_0.sg13g2_and2_2$1_0.VSS.n79 wind_comp_0.sg13g2_and2_2$1_0.VSS.n917 17.0005
R2223 wind_comp_0.sg13g2_and2_2$1_0.VSS.n79 wind_comp_0.sg13g2_and2_2$1_0.VSS.n918 17.0005
R2224 wind_comp_0.sg13g2_and2_2$1_0.VSS.n79 wind_comp_0.sg13g2_and2_2$1_0.VSS.n665 17.0005
R2225 wind_comp_0.sg13g2_and2_2$1_0.VSS.n41 wind_comp_0.sg13g2_and2_2$1_0.VSS.n44 0.0178978
R2226 wind_comp_0.sg13g2_and2_2$1_0.VSS.n43 wind_comp_0.sg13g2_and2_2$1_0.VSS.n41 0.00750045
R2227 wind_comp_0.sg13g2_and2_2$1_0.VSS.n79 wind_comp_0.sg13g2_and2_2$1_0.VSS.n43 1.87184
R2228 wind_comp_0.sg13g2_and2_2$1_0.VSS.n291 wind_comp_0.sg13g2_and2_2$1_0.VSS.n289 0.00589388
R2229 wind_comp_0.sg13g2_and2_2$1_0.VSS.n79 wind_comp_0.sg13g2_and2_2$1_0.VSS.n1000 17.0005
R2230 wind_comp_0.sg13g2_and2_2$1_0.VSS.n79 wind_comp_0.sg13g2_and2_2$1_0.VSS.n999 17.0005
R2231 wind_comp_0.sg13g2_and2_2$1_0.VSS.n1018 wind_comp_0.sg13g2_and2_2$1_0.VSS.n79 17.0005
R2232 wind_comp_0.sg13g2_and2_2$1_0.VSS.n79 wind_comp_0.sg13g2_and2_2$1_0.VSS.n1017 17.0005
R2233 wind_comp_0.sg13g2_and2_2$1_0.VSS.n79 wind_comp_0.sg13g2_and2_2$1_0.VSS.n1002 17.0005
R2234 wind_comp_0.sg13g2_and2_2$1_0.VSS.n79 wind_comp_0.sg13g2_and2_2$1_0.VSS.n1001 17.0005
R2235 wind_comp_0.sg13g2_and2_2$1_0.VSS.n79 wind_comp_0.sg13g2_and2_2$1_0.VSS.n1004 17.0005
R2236 wind_comp_0.sg13g2_and2_2$1_0.VSS.n79 wind_comp_0.sg13g2_and2_2$1_0.VSS.n1003 17.0005
R2237 wind_comp_0.sg13g2_and2_2$1_0.VSS.n79 wind_comp_0.sg13g2_and2_2$1_0.VSS.n1006 17.0005
R2238 wind_comp_0.sg13g2_and2_2$1_0.VSS.n79 wind_comp_0.sg13g2_and2_2$1_0.VSS.n1005 17.0005
R2239 wind_comp_0.sg13g2_and2_2$1_0.VSS.n79 wind_comp_0.sg13g2_and2_2$1_0.VSS.n1008 17.0005
R2240 wind_comp_0.sg13g2_and2_2$1_0.VSS.n79 wind_comp_0.sg13g2_and2_2$1_0.VSS.n1007 17.0005
R2241 wind_comp_0.sg13g2_and2_2$1_0.VSS.n79 wind_comp_0.sg13g2_and2_2$1_0.VSS.n1010 17.0005
R2242 wind_comp_0.sg13g2_and2_2$1_0.VSS.n79 wind_comp_0.sg13g2_and2_2$1_0.VSS.n1009 17.0005
R2243 wind_comp_0.sg13g2_and2_2$1_0.VSS.n79 wind_comp_0.sg13g2_and2_2$1_0.VSS.n1012 17.0005
R2244 wind_comp_0.sg13g2_and2_2$1_0.VSS.n79 wind_comp_0.sg13g2_and2_2$1_0.VSS.n1011 17.0005
R2245 wind_comp_0.sg13g2_and2_2$1_0.VSS.n79 wind_comp_0.sg13g2_and2_2$1_0.VSS.n1014 17.0005
R2246 wind_comp_0.sg13g2_and2_2$1_0.VSS.n79 wind_comp_0.sg13g2_and2_2$1_0.VSS.n1013 17.0005
R2247 wind_comp_0.sg13g2_and2_2$1_0.VSS.n79 wind_comp_0.sg13g2_and2_2$1_0.VSS.n1028 17.0005
R2248 wind_comp_0.sg13g2_and2_2$1_0.VSS.n79 wind_comp_0.sg13g2_and2_2$1_0.VSS.n1027 17.0005
R2249 wind_comp_0.sg13g2_and2_2$1_0.VSS.n79 wind_comp_0.sg13g2_and2_2$1_0.VSS.n909 17.0005
R2250 wind_comp_0.sg13g2_and2_2$1_0.VSS.n79 wind_comp_0.sg13g2_and2_2$1_0.VSS.n908 17.0005
R2251 wind_comp_0.sg13g2_and2_2$1_0.VSS.n79 wind_comp_0.sg13g2_and2_2$1_0.VSS.n987 17.0005
R2252 wind_comp_0.sg13g2_and2_2$1_0.VSS.n79 wind_comp_0.sg13g2_and2_2$1_0.VSS.n986 17.0005
R2253 wind_comp_0.sg13g2_and2_2$1_0.VSS.n79 wind_comp_0.sg13g2_and2_2$1_0.VSS.n998 17.0005
R2254 wind_comp_0.sg13g2_and2_2$1_0.VSS.n79 wind_comp_0.sg13g2_and2_2$1_0.VSS.n997 17.0005
R2255 wind_comp_0.sg13g2_and2_2$1_0.VSS.n79 wind_comp_0.sg13g2_and2_2$1_0.VSS.n1031 17.0005
R2256 wind_comp_0.sg13g2_and2_2$1_0.VSS.n79 wind_comp_0.sg13g2_and2_2$1_0.VSS.n1029 17.0005
R2257 wind_comp_0.sg13g2_and2_2$1_0.VSS.n79 wind_comp_0.sg13g2_and2_2$1_0.VSS.n1030 17.0005
R2258 wind_comp_0.sg13g2_and2_2$1_0.VSS.n79 wind_comp_0.sg13g2_and2_2$1_0.VSS.n1033 17.0005
R2259 wind_comp_0.sg13g2_and2_2$1_0.VSS.n79 wind_comp_0.sg13g2_and2_2$1_0.VSS.n1032 17.0005
R2260 wind_comp_0.sg13g2_and2_2$1_0.VSS.n79 wind_comp_0.sg13g2_and2_2$1_0.VSS.n1036 17.0005
R2261 wind_comp_0.sg13g2_and2_2$1_0.VSS.n79 wind_comp_0.sg13g2_and2_2$1_0.VSS.n1034 17.0005
R2262 wind_comp_0.sg13g2_and2_2$1_0.VSS.n79 wind_comp_0.sg13g2_and2_2$1_0.VSS.n1035 17.0005
R2263 wind_comp_0.sg13g2_and2_2$1_0.VSS.n79 wind_comp_0.sg13g2_and2_2$1_0.VSS.n985 17.0005
R2264 wind_comp_0.sg13g2_and2_2$1_0.VSS.n79 wind_comp_0.sg13g2_and2_2$1_0.VSS.n984 17.0005
R2265 wind_comp_0.sg13g2_and2_2$1_0.VSS.n79 wind_comp_0.sg13g2_and2_2$1_0.VSS.n983 17.0005
R2266 wind_comp_0.sg13g2_and2_2$1_0.VSS.n79 wind_comp_0.sg13g2_and2_2$1_0.VSS.n982 17.0005
R2267 wind_comp_0.sg13g2_and2_2$1_0.VSS.n79 wind_comp_0.sg13g2_and2_2$1_0.VSS.n981 17.0005
R2268 wind_comp_0.sg13g2_and2_2$1_0.VSS.n79 wind_comp_0.sg13g2_and2_2$1_0.VSS.n980 17.0005
R2269 wind_comp_0.sg13g2_and2_2$1_0.VSS.n164 wind_comp_0.sg13g2_and2_2$1_0.VSS.n163 0.00642642
R2270 wind_comp_0.sg13g2_and2_2$1_0.VSS.n164 wind_comp_0.sg13g2_and2_2$1_0.VSS.n79 8.49829
R2271 wind_comp_0.sg13g2_and2_2$1_0.VSS.n79 wind_comp_0.sg13g2_and2_2$1_0.VSS.n979 17.0005
R2272 wind_comp_0.sg13g2_and2_2$1_0.VSS.n79 wind_comp_0.sg13g2_and2_2$1_0.VSS.n978 17.0005
R2273 wind_comp_0.sg13g2_and2_2$1_0.VSS.n79 wind_comp_0.sg13g2_and2_2$1_0.VSS.n906 17.0005
R2274 wind_comp_0.sg13g2_and2_2$1_0.VSS.n79 wind_comp_0.sg13g2_and2_2$1_0.VSS.n904 17.0005
R2275 wind_comp_0.sg13g2_and2_2$1_0.VSS.n79 wind_comp_0.sg13g2_and2_2$1_0.VSS.n1050 17.0005
R2276 wind_comp_0.sg13g2_and2_2$1_0.VSS.n1051 wind_comp_0.sg13g2_and2_2$1_0.VSS.n79 17.0005
R2277 wind_comp_0.sg13g2_and2_2$1_0.VSS.n79 wind_comp_0.sg13g2_and2_2$1_0.VSS.n1038 17.0005
R2278 wind_comp_0.sg13g2_and2_2$1_0.VSS.n79 wind_comp_0.sg13g2_and2_2$1_0.VSS.n1037 17.0005
R2279 wind_comp_0.sg13g2_and2_2$1_0.VSS.n79 wind_comp_0.sg13g2_and2_2$1_0.VSS.n1040 17.0005
R2280 wind_comp_0.sg13g2_and2_2$1_0.VSS.n79 wind_comp_0.sg13g2_and2_2$1_0.VSS.n1039 17.0005
R2281 wind_comp_0.sg13g2_and2_2$1_0.VSS.n79 wind_comp_0.sg13g2_and2_2$1_0.VSS.n1042 17.0005
R2282 wind_comp_0.sg13g2_and2_2$1_0.VSS.n79 wind_comp_0.sg13g2_and2_2$1_0.VSS.n1041 17.0005
R2283 wind_comp_0.sg13g2_and2_2$1_0.VSS.n79 wind_comp_0.sg13g2_and2_2$1_0.VSS.n1044 17.0005
R2284 wind_comp_0.sg13g2_and2_2$1_0.VSS.n79 wind_comp_0.sg13g2_and2_2$1_0.VSS.n1043 17.0005
R2285 wind_comp_0.sg13g2_and2_2$1_0.VSS.n79 wind_comp_0.sg13g2_and2_2$1_0.VSS.n1046 17.0005
R2286 wind_comp_0.sg13g2_and2_2$1_0.VSS.n79 wind_comp_0.sg13g2_and2_2$1_0.VSS.n1045 17.0005
R2287 wind_comp_0.sg13g2_and2_2$1_0.VSS.n79 wind_comp_0.sg13g2_and2_2$1_0.VSS.n1047 17.0005
R2288 wind_comp_0.sg13g2_and2_2$1_0.VSS.n22 wind_comp_0.sg13g2_and2_2$1_0.VSS.n21 0.0252203
R2289 wind_comp_0.sg13g2_and2_2$1_0.VSS.n79 wind_comp_0.sg13g2_and2_2$1_0.VSS.n22 5.65162
R2290 wind_comp_0.sg13g2_and2_2$1_0.VSS.n79 wind_comp_0.sg13g2_and2_2$1_0.VSS.n25 4.24195
R2291 wind_comp_0.sg13g2_and2_2$1_0.VSS.n27 wind_comp_0.sg13g2_and2_2$1_0.VSS.n26 0.566519
R2292 wind_comp_0.sg13g2_and2_2$1_0.VSS.n26 wind_comp_0.sg13g2_and2_2$1_0.VSS.n31 0.0075481
R2293 wind_comp_0.sg13g2_and2_2$1_0.VSS.n31 wind_comp_0.sg13g2_and2_2$1_0.VSS.n32 0.0367996
R2294 wind_comp_0.sg13g2_and2_2$1_0.VSS.n79 wind_comp_0.sg13g2_and2_2$1_0.VSS.n49 3.39391
R2295 wind_comp_0.sg13g2_and2_2$1_0.VSS.n48 wind_comp_0.sg13g2_and2_2$1_0.VSS.n49 0.0247428
R2296 wind_comp_0.sg13g2_and2_2$1_0.VSS.n53 wind_comp_0.sg13g2_and2_2$1_0.VSS.n79 0.51961
R2297 wind_comp_0.sg13g2_and2_2$1_0.VSS.n79 wind_comp_0.sg13g2_and2_2$1_0.VSS.n669 17.0005
R2298 wind_comp_0.sg13g2_and2_2$1_0.VSS.n201 wind_comp_0.sg13g2_and2_2$1_0.VSS.n2338 17.0005
R2299 wind_comp_0.sg13g2_and2_2$1_0.VSS.n201 wind_comp_0.sg13g2_and2_2$1_0.VSS.n2339 17.0005
R2300 wind_comp_0.sg13g2_and2_2$1_0.VSS.n201 wind_comp_0.sg13g2_and2_2$1_0.VSS.n2223 17.0005
R2301 wind_comp_0.sg13g2_and2_2$1_0.VSS.n201 wind_comp_0.sg13g2_and2_2$1_0.VSS.n2224 17.0005
R2302 wind_comp_0.sg13g2_and2_2$1_0.VSS.n624 wind_comp_0.sg13g2_and2_2$1_0.VSS.n201 8.49862
R2303 wind_comp_0.sg13g2_and2_2$1_0.VSS.n624 wind_comp_0.sg13g2_and2_2$1_0.VSS.n623 0.0057562
R2304 wind_comp_0.sg13g2_and2_2$1_0.VSS.n19 wind_comp_0.sg13g2_and2_2$1_0.VSS.n17 0.668969
R2305 wind_comp_0.sg13g2_and2_2$1_0.VSS.n201 wind_comp_0.sg13g2_and2_2$1_0.VSS.n19 0.0583183
R2306 wind_comp_0.sg13g2_and2_2$1_0.VSS.n201 wind_comp_0.sg13g2_and2_2$1_0.VSS.n1885 17.0005
R2307 wind_comp_0.sg13g2_and2_2$1_0.VSS.n201 wind_comp_0.sg13g2_and2_2$1_0.VSS.n1884 17.0005
R2308 wind_comp_0.sg13g2_and2_2$1_0.VSS.n201 wind_comp_0.sg13g2_and2_2$1_0.VSS.n1883 17.0005
R2309 wind_comp_0.sg13g2_and2_2$1_0.VSS.n68 wind_comp_0.sg13g2_and2_2$1_0.VSS.n2226 17.0005
R2310 wind_comp_0.sg13g2_and2_2$1_0.VSS.n68 wind_comp_0.sg13g2_and2_2$1_0.VSS.n2225 17.0005
R2311 wind_comp_0.sg13g2_and2_2$1_0.VSS.n68 wind_comp_0.sg13g2_and2_2$1_0.VSS.n2300 17.0005
R2312 wind_comp_0.sg13g2_and2_2$1_0.VSS.n142 wind_comp_0.sg13g2_and2_2$1_0.VSS.n234 0.00590029
R2313 wind_comp_0.sg13g2_and2_2$1_0.VSS.n142 wind_comp_0.sg13g2_and2_2$1_0.VSS.n143 0.0127931
R2314 wind_comp_0.sg13g2_and2_2$1_0.VSS.n68 wind_comp_0.sg13g2_and2_2$1_0.VSS.n143 4.24438
R2315 wind_comp_0.sg13g2_and2_2$1_0.VSS.n68 wind_comp_0.sg13g2_and2_2$1_0.VSS.n1882 17.0005
R2316 wind_comp_0.sg13g2_and2_2$1_0.VSS.n68 wind_comp_0.sg13g2_and2_2$1_0.VSS.n2325 17.0005
R2317 wind_comp_0.sg13g2_and2_2$1_0.VSS.n223 wind_comp_0.sg13g2_and2_2$1_0.VSS.n222 0.00590029
R2318 wind_comp_0.sg13g2_and2_2$1_0.VSS.n223 wind_comp_0.sg13g2_and2_2$1_0.VSS.n68 8.49855
R2319 wind_comp_0.sg13g2_and2_2$1_0.VSS.n2335 wind_comp_0.sg13g2_and2_2$1_0.VSS.n68 17.0005
R2320 wind_comp_0.sg13g2_and2_2$1_0.VSS.n68 wind_comp_0.sg13g2_and2_2$1_0.VSS.n2337 17.0005
R2321 wind_comp_0.sg13g2_and2_2$1_0.VSS.n68 wind_comp_0.sg13g2_and2_2$1_0.VSS.n2326 17.0005
R2322 wind_comp_0.sg13g2_and2_2$1_0.VSS.n68 wind_comp_0.sg13g2_and2_2$1_0.VSS.n1785 17.0005
R2323 wind_comp_0.sg13g2_and2_2$1_0.VSS.n79 wind_comp_0.sg13g2_and2_2$1_0.VSS.n425 3.40081
R2324 wind_comp_0.sg13g2_and2_2$1_0.VSS.n79 wind_comp_0.sg13g2_and2_2$1_0.VSS.n446 3.40041
R2325 wind_comp_0.sg13g2_and2_2$1_0.VSS.n79 wind_comp_0.sg13g2_and2_2$1_0.VSS.n879 17.0005
R2326 wind_comp_0.sg13g2_and2_2$1_0.VSS.n79 wind_comp_0.sg13g2_and2_2$1_0.VSS.n875 17.0005
R2327 wind_comp_0.sg13g2_and2_2$1_0.VSS.n79 wind_comp_0.sg13g2_and2_2$1_0.VSS.n874 17.0005
R2328 wind_comp_0.sg13g2_and2_2$1_0.VSS.n79 wind_comp_0.sg13g2_and2_2$1_0.VSS.n873 17.0005
R2329 wind_comp_0.sg13g2_and2_2$1_0.VSS.n79 wind_comp_0.sg13g2_and2_2$1_0.VSS.n221 8.49956
R2330 wind_comp_0.sg13g2_and2_2$1_0.VSS.n79 wind_comp_0.sg13g2_and2_2$1_0.VSS.n871 17.0005
R2331 wind_comp_0.sg13g2_and2_2$1_0.VSS.n79 wind_comp_0.sg13g2_and2_2$1_0.VSS.n870 17.0005
R2332 wind_comp_0.sg13g2_and2_2$1_0.VSS.n79 wind_comp_0.sg13g2_and2_2$1_0.VSS.n869 17.0005
R2333 wind_comp_0.sg13g2_and2_2$1_0.VSS.n79 wind_comp_0.sg13g2_and2_2$1_0.VSS.n142 8.49855
R2334 wind_comp_0.sg13g2_and2_2$1_0.VSS.n79 wind_comp_0.sg13g2_and2_2$1_0.VSS.n233 5.66432
R2335 wind_comp_0.sg13g2_and2_2$1_0.VSS.n79 wind_comp_0.sg13g2_and2_2$1_0.VSS.n868 17.0005
R2336 wind_comp_0.sg13g2_and2_2$1_0.VSS.n79 wind_comp_0.sg13g2_and2_2$1_0.VSS.n867 17.0005
R2337 wind_comp_0.sg13g2_and2_2$1_0.VSS.n79 wind_comp_0.sg13g2_and2_2$1_0.VSS.n866 17.0005
R2338 wind_comp_0.sg13g2_and2_2$1_0.VSS.n79 wind_comp_0.sg13g2_and2_2$1_0.VSS.n865 17.0005
R2339 wind_comp_0.sg13g2_and2_2$1_0.VSS.n79 wind_comp_0.sg13g2_and2_2$1_0.VSS.n864 17.0005
R2340 wind_comp_0.sg13g2_and2_2$1_0.VSS.n79 wind_comp_0.sg13g2_and2_2$1_0.VSS.n863 17.0005
R2341 wind_comp_0.sg13g2_and2_2$1_0.VSS.n79 wind_comp_0.sg13g2_and2_2$1_0.VSS.n18 1.28721
R2342 wind_comp_0.sg13g2_and2_2$1_0.VSS.n18 wind_comp_0.sg13g2_and2_2$1_0.VSS.n17 0.0106529
R2343 wind_comp_0.sg13g2_and2_2$1_0.VSS.n79 wind_comp_0.sg13g2_and2_2$1_0.VSS.n623 17.0005
R2344 wind_comp_0.sg13g2_and2_2$1_0.VSS.n4 wind_comp_0.sg13g2_and2_2$1_0.VSS.n1975 17.0005
R2345 wind_comp_0.sg13g2_and2_2$1_0.VSS.n29 wind_comp_0.sg13g2_and2_2$1_0.VSS.n40 0.0360779
R2346 wind_comp_0.sg13g2_and2_2$1_0.VSS.n66 wind_comp_0.sg13g2_and2_2$1_0.VSS.n29 0.0706703
R2347 wind_comp_0.sg13g2_and2_2$1_0.VSS.n4 wind_comp_0.sg13g2_and2_2$1_0.VSS.n29 0.714538
R2348 wind_comp_0.sg13g2_and2_2$1_0.VSS.n4 wind_comp_0.sg13g2_and2_2$1_0.VSS.n1999 17.0005
R2349 wind_comp_0.sg13g2_and2_2$1_0.VSS.n4 wind_comp_0.sg13g2_and2_2$1_0.VSS.n2001 17.0005
R2350 wind_comp_0.sg13g2_and2_2$1_0.VSS.n4 wind_comp_0.sg13g2_and2_2$1_0.VSS.n2000 17.0005
R2351 wind_comp_0.sg13g2_and2_2$1_0.VSS.n1995 wind_comp_0.sg13g2_and2_2$1_0.VSS.n4 17.0005
R2352 wind_comp_0.sg13g2_and2_2$1_0.VSS.n4 wind_comp_0.sg13g2_and2_2$1_0.VSS.n1976 17.0005
R2353 wind_comp_0.sg13g2_and2_2$1_0.VSS.n4 wind_comp_0.sg13g2_and2_2$1_0.VSS.n1974 17.0005
R2354 wind_comp_0.sg13g2_and2_2$1_0.VSS.n4 wind_comp_0.sg13g2_and2_2$1_0.VSS.n1982 17.0005
R2355 wind_comp_0.sg13g2_and2_2$1_0.VSS.n4 wind_comp_0.sg13g2_and2_2$1_0.VSS.n13 0.486102
R2356 wind_comp_0.sg13g2_and2_2$1_0.VSS.n4 wind_comp_0.sg13g2_and2_2$1_0.VSS.n2002 17.0005
R2357 wind_comp_0.sg13g2_and2_2$1_0.VSS.n4 wind_comp_0.sg13g2_and2_2$1_0.VSS.n2003 17.0005
R2358 wind_comp_0.sg13g2_and2_2$1_0.VSS.n4 wind_comp_0.sg13g2_and2_2$1_0.VSS.n2005 17.0005
R2359 wind_comp_0.sg13g2_and2_2$1_0.VSS.n4 wind_comp_0.sg13g2_and2_2$1_0.VSS.n2004 17.0005
R2360 wind_comp_0.sg13g2_and2_2$1_0.VSS.n4 wind_comp_0.sg13g2_and2_2$1_0.VSS.n2008 17.0005
R2361 wind_comp_0.sg13g2_and2_2$1_0.VSS.n4 wind_comp_0.sg13g2_and2_2$1_0.VSS.n2006 17.0005
R2362 wind_comp_0.sg13g2_and2_2$1_0.VSS.n4 wind_comp_0.sg13g2_and2_2$1_0.VSS.n2007 17.0005
R2363 wind_comp_0.sg13g2_and2_2$1_0.VSS.n169 wind_comp_0.sg13g2_and2_2$1_0.VSS.n168 0.00625857
R2364 wind_comp_0.sg13g2_and2_2$1_0.VSS.n169 wind_comp_0.sg13g2_and2_2$1_0.VSS.n4 8.49837
R2365 wind_comp_0.sg13g2_and2_2$1_0.VSS.n4 wind_comp_0.sg13g2_and2_2$1_0.VSS.n1979 17.0005
R2366 wind_comp_0.sg13g2_and2_2$1_0.VSS.n4 wind_comp_0.sg13g2_and2_2$1_0.VSS.n1980 17.0005
R2367 wind_comp_0.sg13g2_and2_2$1_0.VSS.n4 wind_comp_0.sg13g2_and2_2$1_0.VSS.n5 0.13162
R2368 wind_comp_0.sg13g2_and2_2$1_0.VSS.n4 wind_comp_0.sg13g2_and2_2$1_0.VSS.n2018 17.0005
R2369 wind_comp_0.sg13g2_and2_2$1_0.VSS.n454 wind_comp_0.sg13g2_and2_2$1_0.VSS.n4 8.49837
R2370 wind_comp_0.sg13g2_and2_2$1_0.VSS.n4 wind_comp_0.sg13g2_and2_2$1_0.VSS.n2016 17.0005
R2371 wind_comp_0.sg13g2_and2_2$1_0.VSS.n4 wind_comp_0.sg13g2_and2_2$1_0.VSS.n2017 17.0005
R2372 wind_comp_0.sg13g2_and2_2$1_0.VSS.n4 wind_comp_0.sg13g2_and2_2$1_0.VSS.n2012 17.0005
R2373 wind_comp_0.sg13g2_and2_2$1_0.VSS.n4 wind_comp_0.sg13g2_and2_2$1_0.VSS.n2011 17.0005
R2374 wind_comp_0.sg13g2_and2_2$1_0.VSS.n4 wind_comp_0.sg13g2_and2_2$1_0.VSS.n2015 17.0005
R2375 wind_comp_0.sg13g2_and2_2$1_0.VSS.n4 wind_comp_0.sg13g2_and2_2$1_0.VSS.n2013 17.0005
R2376 wind_comp_0.sg13g2_and2_2$1_0.VSS.n4 wind_comp_0.sg13g2_and2_2$1_0.VSS.n2014 17.0005
R2377 wind_comp_0.sg13g2_and2_2$1_0.VSS.n4 wind_comp_0.sg13g2_and2_2$1_0.VSS.n2010 17.0005
R2378 wind_comp_0.sg13g2_and2_2$1_0.VSS.n4 wind_comp_0.sg13g2_and2_2$1_0.VSS.n2009 17.0005
R2379 wind_comp_0.sg13g2_and2_2$1_0.VSS.n4 wind_comp_0.sg13g2_and2_2$1_0.VSS.n1978 17.0005
R2380 wind_comp_0.sg13g2_and2_2$1_0.VSS.n4 wind_comp_0.sg13g2_and2_2$1_0.VSS.n1977 17.0005
R2381 wind_comp_0.sg13g2_and2_2$1_0.VSS.n217 wind_comp_0.sg13g2_and2_2$1_0.VSS.n4 8.49837
R2382 wind_comp_0.sg13g2_and2_2$1_0.VSS.n217 wind_comp_0.sg13g2_and2_2$1_0.VSS.n216 0.00625857
R2383 wind_comp_0.sg13g2_and2_2$1_0.VSS.n4 wind_comp_0.sg13g2_and2_2$1_0.VSS.n2024 17.0005
R2384 wind_comp_0.sg13g2_and2_2$1_0.VSS.n6 wind_comp_0.sg13g2_and2_2$1_0.VSS.n4 0.180595
R2385 wind_comp_0.sg13g2_and2_2$1_0.VSS.n4 wind_comp_0.sg13g2_and2_2$1_0.VSS.n267 3.37153
R2386 wind_comp_0.sg13g2_and2_2$1_0.VSS.n4 wind_comp_0.sg13g2_and2_2$1_0.VSS.n268 3.3658
R2387 wind_comp_0.sg13g2_and2_2$1_0.VSS.n4 wind_comp_0.sg13g2_and2_2$1_0.VSS.n269 3.35618
R2388 wind_comp_0.sg13g2_and2_2$1_0.VSS.n4 wind_comp_0.sg13g2_and2_2$1_0.VSS.n264 3.37584
R2389 wind_comp_0.sg13g2_and2_2$1_0.VSS.n4 wind_comp_0.sg13g2_and2_2$1_0.VSS.n270 3.35579
R2390 wind_comp_0.sg13g2_and2_2$1_0.VSS.n4 wind_comp_0.sg13g2_and2_2$1_0.VSS.n271 3.3556
R2391 wind_comp_0.sg13g2_and2_2$1_0.VSS.n4 wind_comp_0.sg13g2_and2_2$1_0.VSS.n272 3.35792
R2392 wind_comp_0.sg13g2_and2_2$1_0.VSS.n4 wind_comp_0.sg13g2_and2_2$1_0.VSS.n274 3.35206
R2393 wind_comp_0.sg13g2_and2_2$1_0.VSS.n4 wind_comp_0.sg13g2_and2_2$1_0.VSS.n275 3.35149
R2394 wind_comp_0.sg13g2_and2_2$1_0.VSS.n4 wind_comp_0.sg13g2_and2_2$1_0.VSS.n258 3.37903
R2395 wind_comp_0.sg13g2_and2_2$1_0.VSS.n4 wind_comp_0.sg13g2_and2_2$1_0.VSS.n276 3.36457
R2396 wind_comp_0.sg13g2_and2_2$1_0.VSS.n4 wind_comp_0.sg13g2_and2_2$1_0.VSS.n277 3.3739
R2397 wind_comp_0.sg13g2_and2_2$1_0.VSS.n4 wind_comp_0.sg13g2_and2_2$1_0.VSS.n256 3.35413
R2398 wind_comp_0.sg13g2_and2_2$1_0.VSS.n4 wind_comp_0.sg13g2_and2_2$1_0.VSS.n278 3.36348
R2399 wind_comp_0.sg13g2_and2_2$1_0.VSS.n4 wind_comp_0.sg13g2_and2_2$1_0.VSS.n279 3.3535
R2400 wind_comp_0.sg13g2_and2_2$1_0.VSS.n4 wind_comp_0.sg13g2_and2_2$1_0.VSS.n254 3.35524
R2401 wind_comp_0.sg13g2_and2_2$1_0.VSS.n4 wind_comp_0.sg13g2_and2_2$1_0.VSS.n280 3.35034
R2402 wind_comp_0.sg13g2_and2_2$1_0.VSS.n4 wind_comp_0.sg13g2_and2_2$1_0.VSS.n259 3.387
R2403 wind_comp_0.sg13g2_and2_2$1_0.VSS.n4 wind_comp_0.sg13g2_and2_2$1_0.VSS.n273 3.38824
R2404 wind_comp_0.sg13g2_and2_2$1_0.VSS.n4 wind_comp_0.sg13g2_and2_2$1_0.VSS.n262 3.37725
R2405 wind_comp_0.sg13g2_and2_2$1_0.VSS.n4 wind_comp_0.sg13g2_and2_2$1_0.VSS.n266 3.39769
R2406 wind_comp_0.sg13g2_and2_2$1_0.VSS.n4 wind_comp_0.sg13g2_and2_2$1_0.VSS.n250 3.49433
R2407 wind_comp_0.sg13g2_and2_2$1_0.VSS.n4 wind_comp_0.sg13g2_and2_2$1_0.VSS.n755 17.0005
R2408 wind_comp_0.sg13g2_and2_2$1_0.VSS.n4 wind_comp_0.sg13g2_and2_2$1_0.VSS.n754 17.0005
R2409 wind_comp_0.sg13g2_and2_2$1_0.VSS.n4 wind_comp_0.sg13g2_and2_2$1_0.VSS.n257 3.35426
R2410 wind_comp_0.sg13g2_and2_2$1_0.VSS.n4 wind_comp_0.sg13g2_and2_2$1_0.VSS.n260 3.35745
R2411 wind_comp_0.sg13g2_and2_2$1_0.VSS.n4 wind_comp_0.sg13g2_and2_2$1_0.VSS.n265 3.35859
R2412 wind_comp_0.sg13g2_and2_2$1_0.VSS.n2535 wind_comp_0.sg13g2_and2_2$1_0.VSS.t104 17.0005
R2413 wind_comp_0.sg13g2_and2_2$1_0.VSS.n2542 wind_comp_0.sg13g2_and2_2$1_0.VSS.t93 17.0005
R2414 wind_comp_0.sg13g2_and2_2$1_0.VSS.t93 wind_comp_0.sg13g2_and2_2$1_0.VSS.n2540 17.0005
R2415 wind_comp_0.sg13g2_and2_2$1_0.VSS.t104 wind_comp_0.sg13g2_and2_2$1_0.VSS.n2533 17.0005
R2416 wind_comp_0.sg13g2_and2_2$1_0.VSS.n1540 wind_comp_0.sg13g2_and2_2$1_0.VSS.t89 17.0005
R2417 wind_comp_0.sg13g2_and2_2$1_0.VSS.n1341 wind_comp_0.sg13g2_and2_2$1_0.VSS.t75 17.0005
R2418 wind_comp_0.sg13g2_and2_2$1_0.VSS.n1343 wind_comp_0.sg13g2_and2_2$1_0.VSS.t74 17.0005
R2419 wind_comp_0.sg13g2_and2_2$1_0.VSS.n1530 wind_comp_0.sg13g2_and2_2$1_0.VSS.t65 17.0005
R2420 wind_comp_0.sg13g2_and2_2$1_0.VSS.t65 wind_comp_0.sg13g2_and2_2$1_0.VSS.n1526 17.0005
R2421 wind_comp_0.sg13g2_and2_2$1_0.VSS.t89 wind_comp_0.sg13g2_and2_2$1_0.VSS.n1538 17.0005
R2422 wind_comp_0.sg13g2_and2_2$1_0.VSS.n1955 wind_comp_0.sg13g2_and2_2$1_0.VSS.t298 17.0005
R2423 wind_comp_0.sg13g2_and2_2$1_0.VSS.n1549 wind_comp_0.sg13g2_and2_2$1_0.VSS.t80 17.0005
R2424 wind_comp_0.sg13g2_and2_2$1_0.VSS.n1321 wind_comp_0.sg13g2_and2_2$1_0.VSS.t62 17.0005
R2425 wind_comp_0.sg13g2_and2_2$1_0.VSS.n1323 wind_comp_0.sg13g2_and2_2$1_0.VSS.t56 17.0005
R2426 wind_comp_0.sg13g2_and2_2$1_0.VSS.n2520 wind_comp_0.sg13g2_and2_2$1_0.VSS.t292 17.0005
R2427 wind_comp_0.sg13g2_and2_2$1_0.VSS.t117 wind_comp_0.sg13g2_and2_2$1_0.VSS.n1695 17.0005
R2428 wind_comp_0.sg13g2_and2_2$1_0.VSS.n1697 wind_comp_0.sg13g2_and2_2$1_0.VSS.t117 17.0005
R2429 wind_comp_0.sg13g2_and2_2$1_0.VSS.n1715 wind_comp_0.sg13g2_and2_2$1_0.VSS.t128 17.0005
R2430 wind_comp_0.sg13g2_and2_2$1_0.VSS.t128 wind_comp_0.sg13g2_and2_2$1_0.VSS.n1714 17.0005
R2431 wind_comp_0.sg13g2_and2_2$1_0.VSS.n1566 wind_comp_0.sg13g2_and2_2$1_0.VSS.t1 17.0005
R2432 wind_comp_0.sg13g2_and2_2$1_0.VSS.n2551 wind_comp_0.sg13g2_and2_2$1_0.VSS.t17 17.0005
R2433 wind_comp_0.sg13g2_and2_2$1_0.VSS.n2558 wind_comp_0.sg13g2_and2_2$1_0.VSS.t85 17.0005
R2434 wind_comp_0.sg13g2_and2_2$1_0.VSS.t85 wind_comp_0.sg13g2_and2_2$1_0.VSS.n2556 17.0005
R2435 wind_comp_0.sg13g2_and2_2$1_0.VSS.t17 wind_comp_0.sg13g2_and2_2$1_0.VSS.n2549 17.0005
R2436 wind_comp_0.sg13g2_and2_2$1_0.VSS.n1558 wind_comp_0.sg13g2_and2_2$1_0.VSS.t68 17.0005
R2437 wind_comp_0.sg13g2_and2_2$1_0.VSS.t68 wind_comp_0.sg13g2_and2_2$1_0.VSS.n1557 17.0005
R2438 wind_comp_0.sg13g2_and2_2$1_0.VSS.t80 wind_comp_0.sg13g2_and2_2$1_0.VSS.n1547 17.0005
R2439 wind_comp_0.sg13g2_and2_2$1_0.VSS.n1858 wind_comp_0.sg13g2_and2_2$1_0.VSS.t124 17.0005
R2440 wind_comp_0.sg13g2_and2_2$1_0.VSS.n1853 wind_comp_0.sg13g2_and2_2$1_0.VSS.t123 17.0005
R2441 wind_comp_0.sg13g2_and2_2$1_0.VSS.n1873 wind_comp_0.sg13g2_and2_2$1_0.VSS.t114 17.0005
R2442 wind_comp_0.sg13g2_and2_2$1_0.VSS.n1869 wind_comp_0.sg13g2_and2_2$1_0.VSS.t113 17.0005
R2443 wind_comp_0.sg13g2_and2_2$1_0.VSS.n1879 wind_comp_0.sg13g2_and2_2$1_0.VSS.t98 17.0005
R2444 wind_comp_0.sg13g2_and2_2$1_0.VSS.t98 wind_comp_0.sg13g2_and2_2$1_0.VSS.n1878 17.0005
R2445 wind_comp_0.sg13g2_and2_2$1_0.VSS.n1864 wind_comp_0.sg13g2_and2_2$1_0.VSS.t108 17.0005
R2446 wind_comp_0.sg13g2_and2_2$1_0.VSS.t108 wind_comp_0.sg13g2_and2_2$1_0.VSS.n1863 17.0005
R2447 wind_comp_0.sg13g2_and2_2$1_0.VSS.t232 wind_comp_0.sg13g2_and2_2$1_0.VSS.n2240 17.0005
R2448 wind_comp_0.sg13g2_and2_2$1_0.VSS.t232 wind_comp_0.sg13g2_and2_2$1_0.VSS.n2241 17.0005
R2449 wind_comp_0.sg13g2_and2_2$1_0.VSS.t232 wind_comp_0.sg13g2_and2_2$1_0.VSS.n2242 17.0005
R2450 wind_comp_0.sg13g2_and2_2$1_0.VSS.t229 wind_comp_0.sg13g2_and2_2$1_0.VSS.n2261 17.0005
R2451 wind_comp_0.sg13g2_and2_2$1_0.VSS.t229 wind_comp_0.sg13g2_and2_2$1_0.VSS.n2262 17.0005
R2452 wind_comp_0.sg13g2_and2_2$1_0.VSS.t229 wind_comp_0.sg13g2_and2_2$1_0.VSS.n2263 17.0005
R2453 wind_comp_0.sg13g2_and2_2$1_0.VSS.t199 wind_comp_0.sg13g2_and2_2$1_0.VSS.n2327 17.0005
R2454 wind_comp_0.sg13g2_and2_2$1_0.VSS.n2330 wind_comp_0.sg13g2_and2_2$1_0.VSS.t199 17.0005
R2455 wind_comp_0.sg13g2_and2_2$1_0.VSS.n2297 wind_comp_0.sg13g2_and2_2$1_0.VSS.t207 17.0005
R2456 wind_comp_0.sg13g2_and2_2$1_0.VSS.t207 wind_comp_0.sg13g2_and2_2$1_0.VSS.n2296 17.0005
R2457 wind_comp_0.sg13g2_and2_2$1_0.VSS.t218 wind_comp_0.sg13g2_and2_2$1_0.VSS.n2318 17.0005
R2458 wind_comp_0.sg13g2_and2_2$1_0.VSS.n2321 wind_comp_0.sg13g2_and2_2$1_0.VSS.t218 17.0005
R2459 wind_comp_0.sg13g2_and2_2$1_0.VSS.n2307 wind_comp_0.sg13g2_and2_2$1_0.VSS.t222 17.0005
R2460 wind_comp_0.sg13g2_and2_2$1_0.VSS.t222 wind_comp_0.sg13g2_and2_2$1_0.VSS.n2306 17.0005
R2461 wind_comp_0.sg13g2_and2_2$1_0.VSS.n1910 wind_comp_0.sg13g2_and2_2$1_0.VSS.t161 17.0005
R2462 wind_comp_0.sg13g2_and2_2$1_0.VSS.t161 wind_comp_0.sg13g2_and2_2$1_0.VSS.n1909 17.0005
R2463 wind_comp_0.sg13g2_and2_2$1_0.VSS.n1903 wind_comp_0.sg13g2_and2_2$1_0.VSS.t194 17.0005
R2464 wind_comp_0.sg13g2_and2_2$1_0.VSS.t194 wind_comp_0.sg13g2_and2_2$1_0.VSS.n1901 17.0005
R2465 wind_comp_0.sg13g2_and2_2$1_0.VSS.n1926 wind_comp_0.sg13g2_and2_2$1_0.VSS.t170 17.0005
R2466 wind_comp_0.sg13g2_and2_2$1_0.VSS.t170 wind_comp_0.sg13g2_and2_2$1_0.VSS.n1925 17.0005
R2467 wind_comp_0.sg13g2_and2_2$1_0.VSS.n1917 wind_comp_0.sg13g2_and2_2$1_0.VSS.t203 17.0005
R2468 wind_comp_0.sg13g2_and2_2$1_0.VSS.t203 wind_comp_0.sg13g2_and2_2$1_0.VSS.n1915 17.0005
R2469 wind_comp_0.sg13g2_and2_2$1_0.VSS.t182 wind_comp_0.sg13g2_and2_2$1_0.VSS.n1887 17.0005
R2470 wind_comp_0.sg13g2_and2_2$1_0.VSS.n1889 wind_comp_0.sg13g2_and2_2$1_0.VSS.t182 17.0005
R2471 wind_comp_0.sg13g2_and2_2$1_0.VSS.n1895 wind_comp_0.sg13g2_and2_2$1_0.VSS.t178 17.0005
R2472 wind_comp_0.sg13g2_and2_2$1_0.VSS.t178 wind_comp_0.sg13g2_and2_2$1_0.VSS.n1893 17.0005
R2473 wind_comp_0.sg13g2_and2_2$1_0.VSS.n2222 wind_comp_0.sg13g2_and2_2$1_0.VSS.t190 17.0005
R2474 wind_comp_0.sg13g2_and2_2$1_0.VSS.t190 wind_comp_0.sg13g2_and2_2$1_0.VSS.n2221 17.0005
R2475 wind_comp_0.sg13g2_and2_2$1_0.VSS.n2213 wind_comp_0.sg13g2_and2_2$1_0.VSS.t211 17.0005
R2476 wind_comp_0.sg13g2_and2_2$1_0.VSS.t211 wind_comp_0.sg13g2_and2_2$1_0.VSS.n2211 17.0005
R2477 wind_comp_0.sg13g2_and2_2$1_0.VSS.n2099 wind_comp_0.sg13g2_and2_2$1_0.VSS.t186 17.0005
R2478 wind_comp_0.sg13g2_and2_2$1_0.VSS.t186 wind_comp_0.sg13g2_and2_2$1_0.VSS.n2097 17.0005
R2479 wind_comp_0.sg13g2_and2_2$1_0.VSS.n2088 wind_comp_0.sg13g2_and2_2$1_0.VSS.t175 17.0005
R2480 wind_comp_0.sg13g2_and2_2$1_0.VSS.n2090 wind_comp_0.sg13g2_and2_2$1_0.VSS.t174 17.0005
R2481 wind_comp_0.sg13g2_and2_2$1_0.VSS.n681 wind_comp_0.sg13g2_and2_2$1_0.VSS.t166 17.0005
R2482 wind_comp_0.sg13g2_and2_2$1_0.VSS.n683 wind_comp_0.sg13g2_and2_2$1_0.VSS.t165 17.0005
R2483 wind_comp_0.sg13g2_and2_2$1_0.VSS.n734 wind_comp_0.sg13g2_and2_2$1_0.VSS.t156 17.0005
R2484 wind_comp_0.sg13g2_and2_2$1_0.VSS.n736 wind_comp_0.sg13g2_and2_2$1_0.VSS.t155 17.0005
R2485 wind_comp_0.sg13g2_and2_2$1_0.VSS.n1535 wind_comp_0.sg13g2_and2_2$1_0.VSS.t90 15.6272
R2486 wind_comp_0.sg13g2_and2_2$1_0.VSS.n1561 wind_comp_0.sg13g2_and2_2$1_0.VSS.t66 15.6272
R2487 wind_comp_0.sg13g2_and2_2$1_0.VSS.n1536 wind_comp_0.sg13g2_and2_2$1_0.VSS.t90 15.4225
R2488 wind_comp_0.sg13g2_and2_2$1_0.VSS.n1551 wind_comp_0.sg13g2_and2_2$1_0.VSS.t81 15.3765
R2489 wind_comp_0.sg13g2_and2_2$1_0.VSS.n1531 wind_comp_0.sg13g2_and2_2$1_0.VSS.t69 15.3138
R2490 wind_comp_0.sg13g2_and2_2$1_0.VSS.t81 wind_comp_0.sg13g2_and2_2$1_0.VSS.n1550 15.3138
R2491 wind_comp_0.sg13g2_and2_2$1_0.VSS.t69 wind_comp_0.sg13g2_and2_2$1_0.VSS.n1527 15.2115
R2492 wind_comp_0.sg13g2_and2_2$1_0.VSS.n1559 wind_comp_0.sg13g2_and2_2$1_0.VSS.t66 15.1885
R2493 wind_comp_0.sg13g2_and2_2$1_0.VSS.t94 wind_comp_0.sg13g2_and2_2$1_0.VSS.n2541 15.1728
R2494 wind_comp_0.sg13g2_and2_2$1_0.VSS.t105 wind_comp_0.sg13g2_and2_2$1_0.VSS.n2534 15.1728
R2495 wind_comp_0.sg13g2_and2_2$1_0.VSS.n2543 wind_comp_0.sg13g2_and2_2$1_0.VSS.t94 15.1728
R2496 wind_comp_0.sg13g2_and2_2$1_0.VSS.n2536 wind_comp_0.sg13g2_and2_2$1_0.VSS.t105 15.1728
R2497 wind_comp_0.sg13g2_and2_2$1_0.VSS.t76 wind_comp_0.sg13g2_and2_2$1_0.VSS.n1342 15.1728
R2498 wind_comp_0.sg13g2_and2_2$1_0.VSS.n1344 wind_comp_0.sg13g2_and2_2$1_0.VSS.t76 15.1728
R2499 wind_comp_0.sg13g2_and2_2$1_0.VSS.t54 wind_comp_0.sg13g2_and2_2$1_0.VSS.n1322 15.1728
R2500 wind_comp_0.sg13g2_and2_2$1_0.VSS.n1324 wind_comp_0.sg13g2_and2_2$1_0.VSS.t54 15.1728
R2501 wind_comp_0.sg13g2_and2_2$1_0.VSS.t115 wind_comp_0.sg13g2_and2_2$1_0.VSS.n1696 15.1728
R2502 wind_comp_0.sg13g2_and2_2$1_0.VSS.n1698 wind_comp_0.sg13g2_and2_2$1_0.VSS.t115 15.1728
R2503 wind_comp_0.sg13g2_and2_2$1_0.VSS.t127 wind_comp_0.sg13g2_and2_2$1_0.VSS.n1712 15.1728
R2504 wind_comp_0.sg13g2_and2_2$1_0.VSS.n1713 wind_comp_0.sg13g2_and2_2$1_0.VSS.t127 15.1728
R2505 wind_comp_0.sg13g2_and2_2$1_0.VSS.n2559 wind_comp_0.sg13g2_and2_2$1_0.VSS.t83 15.1728
R2506 wind_comp_0.sg13g2_and2_2$1_0.VSS.n2552 wind_comp_0.sg13g2_and2_2$1_0.VSS.t99 15.1728
R2507 wind_comp_0.sg13g2_and2_2$1_0.VSS.t83 wind_comp_0.sg13g2_and2_2$1_0.VSS.n2557 15.1728
R2508 wind_comp_0.sg13g2_and2_2$1_0.VSS.t99 wind_comp_0.sg13g2_and2_2$1_0.VSS.n2550 15.1728
R2509 wind_comp_0.sg13g2_and2_2$1_0.VSS.n1855 wind_comp_0.sg13g2_and2_2$1_0.VSS.t125 15.1728
R2510 wind_comp_0.sg13g2_and2_2$1_0.VSS.t125 wind_comp_0.sg13g2_and2_2$1_0.VSS.n1854 15.1728
R2511 wind_comp_0.sg13g2_and2_2$1_0.VSS.n1870 wind_comp_0.sg13g2_and2_2$1_0.VSS.t118 15.1728
R2512 wind_comp_0.sg13g2_and2_2$1_0.VSS.t118 wind_comp_0.sg13g2_and2_2$1_0.VSS.n1868 15.1728
R2513 wind_comp_0.sg13g2_and2_2$1_0.VSS.t101 wind_comp_0.sg13g2_and2_2$1_0.VSS.n1876 15.1728
R2514 wind_comp_0.sg13g2_and2_2$1_0.VSS.n1877 wind_comp_0.sg13g2_and2_2$1_0.VSS.t101 15.1728
R2515 wind_comp_0.sg13g2_and2_2$1_0.VSS.t107 wind_comp_0.sg13g2_and2_2$1_0.VSS.n1861 15.1728
R2516 wind_comp_0.sg13g2_and2_2$1_0.VSS.n1862 wind_comp_0.sg13g2_and2_2$1_0.VSS.t107 15.1728
R2517 wind_comp_0.sg13g2_and2_2$1_0.VSS.t197 wind_comp_0.sg13g2_and2_2$1_0.VSS.n2328 15.1728
R2518 wind_comp_0.sg13g2_and2_2$1_0.VSS.n2331 wind_comp_0.sg13g2_and2_2$1_0.VSS.t197 15.1728
R2519 wind_comp_0.sg13g2_and2_2$1_0.VSS.t206 wind_comp_0.sg13g2_and2_2$1_0.VSS.n2294 15.1728
R2520 wind_comp_0.sg13g2_and2_2$1_0.VSS.n2295 wind_comp_0.sg13g2_and2_2$1_0.VSS.t206 15.1728
R2521 wind_comp_0.sg13g2_and2_2$1_0.VSS.t217 wind_comp_0.sg13g2_and2_2$1_0.VSS.n2319 15.1728
R2522 wind_comp_0.sg13g2_and2_2$1_0.VSS.n2322 wind_comp_0.sg13g2_and2_2$1_0.VSS.t217 15.1728
R2523 wind_comp_0.sg13g2_and2_2$1_0.VSS.t225 wind_comp_0.sg13g2_and2_2$1_0.VSS.n2304 15.1728
R2524 wind_comp_0.sg13g2_and2_2$1_0.VSS.n2305 wind_comp_0.sg13g2_and2_2$1_0.VSS.t225 15.1728
R2525 wind_comp_0.sg13g2_and2_2$1_0.VSS.t195 wind_comp_0.sg13g2_and2_2$1_0.VSS.n1902 15.1728
R2526 wind_comp_0.sg13g2_and2_2$1_0.VSS.t159 wind_comp_0.sg13g2_and2_2$1_0.VSS.n1907 15.1728
R2527 wind_comp_0.sg13g2_and2_2$1_0.VSS.n1908 wind_comp_0.sg13g2_and2_2$1_0.VSS.t159 15.1728
R2528 wind_comp_0.sg13g2_and2_2$1_0.VSS.n1904 wind_comp_0.sg13g2_and2_2$1_0.VSS.t195 15.1728
R2529 wind_comp_0.sg13g2_and2_2$1_0.VSS.t204 wind_comp_0.sg13g2_and2_2$1_0.VSS.n1916 15.1728
R2530 wind_comp_0.sg13g2_and2_2$1_0.VSS.t169 wind_comp_0.sg13g2_and2_2$1_0.VSS.n1923 15.1728
R2531 wind_comp_0.sg13g2_and2_2$1_0.VSS.n1924 wind_comp_0.sg13g2_and2_2$1_0.VSS.t169 15.1728
R2532 wind_comp_0.sg13g2_and2_2$1_0.VSS.n1918 wind_comp_0.sg13g2_and2_2$1_0.VSS.t204 15.1728
R2533 wind_comp_0.sg13g2_and2_2$1_0.VSS.t215 wind_comp_0.sg13g2_and2_2$1_0.VSS.n1894 15.1728
R2534 wind_comp_0.sg13g2_and2_2$1_0.VSS.t181 wind_comp_0.sg13g2_and2_2$1_0.VSS.n1888 15.1728
R2535 wind_comp_0.sg13g2_and2_2$1_0.VSS.n1890 wind_comp_0.sg13g2_and2_2$1_0.VSS.t181 15.1728
R2536 wind_comp_0.sg13g2_and2_2$1_0.VSS.n1896 wind_comp_0.sg13g2_and2_2$1_0.VSS.t215 15.1728
R2537 wind_comp_0.sg13g2_and2_2$1_0.VSS.t223 wind_comp_0.sg13g2_and2_2$1_0.VSS.n2212 15.1728
R2538 wind_comp_0.sg13g2_and2_2$1_0.VSS.t189 wind_comp_0.sg13g2_and2_2$1_0.VSS.n2219 15.1728
R2539 wind_comp_0.sg13g2_and2_2$1_0.VSS.n2220 wind_comp_0.sg13g2_and2_2$1_0.VSS.t189 15.1728
R2540 wind_comp_0.sg13g2_and2_2$1_0.VSS.n2214 wind_comp_0.sg13g2_and2_2$1_0.VSS.t223 15.1728
R2541 wind_comp_0.sg13g2_and2_2$1_0.VSS.n2100 wind_comp_0.sg13g2_and2_2$1_0.VSS.t187 15.1728
R2542 wind_comp_0.sg13g2_and2_2$1_0.VSS.t187 wind_comp_0.sg13g2_and2_2$1_0.VSS.n2098 15.1728
R2543 wind_comp_0.sg13g2_and2_2$1_0.VSS.t179 wind_comp_0.sg13g2_and2_2$1_0.VSS.n2089 15.1728
R2544 wind_comp_0.sg13g2_and2_2$1_0.VSS.n2091 wind_comp_0.sg13g2_and2_2$1_0.VSS.t179 15.1728
R2545 wind_comp_0.sg13g2_and2_2$1_0.VSS.t167 wind_comp_0.sg13g2_and2_2$1_0.VSS.n682 15.1728
R2546 wind_comp_0.sg13g2_and2_2$1_0.VSS.n684 wind_comp_0.sg13g2_and2_2$1_0.VSS.t167 15.1728
R2547 wind_comp_0.sg13g2_and2_2$1_0.VSS.t157 wind_comp_0.sg13g2_and2_2$1_0.VSS.n735 15.1728
R2548 wind_comp_0.sg13g2_and2_2$1_0.VSS.n737 wind_comp_0.sg13g2_and2_2$1_0.VSS.t157 15.1728
R2549 wind_comp_0.sg13g2_and2_2$1_0.VSS.t29 wind_comp_0.sg13g2_and2_2$1_0.VSS.n895 15.1618
R2550 wind_comp_0.sg13g2_and2_2$1_0.VSS.n897 wind_comp_0.sg13g2_and2_2$1_0.VSS.t29 15.1618
R2551 wind_comp_0.sg13g2_and2_2$1_0.VSS.n1993 wind_comp_0.sg13g2_and2_2$1_0.VSS.t146 15.1618
R2552 wind_comp_0.sg13g2_and2_2$1_0.VSS.t146 wind_comp_0.sg13g2_and2_2$1_0.VSS.n1992 15.1618
R2553 wind_comp_0.sg13g2_and2_2$1_0.VSS.t49 wind_comp_0.sg13g2_and2_2$1_0.VSS.n1984 15.1618
R2554 wind_comp_0.sg13g2_and2_2$1_0.VSS.n1986 wind_comp_0.sg13g2_and2_2$1_0.VSS.t49 15.1618
R2555 wind_comp_0.sg13g2_and2_2$1_0.VSS.n2022 wind_comp_0.sg13g2_and2_2$1_0.VSS.t26 15.1618
R2556 wind_comp_0.sg13g2_and2_2$1_0.VSS.t26 wind_comp_0.sg13g2_and2_2$1_0.VSS.n2021 15.1618
R2557 wind_comp_0.sg13g2_and2_2$1_0.VSS.t18 wind_comp_0.sg13g2_and2_2$1_0.VSS.n784 15.1618
R2558 wind_comp_0.sg13g2_and2_2$1_0.VSS.n786 wind_comp_0.sg13g2_and2_2$1_0.VSS.t18 15.1618
R2559 wind_comp_0.sg13g2_and2_2$1_0.VSS.n2579 wind_comp_0.sg13g2_and2_2$1_0.VSS.t40 15.1618
R2560 wind_comp_0.sg13g2_and2_2$1_0.VSS.t40 wind_comp_0.sg13g2_and2_2$1_0.VSS.n2578 15.1618
R2561 wind_comp_0.sg13g2_and2_2$1_0.VSS.n2586 wind_comp_0.sg13g2_and2_2$1_0.VSS.t51 15.1618
R2562 wind_comp_0.sg13g2_and2_2$1_0.VSS.t51 wind_comp_0.sg13g2_and2_2$1_0.VSS.n2585 15.1618
R2563 wind_comp_0.sg13g2_and2_2$1_0.VSS.n778 wind_comp_0.sg13g2_and2_2$1_0.VSS.t20 15.1618
R2564 wind_comp_0.sg13g2_and2_2$1_0.VSS.t20 wind_comp_0.sg13g2_and2_2$1_0.VSS.n775 15.1618
R2565 wind_comp_0.sg13g2_and2_2$1_0.VSS.n974 wind_comp_0.sg13g2_and2_2$1_0.VSS.t35 15.1618
R2566 wind_comp_0.sg13g2_and2_2$1_0.VSS.t35 wind_comp_0.sg13g2_and2_2$1_0.VSS.n973 15.1618
R2567 wind_comp_0.sg13g2_and2_2$1_0.VSS.t137 wind_comp_0.sg13g2_and2_2$1_0.VSS.n1049 15.1618
R2568 wind_comp_0.sg13g2_and2_2$1_0.VSS.n1055 wind_comp_0.sg13g2_and2_2$1_0.VSS.t137 15.1618
R2569 wind_comp_0.sg13g2_and2_2$1_0.VSS.n991 wind_comp_0.sg13g2_and2_2$1_0.VSS.t230 15.1618
R2570 wind_comp_0.sg13g2_and2_2$1_0.VSS.t230 wind_comp_0.sg13g2_and2_2$1_0.VSS.n990 15.1618
R2571 wind_comp_0.sg13g2_and2_2$1_0.VSS.t239 wind_comp_0.sg13g2_and2_2$1_0.VSS.n1016 15.1618
R2572 wind_comp_0.sg13g2_and2_2$1_0.VSS.n1022 wind_comp_0.sg13g2_and2_2$1_0.VSS.t239 15.1618
R2573 wind_comp_0.sg13g2_and2_2$1_0.VSS.n2232 wind_comp_0.sg13g2_and2_2$1_0.VSS.t227 15.1618
R2574 wind_comp_0.sg13g2_and2_2$1_0.VSS.t227 wind_comp_0.sg13g2_and2_2$1_0.VSS.n2230 15.1618
R2575 wind_comp_0.sg13g2_and2_2$1_0.VSS.n886 wind_comp_0.sg13g2_and2_2$1_0.VSS.t134 15.1618
R2576 wind_comp_0.sg13g2_and2_2$1_0.VSS.t134 wind_comp_0.sg13g2_and2_2$1_0.VSS.n885 15.1618
R2577 wind_comp_0.sg13g2_and2_2$1_0.VSS.n2312 wind_comp_0.sg13g2_and2_2$1_0.VSS.t241 15.1618
R2578 wind_comp_0.sg13g2_and2_2$1_0.VSS.t241 wind_comp_0.sg13g2_and2_2$1_0.VSS.n2310 15.1618
R2579 wind_comp_0.sg13g2_and2_2$1_0.VSS.t148 wind_comp_0.sg13g2_and2_2$1_0.VSS.n2096 15.1618
R2580 wind_comp_0.sg13g2_and2_2$1_0.VSS.n2109 wind_comp_0.sg13g2_and2_2$1_0.VSS.t148 15.1618
R2581 wind_comp_0.sg13g2_and2_2$1_0.VSS.n2575 wind_comp_0.comparator_0.dynamic_pcell$2_0.SRC_NET_MNO 15.1358
R2582 wind_comp_0.comparator_1.dynamic_pcell$2_0.SRC_NET_MNO wind_comp_0.sg13g2_and2_2$1_0.VSS.n2283 15.1358
R2583 wind_comp_0.sg13g2_and2_2$1_0.VSS.n300 wind_comp_0.sg13g2_and2_2$1_0.VSS.n606 15.0949
R2584 wind_comp_0.sg13g2_and2_2$1_0.VSS.n95 wind_comp_0.sg13g2_and2_2$1_0.VSS.n193 1.75944
R2585 wind_comp_0.sg13g2_and2_2$1_0.VSS.n901 wind_comp_0.sg13g2_and2_2$1_0.VSS.t11 15.0005
R2586 wind_comp_0.sg13g2_and2_2$1_0.VSS.t11 wind_comp_0.sg13g2_and2_2$1_0.VSS.n900 15.0005
R2587 wind_comp_0.sg13g2_and2_2$1_0.VSS.n1994 wind_comp_0.sg13g2_and2_2$1_0.VSS.t143 15.0005
R2588 wind_comp_0.sg13g2_and2_2$1_0.VSS.t143 wind_comp_0.sg13g2_and2_2$1_0.VSS.n1990 15.0005
R2589 wind_comp_0.sg13g2_and2_2$1_0.VSS.n1989 wind_comp_0.sg13g2_and2_2$1_0.VSS.t46 15.0005
R2590 wind_comp_0.sg13g2_and2_2$1_0.VSS.t46 wind_comp_0.sg13g2_and2_2$1_0.VSS.n1988 15.0005
R2591 wind_comp_0.sg13g2_and2_2$1_0.VSS.n2023 wind_comp_0.sg13g2_and2_2$1_0.VSS.t37 15.0005
R2592 wind_comp_0.sg13g2_and2_2$1_0.VSS.t37 wind_comp_0.sg13g2_and2_2$1_0.VSS.n2019 15.0005
R2593 wind_comp_0.sg13g2_and2_2$1_0.VSS.n789 wind_comp_0.sg13g2_and2_2$1_0.VSS.t7 15.0005
R2594 wind_comp_0.sg13g2_and2_2$1_0.VSS.t7 wind_comp_0.sg13g2_and2_2$1_0.VSS.n788 15.0005
R2595 wind_comp_0.sg13g2_and2_2$1_0.VSS.n2580 wind_comp_0.sg13g2_and2_2$1_0.VSS.t43 15.0005
R2596 wind_comp_0.sg13g2_and2_2$1_0.VSS.t43 wind_comp_0.sg13g2_and2_2$1_0.VSS.n750 15.0005
R2597 wind_comp_0.sg13g2_and2_2$1_0.VSS.n2538 wind_comp_0.sg13g2_and2_2$1_0.VSS.t103 15.0005
R2598 wind_comp_0.sg13g2_and2_2$1_0.VSS.n2545 wind_comp_0.sg13g2_and2_2$1_0.VSS.t92 15.0005
R2599 wind_comp_0.sg13g2_and2_2$1_0.VSS.t103 wind_comp_0.sg13g2_and2_2$1_0.VSS.n2537 15.0005
R2600 wind_comp_0.sg13g2_and2_2$1_0.VSS.t92 wind_comp_0.sg13g2_and2_2$1_0.VSS.n2544 15.0005
R2601 wind_comp_0.sg13g2_and2_2$1_0.VSS.t88 wind_comp_0.sg13g2_and2_2$1_0.VSS.n1535 15.0005
R2602 wind_comp_0.sg13g2_and2_2$1_0.VSS.t63 wind_comp_0.sg13g2_and2_2$1_0.VSS.n1532 15.0005
R2603 wind_comp_0.sg13g2_and2_2$1_0.VSS.n1536 wind_comp_0.sg13g2_and2_2$1_0.VSS.t88 15.0005
R2604 wind_comp_0.sg13g2_and2_2$1_0.VSS.n1348 wind_comp_0.sg13g2_and2_2$1_0.VSS.t73 15.0005
R2605 wind_comp_0.sg13g2_and2_2$1_0.VSS.t73 wind_comp_0.sg13g2_and2_2$1_0.VSS.n1347 15.0005
R2606 wind_comp_0.sg13g2_and2_2$1_0.VSS.n2587 wind_comp_0.sg13g2_and2_2$1_0.VSS.t57 15.0005
R2607 wind_comp_0.sg13g2_and2_2$1_0.VSS.t57 wind_comp_0.sg13g2_and2_2$1_0.VSS.n749 15.0005
R2608 wind_comp_0.sg13g2_and2_2$1_0.VSS.n1533 wind_comp_0.sg13g2_and2_2$1_0.VSS.t63 15.0005
R2609 wind_comp_0.sg13g2_and2_2$1_0.VSS.t78 wind_comp_0.sg13g2_and2_2$1_0.VSS.n1551 15.0005
R2610 wind_comp_0.sg13g2_and2_2$1_0.VSS.t71 wind_comp_0.sg13g2_and2_2$1_0.VSS.n1560 15.0005
R2611 wind_comp_0.sg13g2_and2_2$1_0.VSS.n1552 wind_comp_0.sg13g2_and2_2$1_0.VSS.t78 15.0005
R2612 wind_comp_0.sg13g2_and2_2$1_0.VSS.n1561 wind_comp_0.sg13g2_and2_2$1_0.VSS.t71 15.0005
R2613 wind_comp_0.sg13g2_and2_2$1_0.VSS.n1329 wind_comp_0.sg13g2_and2_2$1_0.VSS.t60 15.0005
R2614 wind_comp_0.sg13g2_and2_2$1_0.VSS.t60 wind_comp_0.sg13g2_and2_2$1_0.VSS.n1328 15.0005
R2615 wind_comp_0.sg13g2_and2_2$1_0.VSS.n1700 wind_comp_0.sg13g2_and2_2$1_0.VSS.t120 15.0005
R2616 wind_comp_0.sg13g2_and2_2$1_0.VSS.t120 wind_comp_0.sg13g2_and2_2$1_0.VSS.n1699 15.0005
R2617 wind_comp_0.sg13g2_and2_2$1_0.VSS.n1711 wind_comp_0.sg13g2_and2_2$1_0.VSS.t129 15.0005
R2618 wind_comp_0.sg13g2_and2_2$1_0.VSS.t129 wind_comp_0.sg13g2_and2_2$1_0.VSS.n1708 15.0005
R2619 wind_comp_0.sg13g2_and2_2$1_0.VSS.t15 wind_comp_0.sg13g2_and2_2$1_0.VSS.n2553 15.0005
R2620 wind_comp_0.sg13g2_and2_2$1_0.VSS.t86 wind_comp_0.sg13g2_and2_2$1_0.VSS.n2560 15.0005
R2621 wind_comp_0.sg13g2_and2_2$1_0.VSS.n2554 wind_comp_0.sg13g2_and2_2$1_0.VSS.t15 15.0005
R2622 wind_comp_0.sg13g2_and2_2$1_0.VSS.n2561 wind_comp_0.sg13g2_and2_2$1_0.VSS.t86 15.0005
R2623 wind_comp_0.sg13g2_and2_2$1_0.VSS.n1856 wind_comp_0.sg13g2_and2_2$1_0.VSS.t122 15.0005
R2624 wind_comp_0.sg13g2_and2_2$1_0.VSS.t122 wind_comp_0.sg13g2_and2_2$1_0.VSS.n1852 15.0005
R2625 wind_comp_0.sg13g2_and2_2$1_0.VSS.t111 wind_comp_0.sg13g2_and2_2$1_0.VSS.n1871 15.0005
R2626 wind_comp_0.sg13g2_and2_2$1_0.VSS.n1872 wind_comp_0.sg13g2_and2_2$1_0.VSS.t111 15.0005
R2627 wind_comp_0.sg13g2_and2_2$1_0.VSS.n1875 wind_comp_0.sg13g2_and2_2$1_0.VSS.t96 15.0005
R2628 wind_comp_0.sg13g2_and2_2$1_0.VSS.t96 wind_comp_0.sg13g2_and2_2$1_0.VSS.n1867 15.0005
R2629 wind_comp_0.sg13g2_and2_2$1_0.VSS.n1860 wind_comp_0.sg13g2_and2_2$1_0.VSS.t109 15.0005
R2630 wind_comp_0.sg13g2_and2_2$1_0.VSS.t109 wind_comp_0.sg13g2_and2_2$1_0.VSS.n1851 15.0005
R2631 wind_comp_0.sg13g2_and2_2$1_0.VSS.t23 wind_comp_0.sg13g2_and2_2$1_0.VSS.n779 15.0005
R2632 wind_comp_0.sg13g2_and2_2$1_0.VSS.n780 wind_comp_0.sg13g2_and2_2$1_0.VSS.t23 15.0005
R2633 wind_comp_0.sg13g2_and2_2$1_0.VSS.n975 wind_comp_0.sg13g2_and2_2$1_0.VSS.t31 15.0005
R2634 wind_comp_0.sg13g2_and2_2$1_0.VSS.t31 wind_comp_0.sg13g2_and2_2$1_0.VSS.n971 15.0005
R2635 wind_comp_0.sg13g2_and2_2$1_0.VSS.n1057 wind_comp_0.sg13g2_and2_2$1_0.VSS.t140 15.0005
R2636 wind_comp_0.sg13g2_and2_2$1_0.VSS.t140 wind_comp_0.sg13g2_and2_2$1_0.VSS.n1056 15.0005
R2637 wind_comp_0.sg13g2_and2_2$1_0.VSS.n992 wind_comp_0.sg13g2_and2_2$1_0.VSS.t233 15.0005
R2638 wind_comp_0.sg13g2_and2_2$1_0.VSS.t233 wind_comp_0.sg13g2_and2_2$1_0.VSS.n988 15.0005
R2639 wind_comp_0.sg13g2_and2_2$1_0.VSS.n1024 wind_comp_0.sg13g2_and2_2$1_0.VSS.t243 15.0005
R2640 wind_comp_0.sg13g2_and2_2$1_0.VSS.t243 wind_comp_0.sg13g2_and2_2$1_0.VSS.n1023 15.0005
R2641 wind_comp_0.sg13g2_and2_2$1_0.VSS.t212 wind_comp_0.sg13g2_and2_2$1_0.VSS.n2235 15.0005
R2642 wind_comp_0.sg13g2_and2_2$1_0.VSS.n2236 wind_comp_0.sg13g2_and2_2$1_0.VSS.t212 15.0005
R2643 wind_comp_0.sg13g2_and2_2$1_0.VSS.n887 wind_comp_0.sg13g2_and2_2$1_0.VSS.t131 15.0005
R2644 wind_comp_0.sg13g2_and2_2$1_0.VSS.t131 wind_comp_0.sg13g2_and2_2$1_0.VSS.n883 15.0005
R2645 wind_comp_0.sg13g2_and2_2$1_0.VSS.t236 wind_comp_0.sg13g2_and2_2$1_0.VSS.n2315 15.0005
R2646 wind_comp_0.sg13g2_and2_2$1_0.VSS.n2316 wind_comp_0.sg13g2_and2_2$1_0.VSS.t236 15.0005
R2647 wind_comp_0.sg13g2_and2_2$1_0.VSS.n2333 wind_comp_0.sg13g2_and2_2$1_0.VSS.t200 15.0005
R2648 wind_comp_0.sg13g2_and2_2$1_0.VSS.t200 wind_comp_0.sg13g2_and2_2$1_0.VSS.n2332 15.0005
R2649 wind_comp_0.sg13g2_and2_2$1_0.VSS.n2293 wind_comp_0.sg13g2_and2_2$1_0.VSS.t208 15.0005
R2650 wind_comp_0.sg13g2_and2_2$1_0.VSS.t208 wind_comp_0.sg13g2_and2_2$1_0.VSS.n2228 15.0005
R2651 wind_comp_0.sg13g2_and2_2$1_0.VSS.n2324 wind_comp_0.sg13g2_and2_2$1_0.VSS.t219 15.0005
R2652 wind_comp_0.sg13g2_and2_2$1_0.VSS.t219 wind_comp_0.sg13g2_and2_2$1_0.VSS.n2323 15.0005
R2653 wind_comp_0.sg13g2_and2_2$1_0.VSS.n2303 wind_comp_0.sg13g2_and2_2$1_0.VSS.t221 15.0005
R2654 wind_comp_0.sg13g2_and2_2$1_0.VSS.t221 wind_comp_0.sg13g2_and2_2$1_0.VSS.n2301 15.0005
R2655 wind_comp_0.sg13g2_and2_2$1_0.VSS.n1913 wind_comp_0.sg13g2_and2_2$1_0.VSS.t193 15.0005
R2656 wind_comp_0.sg13g2_and2_2$1_0.VSS.n1906 wind_comp_0.sg13g2_and2_2$1_0.VSS.t162 15.0005
R2657 wind_comp_0.sg13g2_and2_2$1_0.VSS.t162 wind_comp_0.sg13g2_and2_2$1_0.VSS.n1905 15.0005
R2658 wind_comp_0.sg13g2_and2_2$1_0.VSS.t193 wind_comp_0.sg13g2_and2_2$1_0.VSS.n1912 15.0005
R2659 wind_comp_0.sg13g2_and2_2$1_0.VSS.n1920 wind_comp_0.sg13g2_and2_2$1_0.VSS.t202 15.0005
R2660 wind_comp_0.sg13g2_and2_2$1_0.VSS.n1922 wind_comp_0.sg13g2_and2_2$1_0.VSS.t171 15.0005
R2661 wind_comp_0.sg13g2_and2_2$1_0.VSS.t171 wind_comp_0.sg13g2_and2_2$1_0.VSS.n1914 15.0005
R2662 wind_comp_0.sg13g2_and2_2$1_0.VSS.t202 wind_comp_0.sg13g2_and2_2$1_0.VSS.n1919 15.0005
R2663 wind_comp_0.sg13g2_and2_2$1_0.VSS.n1898 wind_comp_0.sg13g2_and2_2$1_0.VSS.t176 15.0005
R2664 wind_comp_0.sg13g2_and2_2$1_0.VSS.n1892 wind_comp_0.sg13g2_and2_2$1_0.VSS.t183 15.0005
R2665 wind_comp_0.sg13g2_and2_2$1_0.VSS.t183 wind_comp_0.sg13g2_and2_2$1_0.VSS.n1891 15.0005
R2666 wind_comp_0.sg13g2_and2_2$1_0.VSS.t176 wind_comp_0.sg13g2_and2_2$1_0.VSS.n1897 15.0005
R2667 wind_comp_0.sg13g2_and2_2$1_0.VSS.n2216 wind_comp_0.sg13g2_and2_2$1_0.VSS.t210 15.0005
R2668 wind_comp_0.sg13g2_and2_2$1_0.VSS.n2218 wind_comp_0.sg13g2_and2_2$1_0.VSS.t191 15.0005
R2669 wind_comp_0.sg13g2_and2_2$1_0.VSS.t191 wind_comp_0.sg13g2_and2_2$1_0.VSS.n2210 15.0005
R2670 wind_comp_0.sg13g2_and2_2$1_0.VSS.t210 wind_comp_0.sg13g2_and2_2$1_0.VSS.n2215 15.0005
R2671 wind_comp_0.sg13g2_and2_2$1_0.VSS.t185 wind_comp_0.sg13g2_and2_2$1_0.VSS.n2102 15.0005
R2672 wind_comp_0.sg13g2_and2_2$1_0.VSS.n2103 wind_comp_0.sg13g2_and2_2$1_0.VSS.t185 15.0005
R2673 wind_comp_0.sg13g2_and2_2$1_0.VSS.n2120 wind_comp_0.sg13g2_and2_2$1_0.VSS.t173 15.0005
R2674 wind_comp_0.sg13g2_and2_2$1_0.VSS.t173 wind_comp_0.sg13g2_and2_2$1_0.VSS.n2119 15.0005
R2675 wind_comp_0.sg13g2_and2_2$1_0.VSS.n687 wind_comp_0.sg13g2_and2_2$1_0.VSS.t164 15.0005
R2676 wind_comp_0.sg13g2_and2_2$1_0.VSS.t164 wind_comp_0.sg13g2_and2_2$1_0.VSS.n686 15.0005
R2677 wind_comp_0.sg13g2_and2_2$1_0.VSS.n742 wind_comp_0.sg13g2_and2_2$1_0.VSS.t153 15.0005
R2678 wind_comp_0.sg13g2_and2_2$1_0.VSS.t153 wind_comp_0.sg13g2_and2_2$1_0.VSS.n741 15.0005
R2679 wind_comp_0.sg13g2_and2_2$1_0.VSS.n2111 wind_comp_0.sg13g2_and2_2$1_0.VSS.t150 15.0005
R2680 wind_comp_0.sg13g2_and2_2$1_0.VSS.t150 wind_comp_0.sg13g2_and2_2$1_0.VSS.n2110 15.0005
R2681 wind_comp_0.sg13g2_and2_2$1_0.VSS.n128 wind_comp_0.sg13g2_and2_2$1_0.VSS.n126 5.15453
R2682 wind_comp_0.sg13g2_and2_2$1_0.VSS.n2126 wind_comp_0.sg13g2_and2_2$1_0.VSS.n680 13.349
R2683 wind_comp_0.sg13g2_and2_2$1_0.VSS.n2290 wind_comp_0.sg13g2_and2_2$1_0.VSS.n2289 13.349
R2684 wind_comp_0.sg13g2_and2_2$1_0.VSS.n131 wind_comp_0.sg13g2_and2_2$1_0.VSS.n74 0.991574
R2685 wind_comp_0.comparator_0.dynamic_pcell$2_0.SRC_NET_MNO wind_comp_0.sg13g2_and2_2$1_0.VSS.n2615 11.1908
R2686 wind_comp_0.comparator_1.dynamic_pcell$2_0.SRC_NET_MNO wind_comp_0.sg13g2_and2_2$1_0.VSS.n2256 11.1908
R2687 wind_comp_0.sg13g2_and2_2$1_0.VSS.n124 wind_comp_0.sg13g2_and2_2$1_0.VSS.n1563 9.85156
R2688 wind_comp_0.sg13g2_and2_2$1_0.VSS.n2594 wind_comp_0.sg13g2_and2_2$1_0.VSS.n680 9.8299
R2689 wind_comp_0.sg13g2_and2_2$1_0.VSS.n2291 wind_comp_0.sg13g2_and2_2$1_0.VSS.n2290 9.8299
R2690 wind_comp_0.sg13g2_and2_2$1_0.VSS.n2563 wind_comp_0.sg13g2_and2_2$1_0.VSS.n74 2.43613
R2691 wind_comp_0.sg13g2_and2_2$1_0.VSS.n2616 wind_comp_0.sg13g2_and2_2$1_0.VSS.n2595 9.70359
R2692 wind_comp_0.comparator_0.dynamic_pcell$2_0.SRC_NET_MNO wind_comp_0.sg13g2_and2_2$1_0.VSS.n2125 9.70359
R2693 wind_comp_0.sg13g2_and2_2$1_0.VSS.n701 wind_comp_0.comparator_0.dynamic_pcell$1_0.SRC_NET_PQRS 9.70359
R2694 wind_comp_0.comparator_1.dynamic_pcell$1_0.SRC_NET_PQRS wind_comp_0.sg13g2_and2_2$1_0.VSS.n1955 9.70359
R2695 wind_comp_0.comparator_0.dynamic_pcell$2_0.SRC_NET_MNO wind_comp_0.sg13g2_and2_2$1_0.VSS.n2574 9.70359
R2696 wind_comp_0.comparator_1.dynamic_pcell$2_0.SRC_NET_MNO wind_comp_0.sg13g2_and2_2$1_0.VSS.n2288 9.70359
R2697 wind_comp_0.sg13g2_and2_2$1_0.VSS.n2257 wind_comp_0.sg13g2_and2_2$1_0.VSS.n2277 9.70359
R2698 wind_comp_0.comparator_1.dynamic_pcell$2_0.SRC_NET_MNO wind_comp_0.sg13g2_and2_2$1_0.VSS.n2282 9.70359
R2699 wind_comp_0.sg13g2_and2_2$1_0.VSS.n2522 wind_comp_0.sg13g2_and2_2$1_0.VSS.n2520 9.67719
R2700 wind_comp_0.sg13g2_and2_2$1_0.VSS.n1568 wind_comp_0.sg13g2_and2_2$1_0.VSS.n1566 9.67719
R2701 wind_comp_0.sg13g2_and2_2$1_0.VSS.n2617 wind_comp_0.sg13g2_and2_2$1_0.VSS.n2616 9.03894
R2702 wind_comp_0.sg13g2_and2_2$1_0.VSS.n2621 wind_comp_0.sg13g2_and2_2$1_0.VSS.n2620 9.03894
R2703 wind_comp_0.sg13g2_and2_2$1_0.VSS.n2615 wind_comp_0.sg13g2_and2_2$1_0.VSS.n2614 9.03894
R2704 wind_comp_0.sg13g2_and2_2$1_0.VSS.n2613 wind_comp_0.sg13g2_and2_2$1_0.VSS.n2612 9.03894
R2705 wind_comp_0.sg13g2_and2_2$1_0.VSS.n2125 wind_comp_0.sg13g2_and2_2$1_0.VSS.n2124 9.03894
R2706 wind_comp_0.sg13g2_and2_2$1_0.VSS.n2574 wind_comp_0.sg13g2_and2_2$1_0.VSS.n2573 9.03894
R2707 wind_comp_0.sg13g2_and2_2$1_0.VSS.n2288 wind_comp_0.sg13g2_and2_2$1_0.VSS.n2287 9.03894
R2708 wind_comp_0.sg13g2_and2_2$1_0.VSS.n2256 wind_comp_0.sg13g2_and2_2$1_0.VSS.n2255 9.03894
R2709 wind_comp_0.sg13g2_and2_2$1_0.VSS.n2254 wind_comp_0.sg13g2_and2_2$1_0.VSS.n2253 9.03894
R2710 wind_comp_0.sg13g2_and2_2$1_0.VSS.n2277 wind_comp_0.sg13g2_and2_2$1_0.VSS.n2276 9.03894
R2711 wind_comp_0.sg13g2_and2_2$1_0.VSS.n2275 wind_comp_0.sg13g2_and2_2$1_0.VSS.n2274 9.03894
R2712 wind_comp_0.sg13g2_and2_2$1_0.VSS.n2282 wind_comp_0.sg13g2_and2_2$1_0.VSS.n2281 9.03894
R2713 wind_comp_0.sg13g2_and2_2$1_0.VSS.n679 wind_comp_0.sg13g2_and2_2$1_0.VSS.n677 9.0005
R2714 wind_comp_0.sg13g2_and2_2$1_0.VSS.n2623 wind_comp_0.sg13g2_and2_2$1_0.VSS.n2622 9.0005
R2715 wind_comp_0.sg13g2_and2_2$1_0.VSS.n2625 wind_comp_0.sg13g2_and2_2$1_0.VSS.n2624 9.0005
R2716 wind_comp_0.sg13g2_and2_2$1_0.VSS.n2627 wind_comp_0.sg13g2_and2_2$1_0.VSS.n2626 9.0005
R2717 wind_comp_0.sg13g2_and2_2$1_0.VSS.n2628 wind_comp_0.sg13g2_and2_2$1_0.VSS.n676 9.0005
R2718 wind_comp_0.comparator_0.dynamic_pcell$2_0.SRC_NET_MNO wind_comp_0.sg13g2_and2_2$1_0.VSS.n2631 9.0005
R2719 wind_comp_0.sg13g2_and2_2$1_0.VSS.n2597 wind_comp_0.sg13g2_and2_2$1_0.VSS.n2596 9.0005
R2720 wind_comp_0.sg13g2_and2_2$1_0.VSS.n2611 wind_comp_0.sg13g2_and2_2$1_0.VSS.n2603 9.0005
R2721 wind_comp_0.sg13g2_and2_2$1_0.VSS.n2610 wind_comp_0.sg13g2_and2_2$1_0.VSS.n2609 9.0005
R2722 wind_comp_0.sg13g2_and2_2$1_0.VSS.n2608 wind_comp_0.sg13g2_and2_2$1_0.VSS.n2607 9.0005
R2723 wind_comp_0.sg13g2_and2_2$1_0.VSS.n2606 wind_comp_0.sg13g2_and2_2$1_0.VSS.n2605 9.0005
R2724 wind_comp_0.comparator_0.dynamic_pcell$2_0.SRC_NET_MNO wind_comp_0.sg13g2_and2_2$1_0.VSS.n2604 9.0005
R2725 wind_comp_0.sg13g2_and2_2$1_0.VSS.n2122 wind_comp_0.sg13g2_and2_2$1_0.VSS.n2121 9.0005
R2726 wind_comp_0.comparator_0.dynamic_pcell$1_0.SRC_NET_PQRS wind_comp_0.comparator_0.dynamic_pcell$1_0.VSS 9.0005
R2727 wind_comp_0.comparator_0.dynamic_pcell$1_0.SRC_NET_PQRS wind_comp_0.comparator_0.dynamic_pcell$1_0.VSS 9.0005
R2728 wind_comp_0.comparator_0.dynamic_pcell$1_0.SRC_NET_PQRS wind_comp_0.comparator_0.dynamic_pcell$1_0.VSS 9.0005
R2729 wind_comp_0.comparator_0.dynamic_pcell_0.VSS wind_comp_0.sg13g2_and2_2$1_0.VSS.n1568 9.0005
R2730 wind_comp_0.comparator_1.dynamic_pcell$1_0.SRC_NET_PQRS wind_comp_0.comparator_1.dynamic_pcell$1_0.VSS 9.0005
R2731 wind_comp_0.comparator_1.dynamic_pcell$1_0.SRC_NET_PQRS wind_comp_0.comparator_1.dynamic_pcell$1_0.VSS 9.0005
R2732 wind_comp_0.comparator_1.dynamic_pcell$1_0.VSS wind_comp_0.comparator_1.dynamic_pcell$1_0.SRC_NET_PQRS 9.0005
R2733 wind_comp_0.comparator_1.dynamic_pcell_0.VSS wind_comp_0.sg13g2_and2_2$1_0.VSS.n2522 9.0005
R2734 wind_comp_0.sg13g2_and2_2$1_0.VSS.n2571 wind_comp_0.sg13g2_and2_2$1_0.VSS.n2570 9.0005
R2735 wind_comp_0.sg13g2_and2_2$1_0.VSS.n2285 wind_comp_0.sg13g2_and2_2$1_0.VSS.n2284 9.0005
R2736 wind_comp_0.sg13g2_and2_2$1_0.VSS.n2238 wind_comp_0.sg13g2_and2_2$1_0.VSS.n2237 9.0005
R2737 wind_comp_0.sg13g2_and2_2$1_0.VSS.n2252 wind_comp_0.sg13g2_and2_2$1_0.VSS.n2244 9.0005
R2738 wind_comp_0.sg13g2_and2_2$1_0.VSS.n2251 wind_comp_0.sg13g2_and2_2$1_0.VSS.n2250 9.0005
R2739 wind_comp_0.sg13g2_and2_2$1_0.VSS.n2249 wind_comp_0.sg13g2_and2_2$1_0.VSS.n2248 9.0005
R2740 wind_comp_0.sg13g2_and2_2$1_0.VSS.n2247 wind_comp_0.sg13g2_and2_2$1_0.VSS.n2246 9.0005
R2741 wind_comp_0.comparator_1.dynamic_pcell$2_0.SRC_NET_MNO wind_comp_0.sg13g2_and2_2$1_0.VSS.n2245 9.0005
R2742 wind_comp_0.sg13g2_and2_2$1_0.VSS.n2259 wind_comp_0.sg13g2_and2_2$1_0.VSS.n2258 9.0005
R2743 wind_comp_0.sg13g2_and2_2$1_0.VSS.n2273 wind_comp_0.sg13g2_and2_2$1_0.VSS.n2265 9.0005
R2744 wind_comp_0.sg13g2_and2_2$1_0.VSS.n2272 wind_comp_0.sg13g2_and2_2$1_0.VSS.n2271 9.0005
R2745 wind_comp_0.sg13g2_and2_2$1_0.VSS.n2270 wind_comp_0.sg13g2_and2_2$1_0.VSS.n2269 9.0005
R2746 wind_comp_0.sg13g2_and2_2$1_0.VSS.n2268 wind_comp_0.sg13g2_and2_2$1_0.VSS.n2267 9.0005
R2747 wind_comp_0.comparator_1.dynamic_pcell$2_0.SRC_NET_MNO wind_comp_0.sg13g2_and2_2$1_0.VSS.n2266 9.0005
R2748 wind_comp_0.sg13g2_and2_2$1_0.VSS.n2279 wind_comp_0.sg13g2_and2_2$1_0.VSS.n2278 9.0005
R2749 wind_comp_0.sg13g2_and2_2$1_0.VSS.n124 wind_comp_0.sg13g2_and2_2$1_0.VSS.n1544 8.86693
R2750 wind_comp_0.sg13g2_and2_2$1_0.VSS.n1563 wind_comp_0.sg13g2_and2_2$1_0.VSS.n70 8.84379
R2751 wind_comp_0.sg13g2_and2_2$1_0.VSS.n1577 wind_comp_0.sg13g2_and2_2$1_0.VSS.t329 8.80285
R2752 wind_comp_0.sg13g2_and2_2$1_0.VSS.n1456 wind_comp_0.sg13g2_and2_2$1_0.VSS.t250 8.75631
R2753 wind_comp_0.sg13g2_and2_2$1_0.VSS.n1449 wind_comp_0.sg13g2_and2_2$1_0.VSS.t255 8.75631
R2754 wind_comp_0.sg13g2_and2_2$1_0.VSS.n1464 wind_comp_0.sg13g2_and2_2$1_0.VSS.t258 8.75631
R2755 wind_comp_0.sg13g2_and2_2$1_0.VSS.n1467 wind_comp_0.sg13g2_and2_2$1_0.VSS.t261 8.75631
R2756 wind_comp_0.sg13g2_and2_2$1_0.VSS.n1471 wind_comp_0.sg13g2_and2_2$1_0.VSS.t264 8.75631
R2757 wind_comp_0.sg13g2_and2_2$1_0.VSS.n1475 wind_comp_0.sg13g2_and2_2$1_0.VSS.t267 8.75631
R2758 wind_comp_0.sg13g2_and2_2$1_0.VSS.n1478 wind_comp_0.sg13g2_and2_2$1_0.VSS.t270 8.75631
R2759 wind_comp_0.sg13g2_and2_2$1_0.VSS.n1481 wind_comp_0.sg13g2_and2_2$1_0.VSS.t273 8.75631
R2760 wind_comp_0.sg13g2_and2_2$1_0.VSS.n1479 wind_comp_0.sg13g2_and2_2$1_0.VSS.t335 8.75631
R2761 wind_comp_0.sg13g2_and2_2$1_0.VSS.n1494 wind_comp_0.sg13g2_and2_2$1_0.VSS.t340 8.75631
R2762 wind_comp_0.sg13g2_and2_2$1_0.VSS.n1495 wind_comp_0.sg13g2_and2_2$1_0.VSS.t343 8.75631
R2763 wind_comp_0.sg13g2_and2_2$1_0.VSS.n1428 wind_comp_0.sg13g2_and2_2$1_0.VSS.t346 8.75631
R2764 wind_comp_0.sg13g2_and2_2$1_0.VSS.n1424 wind_comp_0.sg13g2_and2_2$1_0.VSS.t349 8.75631
R2765 wind_comp_0.sg13g2_and2_2$1_0.VSS.n1420 wind_comp_0.sg13g2_and2_2$1_0.VSS.t352 8.75631
R2766 wind_comp_0.sg13g2_and2_2$1_0.VSS.n1415 wind_comp_0.sg13g2_and2_2$1_0.VSS.t355 8.75631
R2767 wind_comp_0.sg13g2_and2_2$1_0.VSS.n1410 wind_comp_0.sg13g2_and2_2$1_0.VSS.t358 8.75631
R2768 wind_comp_0.sg13g2_and2_2$1_0.VSS.n1513 wind_comp_0.sg13g2_and2_2$1_0.VSS.t404 8.75631
R2769 wind_comp_0.sg13g2_and2_2$1_0.VSS.n1643 wind_comp_0.sg13g2_and2_2$1_0.VSS.t406 8.75631
R2770 wind_comp_0.sg13g2_and2_2$1_0.VSS.n1645 wind_comp_0.sg13g2_and2_2$1_0.VSS.t368 8.75631
R2771 wind_comp_0.sg13g2_and2_2$1_0.VSS.n1646 wind_comp_0.sg13g2_and2_2$1_0.VSS.t370 8.75631
R2772 wind_comp_0.sg13g2_and2_2$1_0.VSS.n1640 wind_comp_0.sg13g2_and2_2$1_0.VSS.t373 8.75631
R2773 wind_comp_0.sg13g2_and2_2$1_0.VSS.n1637 wind_comp_0.sg13g2_and2_2$1_0.VSS.t376 8.75631
R2774 wind_comp_0.sg13g2_and2_2$1_0.VSS.n1661 wind_comp_0.sg13g2_and2_2$1_0.VSS.t379 8.75631
R2775 wind_comp_0.sg13g2_and2_2$1_0.VSS.n1664 wind_comp_0.sg13g2_and2_2$1_0.VSS.t382 8.75631
R2776 wind_comp_0.sg13g2_and2_2$1_0.VSS.n1668 wind_comp_0.sg13g2_and2_2$1_0.VSS.t385 8.75631
R2777 wind_comp_0.sg13g2_and2_2$1_0.VSS.n1673 wind_comp_0.sg13g2_and2_2$1_0.VSS.t391 8.75631
R2778 wind_comp_0.sg13g2_and2_2$1_0.VSS.n1679 wind_comp_0.sg13g2_and2_2$1_0.VSS.t304 8.75631
R2779 wind_comp_0.sg13g2_and2_2$1_0.VSS.n1682 wind_comp_0.sg13g2_and2_2$1_0.VSS.t305 8.75631
R2780 wind_comp_0.sg13g2_and2_2$1_0.VSS.n1684 wind_comp_0.sg13g2_and2_2$1_0.VSS.t307 8.75631
R2781 wind_comp_0.sg13g2_and2_2$1_0.VSS.n1687 wind_comp_0.sg13g2_and2_2$1_0.VSS.t310 8.75631
R2782 wind_comp_0.sg13g2_and2_2$1_0.VSS.n1688 wind_comp_0.sg13g2_and2_2$1_0.VSS.t313 8.75631
R2783 wind_comp_0.sg13g2_and2_2$1_0.VSS.n1623 wind_comp_0.sg13g2_and2_2$1_0.VSS.t316 8.75631
R2784 wind_comp_0.sg13g2_and2_2$1_0.VSS.n1620 wind_comp_0.sg13g2_and2_2$1_0.VSS.t319 8.75631
R2785 wind_comp_0.sg13g2_and2_2$1_0.VSS.n1693 wind_comp_0.sg13g2_and2_2$1_0.VSS.t325 8.75631
R2786 wind_comp_0.sg13g2_and2_2$1_0.VSS.n1544 wind_comp_0.sg13g2_and2_2$1_0.VSS.n74 8.74794
R2787 wind_comp_0.sg13g2_and2_2$1_0.VSS.t52 wind_comp_0.sg13g2_and2_2$1_0.VSS.n2620 8.50315
R2788 wind_comp_0.sg13g2_and2_2$1_0.VSS.t52 wind_comp_0.sg13g2_and2_2$1_0.VSS.n2617 8.50315
R2789 wind_comp_0.sg13g2_and2_2$1_0.VSS.n2614 wind_comp_0.sg13g2_and2_2$1_0.VSS.t50 8.50315
R2790 wind_comp_0.sg13g2_and2_2$1_0.VSS.t50 wind_comp_0.sg13g2_and2_2$1_0.VSS.n2613 8.50315
R2791 wind_comp_0.sg13g2_and2_2$1_0.VSS.n2124 wind_comp_0.sg13g2_and2_2$1_0.VSS.t289 8.50315
R2792 wind_comp_0.sg13g2_and2_2$1_0.VSS.n2573 wind_comp_0.sg13g2_and2_2$1_0.VSS.t284 8.50315
R2793 wind_comp_0.sg13g2_and2_2$1_0.VSS.n2287 wind_comp_0.sg13g2_and2_2$1_0.VSS.t365 8.50315
R2794 wind_comp_0.sg13g2_and2_2$1_0.VSS.t232 wind_comp_0.sg13g2_and2_2$1_0.VSS.n2254 8.50315
R2795 wind_comp_0.sg13g2_and2_2$1_0.VSS.n2255 wind_comp_0.sg13g2_and2_2$1_0.VSS.t232 8.50315
R2796 wind_comp_0.sg13g2_and2_2$1_0.VSS.n2276 wind_comp_0.sg13g2_and2_2$1_0.VSS.t229 8.50315
R2797 wind_comp_0.sg13g2_and2_2$1_0.VSS.t229 wind_comp_0.sg13g2_and2_2$1_0.VSS.n2275 8.50315
R2798 wind_comp_0.sg13g2_and2_2$1_0.VSS.n2281 wind_comp_0.sg13g2_and2_2$1_0.VSS.t360 8.50315
R2799 wind_comp_0.sg13g2_and2_2$1_0.VSS.n2517 wind_comp_0.sg13g2_and2_2$1_0.VSS.n201 0.459523
R2800 wind_comp_0.sg13g2_and2_2$1_0.VSS.n1816 wind_comp_0.sg13g2_and2_2$1_0.VSS.n83 2.12673
R2801 wind_comp_0.sg13g2_and2_2$1_0.VSS.n1649 wind_comp_0.sg13g2_and2_2$1_0.VSS.n83 2.12792
R2802 wind_comp_0.sg13g2_and2_2$1_0.VSS.n1520 wind_comp_0.sg13g2_and2_2$1_0.VSS.n70 8.501
R2803 wind_comp_0.sg13g2_and2_2$1_0.VSS.n1564 wind_comp_0.sg13g2_and2_2$1_0.VSS.n124 0.895696
R2804 wind_comp_0.sg13g2_and2_2$1_0.VSS.n98 wind_comp_0.sg13g2_and2_2$1_0.VSS.n68 1.02587
R2805 wind_comp_0.sg13g2_and2_2$1_0.VSS.n654 wind_comp_0.sg13g2_and2_2$1_0.VSS.n653 0.0158317
R2806 wind_comp_0.sg13g2_and2_2$1_0.VSS.n652 wind_comp_0.sg13g2_and2_2$1_0.VSS.n653 0.0120188
R2807 wind_comp_0.sg13g2_and2_2$1_0.VSS.n653 wind_comp_0.sg13g2_and2_2$1_0.VSS.n121 2.83124
R2808 wind_comp_0.sg13g2_and2_2$1_0.VSS.n652 wind_comp_0.sg13g2_and2_2$1_0.VSS.n651 0.0231839
R2809 wind_comp_0.sg13g2_and2_2$1_0.VSS.n650 wind_comp_0.sg13g2_and2_2$1_0.VSS.n651 0.0136
R2810 wind_comp_0.sg13g2_and2_2$1_0.VSS.n651 wind_comp_0.sg13g2_and2_2$1_0.VSS.n121 2.83111
R2811 wind_comp_0.sg13g2_and2_2$1_0.VSS.n650 wind_comp_0.sg13g2_and2_2$1_0.VSS.n649 0.0207457
R2812 wind_comp_0.sg13g2_and2_2$1_0.VSS.n648 wind_comp_0.sg13g2_and2_2$1_0.VSS.n649 0.0136
R2813 wind_comp_0.sg13g2_and2_2$1_0.VSS.n649 wind_comp_0.sg13g2_and2_2$1_0.VSS.n121 2.83111
R2814 wind_comp_0.sg13g2_and2_2$1_0.VSS.n648 wind_comp_0.sg13g2_and2_2$1_0.VSS.n647 0.0207457
R2815 wind_comp_0.sg13g2_and2_2$1_0.VSS.n646 wind_comp_0.sg13g2_and2_2$1_0.VSS.n647 0.0136
R2816 wind_comp_0.sg13g2_and2_2$1_0.VSS.n647 wind_comp_0.sg13g2_and2_2$1_0.VSS.n121 2.83111
R2817 wind_comp_0.sg13g2_and2_2$1_0.VSS.n646 wind_comp_0.sg13g2_and2_2$1_0.VSS.n645 0.0207457
R2818 wind_comp_0.sg13g2_and2_2$1_0.VSS.n644 wind_comp_0.sg13g2_and2_2$1_0.VSS.n645 0.0136
R2819 wind_comp_0.sg13g2_and2_2$1_0.VSS.n645 wind_comp_0.sg13g2_and2_2$1_0.VSS.n121 2.83111
R2820 wind_comp_0.sg13g2_and2_2$1_0.VSS.n644 wind_comp_0.sg13g2_and2_2$1_0.VSS.n643 0.0207457
R2821 wind_comp_0.sg13g2_and2_2$1_0.VSS.n642 wind_comp_0.sg13g2_and2_2$1_0.VSS.n643 0.0136
R2822 wind_comp_0.sg13g2_and2_2$1_0.VSS.n643 wind_comp_0.sg13g2_and2_2$1_0.VSS.n121 2.83111
R2823 wind_comp_0.sg13g2_and2_2$1_0.VSS.n642 wind_comp_0.sg13g2_and2_2$1_0.VSS.n641 0.0207457
R2824 wind_comp_0.sg13g2_and2_2$1_0.VSS.n640 wind_comp_0.sg13g2_and2_2$1_0.VSS.n641 0.0136
R2825 wind_comp_0.sg13g2_and2_2$1_0.VSS.n641 wind_comp_0.sg13g2_and2_2$1_0.VSS.n121 2.83111
R2826 wind_comp_0.sg13g2_and2_2$1_0.VSS.n640 wind_comp_0.sg13g2_and2_2$1_0.VSS.n639 0.0207457
R2827 wind_comp_0.sg13g2_and2_2$1_0.VSS.n638 wind_comp_0.sg13g2_and2_2$1_0.VSS.n639 0.0136
R2828 wind_comp_0.sg13g2_and2_2$1_0.VSS.n639 wind_comp_0.sg13g2_and2_2$1_0.VSS.n121 2.83111
R2829 wind_comp_0.sg13g2_and2_2$1_0.VSS.n638 wind_comp_0.sg13g2_and2_2$1_0.VSS.n637 0.0207457
R2830 wind_comp_0.sg13g2_and2_2$1_0.VSS.n636 wind_comp_0.sg13g2_and2_2$1_0.VSS.n637 0.0136
R2831 wind_comp_0.sg13g2_and2_2$1_0.VSS.n637 wind_comp_0.sg13g2_and2_2$1_0.VSS.n121 2.83111
R2832 wind_comp_0.sg13g2_and2_2$1_0.VSS.n636 wind_comp_0.sg13g2_and2_2$1_0.VSS.n635 0.0207457
R2833 wind_comp_0.sg13g2_and2_2$1_0.VSS.n634 wind_comp_0.sg13g2_and2_2$1_0.VSS.n635 0.0136
R2834 wind_comp_0.sg13g2_and2_2$1_0.VSS.n635 wind_comp_0.sg13g2_and2_2$1_0.VSS.n121 2.83111
R2835 wind_comp_0.sg13g2_and2_2$1_0.VSS.n634 wind_comp_0.sg13g2_and2_2$1_0.VSS.n633 0.0207457
R2836 wind_comp_0.sg13g2_and2_2$1_0.VSS.n632 wind_comp_0.sg13g2_and2_2$1_0.VSS.n633 0.0136
R2837 wind_comp_0.sg13g2_and2_2$1_0.VSS.n633 wind_comp_0.sg13g2_and2_2$1_0.VSS.n121 2.83111
R2838 wind_comp_0.sg13g2_and2_2$1_0.VSS.n632 wind_comp_0.sg13g2_and2_2$1_0.VSS.n631 0.0207457
R2839 wind_comp_0.sg13g2_and2_2$1_0.VSS.n630 wind_comp_0.sg13g2_and2_2$1_0.VSS.n631 0.0136
R2840 wind_comp_0.sg13g2_and2_2$1_0.VSS.n631 wind_comp_0.sg13g2_and2_2$1_0.VSS.n121 2.83111
R2841 wind_comp_0.sg13g2_and2_2$1_0.VSS.n2209 wind_comp_0.sg13g2_and2_2$1_0.VSS.n121 8.5005
R2842 wind_comp_0.sg13g2_and2_2$1_0.VSS.n2205 wind_comp_0.sg13g2_and2_2$1_0.VSS.n121 8.5005
R2843 wind_comp_0.sg13g2_and2_2$1_0.VSS.n2203 wind_comp_0.sg13g2_and2_2$1_0.VSS.n121 8.5005
R2844 wind_comp_0.sg13g2_and2_2$1_0.VSS.n2201 wind_comp_0.sg13g2_and2_2$1_0.VSS.n121 8.5005
R2845 wind_comp_0.sg13g2_and2_2$1_0.VSS.n2199 wind_comp_0.sg13g2_and2_2$1_0.VSS.n121 8.5005
R2846 wind_comp_0.sg13g2_and2_2$1_0.VSS.n2197 wind_comp_0.sg13g2_and2_2$1_0.VSS.n121 8.5005
R2847 wind_comp_0.sg13g2_and2_2$1_0.VSS.n2195 wind_comp_0.sg13g2_and2_2$1_0.VSS.n121 8.5005
R2848 wind_comp_0.sg13g2_and2_2$1_0.VSS.n2193 wind_comp_0.sg13g2_and2_2$1_0.VSS.n121 8.5005
R2849 wind_comp_0.sg13g2_and2_2$1_0.VSS.n2191 wind_comp_0.sg13g2_and2_2$1_0.VSS.n121 8.5005
R2850 wind_comp_0.sg13g2_and2_2$1_0.VSS.n2189 wind_comp_0.sg13g2_and2_2$1_0.VSS.n121 8.5005
R2851 wind_comp_0.sg13g2_and2_2$1_0.VSS.n2187 wind_comp_0.sg13g2_and2_2$1_0.VSS.n121 8.5005
R2852 wind_comp_0.sg13g2_and2_2$1_0.VSS.n2185 wind_comp_0.sg13g2_and2_2$1_0.VSS.n121 8.5005
R2853 wind_comp_0.sg13g2_and2_2$1_0.VSS.n2183 wind_comp_0.sg13g2_and2_2$1_0.VSS.n121 8.5005
R2854 wind_comp_0.sg13g2_and2_2$1_0.VSS.n2181 wind_comp_0.sg13g2_and2_2$1_0.VSS.n121 8.5005
R2855 wind_comp_0.sg13g2_and2_2$1_0.VSS.n2179 wind_comp_0.sg13g2_and2_2$1_0.VSS.n121 8.5005
R2856 wind_comp_0.sg13g2_and2_2$1_0.VSS.n2177 wind_comp_0.sg13g2_and2_2$1_0.VSS.n121 8.5005
R2857 wind_comp_0.sg13g2_and2_2$1_0.VSS.n2175 wind_comp_0.sg13g2_and2_2$1_0.VSS.n121 8.5005
R2858 wind_comp_0.sg13g2_and2_2$1_0.VSS.n2173 wind_comp_0.sg13g2_and2_2$1_0.VSS.n121 8.5005
R2859 wind_comp_0.sg13g2_and2_2$1_0.VSS.n2171 wind_comp_0.sg13g2_and2_2$1_0.VSS.n121 8.5005
R2860 wind_comp_0.sg13g2_and2_2$1_0.VSS.n2169 wind_comp_0.sg13g2_and2_2$1_0.VSS.n121 8.5005
R2861 wind_comp_0.sg13g2_and2_2$1_0.VSS.n2167 wind_comp_0.sg13g2_and2_2$1_0.VSS.n121 8.5005
R2862 wind_comp_0.sg13g2_and2_2$1_0.VSS.n2165 wind_comp_0.sg13g2_and2_2$1_0.VSS.n121 8.5005
R2863 wind_comp_0.sg13g2_and2_2$1_0.VSS.n2163 wind_comp_0.sg13g2_and2_2$1_0.VSS.n121 8.5005
R2864 wind_comp_0.sg13g2_and2_2$1_0.VSS.n2161 wind_comp_0.sg13g2_and2_2$1_0.VSS.n121 8.5005
R2865 wind_comp_0.sg13g2_and2_2$1_0.VSS.n2159 wind_comp_0.sg13g2_and2_2$1_0.VSS.n121 8.5005
R2866 wind_comp_0.sg13g2_and2_2$1_0.VSS.n2157 wind_comp_0.sg13g2_and2_2$1_0.VSS.n121 8.5005
R2867 wind_comp_0.sg13g2_and2_2$1_0.VSS.n2155 wind_comp_0.sg13g2_and2_2$1_0.VSS.n121 8.5005
R2868 wind_comp_0.sg13g2_and2_2$1_0.VSS.n397 wind_comp_0.sg13g2_and2_2$1_0.VSS.n121 4.24891
R2869 wind_comp_0.sg13g2_and2_2$1_0.VSS.n2151 wind_comp_0.sg13g2_and2_2$1_0.VSS.n121 8.5005
R2870 wind_comp_0.sg13g2_and2_2$1_0.VSS.n283 wind_comp_0.sg13g2_and2_2$1_0.VSS.n121 4.24891
R2871 wind_comp_0.sg13g2_and2_2$1_0.VSS.n2147 wind_comp_0.sg13g2_and2_2$1_0.VSS.n121 8.5005
R2872 wind_comp_0.sg13g2_and2_2$1_0.VSS.n2144 wind_comp_0.sg13g2_and2_2$1_0.VSS.n121 8.5005
R2873 wind_comp_0.sg13g2_and2_2$1_0.VSS.n628 wind_comp_0.sg13g2_and2_2$1_0.VSS.n121 8.5005
R2874 wind_comp_0.sg13g2_and2_2$1_0.VSS.n627 wind_comp_0.sg13g2_and2_2$1_0.VSS.n121 8.5005
R2875 wind_comp_0.sg13g2_and2_2$1_0.VSS.n2140 wind_comp_0.sg13g2_and2_2$1_0.VSS.n121 8.5005
R2876 wind_comp_0.sg13g2_and2_2$1_0.VSS.n359 wind_comp_0.sg13g2_and2_2$1_0.VSS.n121 4.24891
R2877 wind_comp_0.sg13g2_and2_2$1_0.VSS.n2136 wind_comp_0.sg13g2_and2_2$1_0.VSS.n121 8.5005
R2878 wind_comp_0.sg13g2_and2_2$1_0.VSS.n1964 wind_comp_0.sg13g2_and2_2$1_0.VSS.n121 8.5005
R2879 wind_comp_0.sg13g2_and2_2$1_0.VSS.n2129 wind_comp_0.sg13g2_and2_2$1_0.VSS.n121 8.5005
R2880 wind_comp_0.sg13g2_and2_2$1_0.VSS.n2046 wind_comp_0.sg13g2_and2_2$1_0.VSS.n121 8.5005
R2881 wind_comp_0.sg13g2_and2_2$1_0.VSS.n1968 wind_comp_0.sg13g2_and2_2$1_0.VSS.n121 8.5005
R2882 wind_comp_0.sg13g2_and2_2$1_0.VSS.n2034 wind_comp_0.sg13g2_and2_2$1_0.VSS.n121 8.5005
R2883 wind_comp_0.sg13g2_and2_2$1_0.VSS.n171 wind_comp_0.sg13g2_and2_2$1_0.VSS.n121 4.24974
R2884 wind_comp_0.sg13g2_and2_2$1_0.VSS.n232 wind_comp_0.sg13g2_and2_2$1_0.VSS.n121 4.24981
R2885 wind_comp_0.sg13g2_and2_2$1_0.VSS.n157 wind_comp_0.sg13g2_and2_2$1_0.VSS.n132 0.0141559
R2886 wind_comp_0.sg13g2_and2_2$1_0.VSS.n132 wind_comp_0.sg13g2_and2_2$1_0.VSS.n121 2.82735
R2887 wind_comp_0.sg13g2_and2_2$1_0.VSS.n134 wind_comp_0.sg13g2_and2_2$1_0.VSS.n132 0.0207601
R2888 wind_comp_0.sg13g2_and2_2$1_0.VSS.n252 wind_comp_0.sg13g2_and2_2$1_0.VSS.n121 4.24974
R2889 wind_comp_0.sg13g2_and2_2$1_0.VSS.n166 wind_comp_0.sg13g2_and2_2$1_0.VSS.n121 4.24981
R2890 wind_comp_0.sg13g2_and2_2$1_0.VSS.n152 wind_comp_0.sg13g2_and2_2$1_0.VSS.n88 0.0253251
R2891 wind_comp_0.sg13g2_and2_2$1_0.VSS.n88 wind_comp_0.sg13g2_and2_2$1_0.VSS.n121 1.68953
R2892 wind_comp_0.sg13g2_and2_2$1_0.VSS.n87 wind_comp_0.sg13g2_and2_2$1_0.VSS.n88 0.0273959
R2893 wind_comp_0.sg13g2_and2_2$1_0.VSS.n2074 wind_comp_0.sg13g2_and2_2$1_0.VSS.n121 8.5005
R2894 wind_comp_0.sg13g2_and2_2$1_0.VSS.n2072 wind_comp_0.sg13g2_and2_2$1_0.VSS.n121 8.5005
R2895 wind_comp_0.sg13g2_and2_2$1_0.VSS.n673 wind_comp_0.sg13g2_and2_2$1_0.VSS.n121 8.5005
R2896 wind_comp_0.sg13g2_and2_2$1_0.VSS.n672 wind_comp_0.sg13g2_and2_2$1_0.VSS.n121 8.5005
R2897 wind_comp_0.sg13g2_and2_2$1_0.VSS.n2068 wind_comp_0.sg13g2_and2_2$1_0.VSS.n121 8.5005
R2898 wind_comp_0.sg13g2_and2_2$1_0.VSS.n2065 wind_comp_0.sg13g2_and2_2$1_0.VSS.n121 8.5005
R2899 wind_comp_0.sg13g2_and2_2$1_0.VSS.n2030 wind_comp_0.sg13g2_and2_2$1_0.VSS.n121 8.5005
R2900 wind_comp_0.sg13g2_and2_2$1_0.VSS.n2062 wind_comp_0.sg13g2_and2_2$1_0.VSS.n121 8.5005
R2901 wind_comp_0.sg13g2_and2_2$1_0.VSS.n241 wind_comp_0.sg13g2_and2_2$1_0.VSS.n121 4.2496
R2902 wind_comp_0.sg13g2_and2_2$1_0.VSS.n611 wind_comp_0.sg13g2_and2_2$1_0.VSS.n121 8.5005
R2903 wind_comp_0.sg13g2_and2_2$1_0.VSS.n219 wind_comp_0.sg13g2_and2_2$1_0.VSS.n121 4.2496
R2904 wind_comp_0.sg13g2_and2_2$1_0.VSS.n2028 wind_comp_0.sg13g2_and2_2$1_0.VSS.n121 8.5005
R2905 wind_comp_0.sg13g2_and2_2$1_0.VSS.n160 wind_comp_0.sg13g2_and2_2$1_0.VSS.n121 0.556814
R2906 wind_comp_0.sg13g2_and2_2$1_0.VSS.n159 wind_comp_0.sg13g2_and2_2$1_0.VSS.n160 0.00232415
R2907 wind_comp_0.sg13g2_and2_2$1_0.VSS.t248 wind_comp_0.sg13g2_and2_2$1_0.VSS.n121 8.5005
R2908 wind_comp_0.sg13g2_and2_2$1_0.VSS.n1299 wind_comp_0.sg13g2_and2_2$1_0.VSS.n121 8.5005
R2909 wind_comp_0.sg13g2_and2_2$1_0.VSS.n1296 wind_comp_0.sg13g2_and2_2$1_0.VSS.n121 8.5005
R2910 wind_comp_0.sg13g2_and2_2$1_0.VSS.n1294 wind_comp_0.sg13g2_and2_2$1_0.VSS.n121 8.5005
R2911 wind_comp_0.sg13g2_and2_2$1_0.VSS.n1291 wind_comp_0.sg13g2_and2_2$1_0.VSS.n121 8.5005
R2912 wind_comp_0.sg13g2_and2_2$1_0.VSS.n1288 wind_comp_0.sg13g2_and2_2$1_0.VSS.n121 8.5005
R2913 wind_comp_0.sg13g2_and2_2$1_0.VSS.n1286 wind_comp_0.sg13g2_and2_2$1_0.VSS.n121 8.5005
R2914 wind_comp_0.sg13g2_and2_2$1_0.VSS.n1283 wind_comp_0.sg13g2_and2_2$1_0.VSS.n121 8.5005
R2915 wind_comp_0.sg13g2_and2_2$1_0.VSS.n1281 wind_comp_0.sg13g2_and2_2$1_0.VSS.n121 8.5005
R2916 wind_comp_0.sg13g2_and2_2$1_0.VSS.n1279 wind_comp_0.sg13g2_and2_2$1_0.VSS.n121 8.5005
R2917 wind_comp_0.sg13g2_and2_2$1_0.VSS.n1277 wind_comp_0.sg13g2_and2_2$1_0.VSS.n121 8.5005
R2918 wind_comp_0.sg13g2_and2_2$1_0.VSS.n1519 wind_comp_0.sg13g2_and2_2$1_0.VSS.n121 8.5005
R2919 wind_comp_0.sg13g2_and2_2$1_0.VSS.n1274 wind_comp_0.sg13g2_and2_2$1_0.VSS.n121 8.5005
R2920 wind_comp_0.sg13g2_and2_2$1_0.VSS.n1400 wind_comp_0.sg13g2_and2_2$1_0.VSS.n121 8.5005
R2921 wind_comp_0.sg13g2_and2_2$1_0.VSS.n1516 wind_comp_0.sg13g2_and2_2$1_0.VSS.n121 8.5005
R2922 wind_comp_0.sg13g2_and2_2$1_0.VSS.n1269 wind_comp_0.sg13g2_and2_2$1_0.VSS.n121 8.5005
R2923 wind_comp_0.sg13g2_and2_2$1_0.VSS.n1267 wind_comp_0.sg13g2_and2_2$1_0.VSS.n121 8.5005
R2924 wind_comp_0.sg13g2_and2_2$1_0.VSS.n1514 wind_comp_0.sg13g2_and2_2$1_0.VSS.n121 8.5005
R2925 wind_comp_0.sg13g2_and2_2$1_0.VSS.n1403 wind_comp_0.sg13g2_and2_2$1_0.VSS.n121 8.5005
R2926 wind_comp_0.sg13g2_and2_2$1_0.VSS.n1265 wind_comp_0.sg13g2_and2_2$1_0.VSS.n121 8.5005
R2927 wind_comp_0.sg13g2_and2_2$1_0.VSS.n1510 wind_comp_0.sg13g2_and2_2$1_0.VSS.n121 8.5005
R2928 wind_comp_0.sg13g2_and2_2$1_0.VSS.n1406 wind_comp_0.sg13g2_and2_2$1_0.VSS.n121 8.5005
R2929 wind_comp_0.sg13g2_and2_2$1_0.VSS.n1263 wind_comp_0.sg13g2_and2_2$1_0.VSS.n121 8.5005
R2930 wind_comp_0.sg13g2_and2_2$1_0.VSS.n1507 wind_comp_0.sg13g2_and2_2$1_0.VSS.n121 8.5005
R2931 wind_comp_0.sg13g2_and2_2$1_0.VSS.n1412 wind_comp_0.sg13g2_and2_2$1_0.VSS.n121 8.5005
R2932 wind_comp_0.sg13g2_and2_2$1_0.VSS.n1504 wind_comp_0.sg13g2_and2_2$1_0.VSS.n121 8.5005
R2933 wind_comp_0.sg13g2_and2_2$1_0.VSS.n1261 wind_comp_0.sg13g2_and2_2$1_0.VSS.n121 8.5005
R2934 wind_comp_0.sg13g2_and2_2$1_0.VSS.n1417 wind_comp_0.sg13g2_and2_2$1_0.VSS.n121 8.5005
R2935 wind_comp_0.sg13g2_and2_2$1_0.VSS.n1501 wind_comp_0.sg13g2_and2_2$1_0.VSS.n121 8.5005
R2936 wind_comp_0.sg13g2_and2_2$1_0.VSS.n1259 wind_comp_0.sg13g2_and2_2$1_0.VSS.n121 8.5005
R2937 wind_comp_0.sg13g2_and2_2$1_0.VSS.n1422 wind_comp_0.sg13g2_and2_2$1_0.VSS.n121 8.5005
R2938 wind_comp_0.sg13g2_and2_2$1_0.VSS.n1499 wind_comp_0.sg13g2_and2_2$1_0.VSS.n121 8.5005
R2939 wind_comp_0.sg13g2_and2_2$1_0.VSS.n1426 wind_comp_0.sg13g2_and2_2$1_0.VSS.n121 8.5005
R2940 wind_comp_0.sg13g2_and2_2$1_0.VSS.n121 wind_comp_0.sg13g2_and2_2$1_0.VSS.n1199 8.5005
R2941 wind_comp_0.sg13g2_and2_2$1_0.VSS.n1497 wind_comp_0.sg13g2_and2_2$1_0.VSS.n121 8.5005
R2942 wind_comp_0.sg13g2_and2_2$1_0.VSS.n1430 wind_comp_0.sg13g2_and2_2$1_0.VSS.n121 8.5005
R2943 wind_comp_0.sg13g2_and2_2$1_0.VSS.n121 wind_comp_0.sg13g2_and2_2$1_0.VSS.n1226 8.5005
R2944 wind_comp_0.sg13g2_and2_2$1_0.VSS.n1399 wind_comp_0.sg13g2_and2_2$1_0.VSS.n121 8.5005
R2945 wind_comp_0.sg13g2_and2_2$1_0.VSS.n1524 wind_comp_0.sg13g2_and2_2$1_0.VSS.n121 8.5005
R2946 wind_comp_0.sg13g2_and2_2$1_0.VSS.n1397 wind_comp_0.sg13g2_and2_2$1_0.VSS.n121 8.5005
R2947 wind_comp_0.sg13g2_and2_2$1_0.VSS.n1492 wind_comp_0.sg13g2_and2_2$1_0.VSS.n121 8.5005
R2948 wind_comp_0.sg13g2_and2_2$1_0.VSS.n1395 wind_comp_0.sg13g2_and2_2$1_0.VSS.n121 8.5005
R2949 wind_comp_0.sg13g2_and2_2$1_0.VSS.n1393 wind_comp_0.sg13g2_and2_2$1_0.VSS.n121 8.5005
R2950 wind_comp_0.sg13g2_and2_2$1_0.VSS.n1488 wind_comp_0.sg13g2_and2_2$1_0.VSS.n121 8.5005
R2951 wind_comp_0.sg13g2_and2_2$1_0.VSS.n1391 wind_comp_0.sg13g2_and2_2$1_0.VSS.n121 8.5005
R2952 wind_comp_0.sg13g2_and2_2$1_0.VSS.n1389 wind_comp_0.sg13g2_and2_2$1_0.VSS.n121 8.5005
R2953 wind_comp_0.sg13g2_and2_2$1_0.VSS.n1484 wind_comp_0.sg13g2_and2_2$1_0.VSS.n121 8.5005
R2954 wind_comp_0.sg13g2_and2_2$1_0.VSS.n1436 wind_comp_0.sg13g2_and2_2$1_0.VSS.n121 8.5005
R2955 wind_comp_0.sg13g2_and2_2$1_0.VSS.n1385 wind_comp_0.sg13g2_and2_2$1_0.VSS.n121 8.5005
R2956 wind_comp_0.sg13g2_and2_2$1_0.VSS.n1383 wind_comp_0.sg13g2_and2_2$1_0.VSS.n121 8.5005
R2957 wind_comp_0.sg13g2_and2_2$1_0.VSS.t2 wind_comp_0.sg13g2_and2_2$1_0.VSS.n121 8.5005
R2958 wind_comp_0.sg13g2_and2_2$1_0.VSS.n1380 wind_comp_0.sg13g2_and2_2$1_0.VSS.n121 8.5005
R2959 wind_comp_0.sg13g2_and2_2$1_0.VSS.n1378 wind_comp_0.sg13g2_and2_2$1_0.VSS.n121 8.5005
R2960 wind_comp_0.sg13g2_and2_2$1_0.VSS.n1439 wind_comp_0.sg13g2_and2_2$1_0.VSS.n121 8.5005
R2961 wind_comp_0.sg13g2_and2_2$1_0.VSS.n1473 wind_comp_0.sg13g2_and2_2$1_0.VSS.n121 8.5005
R2962 wind_comp_0.sg13g2_and2_2$1_0.VSS.n1373 wind_comp_0.sg13g2_and2_2$1_0.VSS.n121 8.5005
R2963 wind_comp_0.sg13g2_and2_2$1_0.VSS.n1441 wind_comp_0.sg13g2_and2_2$1_0.VSS.n121 8.5005
R2964 wind_comp_0.sg13g2_and2_2$1_0.VSS.n1469 wind_comp_0.sg13g2_and2_2$1_0.VSS.n121 8.5005
R2965 wind_comp_0.sg13g2_and2_2$1_0.VSS.n1371 wind_comp_0.sg13g2_and2_2$1_0.VSS.n121 8.5005
R2966 wind_comp_0.sg13g2_and2_2$1_0.VSS.n1369 wind_comp_0.sg13g2_and2_2$1_0.VSS.n121 8.5005
R2967 wind_comp_0.sg13g2_and2_2$1_0.VSS.t0 wind_comp_0.sg13g2_and2_2$1_0.VSS.n121 8.5005
R2968 wind_comp_0.sg13g2_and2_2$1_0.VSS.n1367 wind_comp_0.sg13g2_and2_2$1_0.VSS.n121 8.5005
R2969 wind_comp_0.sg13g2_and2_2$1_0.VSS.n1365 wind_comp_0.sg13g2_and2_2$1_0.VSS.n121 8.5005
R2970 wind_comp_0.sg13g2_and2_2$1_0.VSS.n1462 wind_comp_0.sg13g2_and2_2$1_0.VSS.n121 8.5005
R2971 wind_comp_0.sg13g2_and2_2$1_0.VSS.n1444 wind_comp_0.sg13g2_and2_2$1_0.VSS.n121 8.5005
R2972 wind_comp_0.sg13g2_and2_2$1_0.VSS.n1362 wind_comp_0.sg13g2_and2_2$1_0.VSS.n121 8.5005
R2973 wind_comp_0.sg13g2_and2_2$1_0.VSS.n1360 wind_comp_0.sg13g2_and2_2$1_0.VSS.n121 8.5005
R2974 wind_comp_0.sg13g2_and2_2$1_0.VSS.n1447 wind_comp_0.sg13g2_and2_2$1_0.VSS.n121 8.5005
R2975 wind_comp_0.sg13g2_and2_2$1_0.VSS.n1358 wind_comp_0.sg13g2_and2_2$1_0.VSS.n121 8.5005
R2976 wind_comp_0.sg13g2_and2_2$1_0.VSS.n1356 wind_comp_0.sg13g2_and2_2$1_0.VSS.n121 8.5005
R2977 wind_comp_0.sg13g2_and2_2$1_0.VSS.n1451 wind_comp_0.sg13g2_and2_2$1_0.VSS.n121 8.5005
R2978 wind_comp_0.sg13g2_and2_2$1_0.VSS.n1458 wind_comp_0.sg13g2_and2_2$1_0.VSS.n121 8.5005
R2979 wind_comp_0.sg13g2_and2_2$1_0.VSS.n1313 wind_comp_0.sg13g2_and2_2$1_0.VSS.n121 8.5005
R2980 wind_comp_0.sg13g2_and2_2$1_0.VSS.n9 wind_comp_0.sg13g2_and2_2$1_0.VSS.n121 1.65203
R2981 wind_comp_0.sg13g2_and2_2$1_0.VSS.n9 wind_comp_0.sg13g2_and2_2$1_0.VSS.n8 0.866489
R2982 wind_comp_0.sg13g2_and2_2$1_0.VSS.n11 wind_comp_0.sg13g2_and2_2$1_0.VSS.n4 1.25406
R2983 wind_comp_0.sg13g2_and2_2$1_0.VSS.n121 wind_comp_0.sg13g2_and2_2$1_0.VSS.n11 1.22207
R2984 wind_comp_0.sg13g2_and2_2$1_0.VSS.n121 wind_comp_0.sg13g2_and2_2$1_0.VSS.n1200 8.5005
R2985 wind_comp_0.sg13g2_and2_2$1_0.VSS.n121 wind_comp_0.sg13g2_and2_2$1_0.VSS.n1225 8.5005
R2986 wind_comp_0.sg13g2_and2_2$1_0.VSS.n121 wind_comp_0.sg13g2_and2_2$1_0.VSS.n1201 8.5005
R2987 wind_comp_0.sg13g2_and2_2$1_0.VSS.n121 wind_comp_0.sg13g2_and2_2$1_0.VSS.n1224 8.5005
R2988 wind_comp_0.sg13g2_and2_2$1_0.VSS.n121 wind_comp_0.sg13g2_and2_2$1_0.VSS.n1202 8.5005
R2989 wind_comp_0.sg13g2_and2_2$1_0.VSS.n121 wind_comp_0.sg13g2_and2_2$1_0.VSS.n1223 8.5005
R2990 wind_comp_0.sg13g2_and2_2$1_0.VSS.n121 wind_comp_0.sg13g2_and2_2$1_0.VSS.n1203 8.5005
R2991 wind_comp_0.sg13g2_and2_2$1_0.VSS.n121 wind_comp_0.sg13g2_and2_2$1_0.VSS.n1222 8.5005
R2992 wind_comp_0.sg13g2_and2_2$1_0.VSS.n121 wind_comp_0.sg13g2_and2_2$1_0.VSS.n1204 8.5005
R2993 wind_comp_0.sg13g2_and2_2$1_0.VSS.n121 wind_comp_0.sg13g2_and2_2$1_0.VSS.n1221 8.5005
R2994 wind_comp_0.sg13g2_and2_2$1_0.VSS.n121 wind_comp_0.sg13g2_and2_2$1_0.VSS.n1205 8.5005
R2995 wind_comp_0.sg13g2_and2_2$1_0.VSS.n121 wind_comp_0.sg13g2_and2_2$1_0.VSS.n1220 8.5005
R2996 wind_comp_0.sg13g2_and2_2$1_0.VSS.n121 wind_comp_0.sg13g2_and2_2$1_0.VSS.n1207 8.5005
R2997 wind_comp_0.sg13g2_and2_2$1_0.VSS.n121 wind_comp_0.sg13g2_and2_2$1_0.VSS.n1219 8.5005
R2998 wind_comp_0.sg13g2_and2_2$1_0.VSS.n121 wind_comp_0.sg13g2_and2_2$1_0.VSS.n1208 8.5005
R2999 wind_comp_0.sg13g2_and2_2$1_0.VSS.n121 wind_comp_0.sg13g2_and2_2$1_0.VSS.n1218 8.5005
R3000 wind_comp_0.sg13g2_and2_2$1_0.VSS.n121 wind_comp_0.sg13g2_and2_2$1_0.VSS.n1209 8.5005
R3001 wind_comp_0.sg13g2_and2_2$1_0.VSS.n121 wind_comp_0.sg13g2_and2_2$1_0.VSS.n1217 8.5005
R3002 wind_comp_0.sg13g2_and2_2$1_0.VSS.n121 wind_comp_0.sg13g2_and2_2$1_0.VSS.n1210 8.5005
R3003 wind_comp_0.sg13g2_and2_2$1_0.VSS.n121 wind_comp_0.sg13g2_and2_2$1_0.VSS.n1216 8.5005
R3004 wind_comp_0.sg13g2_and2_2$1_0.VSS.n121 wind_comp_0.sg13g2_and2_2$1_0.VSS.n1211 8.5005
R3005 wind_comp_0.sg13g2_and2_2$1_0.VSS.n121 wind_comp_0.sg13g2_and2_2$1_0.VSS.n1215 8.5005
R3006 wind_comp_0.sg13g2_and2_2$1_0.VSS.n121 wind_comp_0.sg13g2_and2_2$1_0.VSS.n1212 8.5005
R3007 wind_comp_0.sg13g2_and2_2$1_0.VSS.n121 wind_comp_0.sg13g2_and2_2$1_0.VSS.n1214 8.5005
R3008 wind_comp_0.sg13g2_and2_2$1_0.VSS.n121 wind_comp_0.sg13g2_and2_2$1_0.VSS.n1213 8.5005
R3009 wind_comp_0.sg13g2_and2_2$1_0.VSS.n121 wind_comp_0.sg13g2_and2_2$1_0.VSS.n12 1.39602
R3010 wind_comp_0.sg13g2_and2_2$1_0.VSS.n12 wind_comp_0.sg13g2_and2_2$1_0.VSS.n4 1.27531
R3011 wind_comp_0.sg13g2_and2_2$1_0.VSS.n128 wind_comp_0.sg13g2_and2_2$1_0.VSS.n1198 8.5005
R3012 wind_comp_0.sg13g2_and2_2$1_0.VSS.n1605 wind_comp_0.sg13g2_and2_2$1_0.VSS.n128 8.5005
R3013 wind_comp_0.sg13g2_and2_2$1_0.VSS.n1604 wind_comp_0.sg13g2_and2_2$1_0.VSS.n128 8.5005
R3014 wind_comp_0.sg13g2_and2_2$1_0.VSS.n1574 wind_comp_0.sg13g2_and2_2$1_0.VSS.n128 8.5005
R3015 wind_comp_0.sg13g2_and2_2$1_0.VSS.n1585 wind_comp_0.sg13g2_and2_2$1_0.VSS.n121 8.5005
R3016 wind_comp_0.sg13g2_and2_2$1_0.VSS.n1582 wind_comp_0.sg13g2_and2_2$1_0.VSS.n121 8.5005
R3017 wind_comp_0.sg13g2_and2_2$1_0.VSS.n1580 wind_comp_0.sg13g2_and2_2$1_0.VSS.n121 8.5005
R3018 wind_comp_0.sg13g2_and2_2$1_0.VSS.n121 wind_comp_0.sg13g2_and2_2$1_0.VSS.n131 4.77297
R3019 wind_comp_0.sg13g2_and2_2$1_0.VSS.n121 wind_comp_0.sg13g2_and2_2$1_0.VSS.n1227 8.5005
R3020 wind_comp_0.sg13g2_and2_2$1_0.VSS.n121 wind_comp_0.sg13g2_and2_2$1_0.VSS.n1228 8.5005
R3021 wind_comp_0.sg13g2_and2_2$1_0.VSS.n1899 wind_comp_0.sg13g2_and2_2$1_0.VSS.n121 8.5005
R3022 wind_comp_0.sg13g2_and2_2$1_0.VSS.n1927 wind_comp_0.sg13g2_and2_2$1_0.VSS.n121 8.5005
R3023 wind_comp_0.sg13g2_and2_2$1_0.VSS.n128 wind_comp_0.sg13g2_and2_2$1_0.VSS.n919 8.5005
R3024 wind_comp_0.sg13g2_and2_2$1_0.VSS.n128 wind_comp_0.sg13g2_and2_2$1_0.VSS.n228 4.24985
R3025 wind_comp_0.sg13g2_and2_2$1_0.VSS.n128 wind_comp_0.sg13g2_and2_2$1_0.VSS.n238 4.2497
R3026 wind_comp_0.sg13g2_and2_2$1_0.VSS.n138 wind_comp_0.sg13g2_and2_2$1_0.VSS.n144 0.00723311
R3027 wind_comp_0.sg13g2_and2_2$1_0.VSS.n128 wind_comp_0.sg13g2_and2_2$1_0.VSS.n138 2.83197
R3028 wind_comp_0.sg13g2_and2_2$1_0.VSS.n105 wind_comp_0.sg13g2_and2_2$1_0.VSS.n119 0.00380243
R3029 wind_comp_0.sg13g2_and2_2$1_0.VSS.n128 wind_comp_0.sg13g2_and2_2$1_0.VSS.n105 4.2496
R3030 wind_comp_0.sg13g2_and2_2$1_0.VSS.n128 wind_comp_0.sg13g2_and2_2$1_0.VSS.n655 8.5005
R3031 wind_comp_0.sg13g2_and2_2$1_0.VSS.n128 wind_comp_0.sg13g2_and2_2$1_0.VSS.n1070 8.5005
R3032 wind_comp_0.sg13g2_and2_2$1_0.VSS.n128 wind_comp_0.sg13g2_and2_2$1_0.VSS.n1073 8.5005
R3033 wind_comp_0.sg13g2_and2_2$1_0.VSS.n128 wind_comp_0.sg13g2_and2_2$1_0.VSS.n1074 8.5005
R3034 wind_comp_0.sg13g2_and2_2$1_0.VSS.n128 wind_comp_0.sg13g2_and2_2$1_0.VSS.n1077 8.5005
R3035 wind_comp_0.sg13g2_and2_2$1_0.VSS.n128 wind_comp_0.sg13g2_and2_2$1_0.VSS.n1078 8.5005
R3036 wind_comp_0.sg13g2_and2_2$1_0.VSS.n128 wind_comp_0.sg13g2_and2_2$1_0.VSS.n1081 8.5005
R3037 wind_comp_0.sg13g2_and2_2$1_0.VSS.n128 wind_comp_0.sg13g2_and2_2$1_0.VSS.n1082 8.5005
R3038 wind_comp_0.sg13g2_and2_2$1_0.VSS.n128 wind_comp_0.sg13g2_and2_2$1_0.VSS.n1085 8.5005
R3039 wind_comp_0.sg13g2_and2_2$1_0.VSS.n128 wind_comp_0.sg13g2_and2_2$1_0.VSS.n1086 8.5005
R3040 wind_comp_0.sg13g2_and2_2$1_0.VSS.n128 wind_comp_0.sg13g2_and2_2$1_0.VSS.n1089 8.5005
R3041 wind_comp_0.sg13g2_and2_2$1_0.VSS.n128 wind_comp_0.sg13g2_and2_2$1_0.VSS.n1090 8.5005
R3042 wind_comp_0.sg13g2_and2_2$1_0.VSS.n128 wind_comp_0.sg13g2_and2_2$1_0.VSS.n1091 8.5005
R3043 wind_comp_0.sg13g2_and2_2$1_0.VSS.n128 wind_comp_0.sg13g2_and2_2$1_0.VSS.n1093 8.5005
R3044 wind_comp_0.sg13g2_and2_2$1_0.VSS.n128 wind_comp_0.sg13g2_and2_2$1_0.VSS.n1094 8.5005
R3045 wind_comp_0.sg13g2_and2_2$1_0.VSS.n128 wind_comp_0.sg13g2_and2_2$1_0.VSS.n1097 8.5005
R3046 wind_comp_0.sg13g2_and2_2$1_0.VSS.n128 wind_comp_0.sg13g2_and2_2$1_0.VSS.n1098 8.5005
R3047 wind_comp_0.sg13g2_and2_2$1_0.VSS.n128 wind_comp_0.sg13g2_and2_2$1_0.VSS.n1101 8.5005
R3048 wind_comp_0.sg13g2_and2_2$1_0.VSS.n128 wind_comp_0.sg13g2_and2_2$1_0.VSS.n1102 8.5005
R3049 wind_comp_0.sg13g2_and2_2$1_0.VSS.n128 wind_comp_0.sg13g2_and2_2$1_0.VSS.n1105 8.5005
R3050 wind_comp_0.sg13g2_and2_2$1_0.VSS.n128 wind_comp_0.sg13g2_and2_2$1_0.VSS.n1106 8.5005
R3051 wind_comp_0.sg13g2_and2_2$1_0.VSS.n128 wind_comp_0.sg13g2_and2_2$1_0.VSS.n1109 8.5005
R3052 wind_comp_0.sg13g2_and2_2$1_0.VSS.n128 wind_comp_0.sg13g2_and2_2$1_0.VSS.n1110 8.5005
R3053 wind_comp_0.sg13g2_and2_2$1_0.VSS.n128 wind_comp_0.sg13g2_and2_2$1_0.VSS.n1113 8.5005
R3054 wind_comp_0.sg13g2_and2_2$1_0.VSS.n128 wind_comp_0.sg13g2_and2_2$1_0.VSS.n1114 8.5005
R3055 wind_comp_0.sg13g2_and2_2$1_0.VSS.n128 wind_comp_0.sg13g2_and2_2$1_0.VSS.n1117 8.5005
R3056 wind_comp_0.sg13g2_and2_2$1_0.VSS.n128 wind_comp_0.sg13g2_and2_2$1_0.VSS.n1118 8.5005
R3057 wind_comp_0.sg13g2_and2_2$1_0.VSS.n128 wind_comp_0.sg13g2_and2_2$1_0.VSS.n1121 8.5005
R3058 wind_comp_0.sg13g2_and2_2$1_0.VSS.n128 wind_comp_0.sg13g2_and2_2$1_0.VSS.n1122 8.5005
R3059 wind_comp_0.sg13g2_and2_2$1_0.VSS.n128 wind_comp_0.sg13g2_and2_2$1_0.VSS.n1125 8.5005
R3060 wind_comp_0.sg13g2_and2_2$1_0.VSS.n128 wind_comp_0.sg13g2_and2_2$1_0.VSS.n1126 8.5005
R3061 wind_comp_0.sg13g2_and2_2$1_0.VSS.n128 wind_comp_0.sg13g2_and2_2$1_0.VSS.n1129 8.5005
R3062 wind_comp_0.sg13g2_and2_2$1_0.VSS.n128 wind_comp_0.sg13g2_and2_2$1_0.VSS.n1130 8.5005
R3063 wind_comp_0.sg13g2_and2_2$1_0.VSS.n128 wind_comp_0.sg13g2_and2_2$1_0.VSS.n1133 8.5005
R3064 wind_comp_0.sg13g2_and2_2$1_0.VSS.n128 wind_comp_0.sg13g2_and2_2$1_0.VSS.n1134 8.5005
R3065 wind_comp_0.sg13g2_and2_2$1_0.VSS.n128 wind_comp_0.sg13g2_and2_2$1_0.VSS.n1137 8.5005
R3066 wind_comp_0.sg13g2_and2_2$1_0.VSS.n128 wind_comp_0.sg13g2_and2_2$1_0.VSS.n1138 8.5005
R3067 wind_comp_0.sg13g2_and2_2$1_0.VSS.n128 wind_comp_0.sg13g2_and2_2$1_0.VSS.n1139 8.5005
R3068 wind_comp_0.sg13g2_and2_2$1_0.VSS.n128 wind_comp_0.sg13g2_and2_2$1_0.VSS.n1141 8.5005
R3069 wind_comp_0.sg13g2_and2_2$1_0.VSS.n128 wind_comp_0.sg13g2_and2_2$1_0.VSS.n1142 8.5005
R3070 wind_comp_0.sg13g2_and2_2$1_0.VSS.n128 wind_comp_0.sg13g2_and2_2$1_0.VSS.n1145 8.5005
R3071 wind_comp_0.sg13g2_and2_2$1_0.VSS.n128 wind_comp_0.sg13g2_and2_2$1_0.VSS.n1146 8.5005
R3072 wind_comp_0.sg13g2_and2_2$1_0.VSS.n128 wind_comp_0.sg13g2_and2_2$1_0.VSS.n1149 8.5005
R3073 wind_comp_0.sg13g2_and2_2$1_0.VSS.n128 wind_comp_0.sg13g2_and2_2$1_0.VSS.n1150 8.5005
R3074 wind_comp_0.sg13g2_and2_2$1_0.VSS.n128 wind_comp_0.sg13g2_and2_2$1_0.VSS.n1153 8.5005
R3075 wind_comp_0.sg13g2_and2_2$1_0.VSS.n128 wind_comp_0.sg13g2_and2_2$1_0.VSS.n1154 8.5005
R3076 wind_comp_0.sg13g2_and2_2$1_0.VSS.n128 wind_comp_0.sg13g2_and2_2$1_0.VSS.n1157 8.5005
R3077 wind_comp_0.sg13g2_and2_2$1_0.VSS.n128 wind_comp_0.sg13g2_and2_2$1_0.VSS.n1158 8.5005
R3078 wind_comp_0.sg13g2_and2_2$1_0.VSS.n128 wind_comp_0.sg13g2_and2_2$1_0.VSS.n1161 8.5005
R3079 wind_comp_0.sg13g2_and2_2$1_0.VSS.n128 wind_comp_0.sg13g2_and2_2$1_0.VSS.n1162 8.5005
R3080 wind_comp_0.sg13g2_and2_2$1_0.VSS.n128 wind_comp_0.sg13g2_and2_2$1_0.VSS.n1165 8.5005
R3081 wind_comp_0.sg13g2_and2_2$1_0.VSS.n128 wind_comp_0.sg13g2_and2_2$1_0.VSS.n1166 8.5005
R3082 wind_comp_0.sg13g2_and2_2$1_0.VSS.n128 wind_comp_0.sg13g2_and2_2$1_0.VSS.n1169 8.5005
R3083 wind_comp_0.sg13g2_and2_2$1_0.VSS.n128 wind_comp_0.sg13g2_and2_2$1_0.VSS.n1170 8.5005
R3084 wind_comp_0.sg13g2_and2_2$1_0.VSS.n128 wind_comp_0.sg13g2_and2_2$1_0.VSS.n1173 8.5005
R3085 wind_comp_0.sg13g2_and2_2$1_0.VSS.n128 wind_comp_0.sg13g2_and2_2$1_0.VSS.n1174 8.5005
R3086 wind_comp_0.sg13g2_and2_2$1_0.VSS.n128 wind_comp_0.sg13g2_and2_2$1_0.VSS.n1177 8.5005
R3087 wind_comp_0.sg13g2_and2_2$1_0.VSS.n128 wind_comp_0.sg13g2_and2_2$1_0.VSS.n1178 8.5005
R3088 wind_comp_0.sg13g2_and2_2$1_0.VSS.n128 wind_comp_0.sg13g2_and2_2$1_0.VSS.n1181 8.5005
R3089 wind_comp_0.sg13g2_and2_2$1_0.VSS.n128 wind_comp_0.sg13g2_and2_2$1_0.VSS.n1182 8.5005
R3090 wind_comp_0.sg13g2_and2_2$1_0.VSS.n128 wind_comp_0.sg13g2_and2_2$1_0.VSS.n1185 8.5005
R3091 wind_comp_0.sg13g2_and2_2$1_0.VSS.n128 wind_comp_0.sg13g2_and2_2$1_0.VSS.n1186 8.5005
R3092 wind_comp_0.sg13g2_and2_2$1_0.VSS.n128 wind_comp_0.sg13g2_and2_2$1_0.VSS.n1189 8.5005
R3093 wind_comp_0.sg13g2_and2_2$1_0.VSS.n128 wind_comp_0.sg13g2_and2_2$1_0.VSS.n1190 8.5005
R3094 wind_comp_0.sg13g2_and2_2$1_0.VSS.n128 wind_comp_0.sg13g2_and2_2$1_0.VSS.n1193 8.5005
R3095 wind_comp_0.sg13g2_and2_2$1_0.VSS.n128 wind_comp_0.sg13g2_and2_2$1_0.VSS.n1194 8.5005
R3096 wind_comp_0.sg13g2_and2_2$1_0.VSS.n128 wind_comp_0.sg13g2_and2_2$1_0.VSS.n1197 8.5005
R3097 wind_comp_0.sg13g2_and2_2$1_0.VSS.n68 wind_comp_0.sg13g2_and2_2$1_0.VSS.n567 8.5005
R3098 wind_comp_0.sg13g2_and2_2$1_0.VSS.n68 wind_comp_0.sg13g2_and2_2$1_0.VSS.n565 8.5005
R3099 wind_comp_0.sg13g2_and2_2$1_0.VSS.n68 wind_comp_0.sg13g2_and2_2$1_0.VSS.n564 3.39877
R3100 wind_comp_0.sg13g2_and2_2$1_0.VSS.n68 wind_comp_0.sg13g2_and2_2$1_0.VSS.n563 8.5005
R3101 wind_comp_0.sg13g2_and2_2$1_0.VSS.n68 wind_comp_0.sg13g2_and2_2$1_0.VSS.n562 8.5005
R3102 wind_comp_0.sg13g2_and2_2$1_0.VSS.n68 wind_comp_0.sg13g2_and2_2$1_0.VSS.n561 8.5005
R3103 wind_comp_0.sg13g2_and2_2$1_0.VSS.n68 wind_comp_0.sg13g2_and2_2$1_0.VSS.n560 8.5005
R3104 wind_comp_0.sg13g2_and2_2$1_0.VSS.n68 wind_comp_0.sg13g2_and2_2$1_0.VSS.n559 8.5005
R3105 wind_comp_0.sg13g2_and2_2$1_0.VSS.n68 wind_comp_0.sg13g2_and2_2$1_0.VSS.n558 8.5005
R3106 wind_comp_0.sg13g2_and2_2$1_0.VSS.n68 wind_comp_0.sg13g2_and2_2$1_0.VSS.n557 8.5005
R3107 wind_comp_0.sg13g2_and2_2$1_0.VSS.n68 wind_comp_0.sg13g2_and2_2$1_0.VSS.n556 8.5005
R3108 wind_comp_0.sg13g2_and2_2$1_0.VSS.n68 wind_comp_0.sg13g2_and2_2$1_0.VSS.n555 8.5005
R3109 wind_comp_0.sg13g2_and2_2$1_0.VSS.n68 wind_comp_0.sg13g2_and2_2$1_0.VSS.n554 8.5005
R3110 wind_comp_0.sg13g2_and2_2$1_0.VSS.n68 wind_comp_0.sg13g2_and2_2$1_0.VSS.n553 8.5005
R3111 wind_comp_0.sg13g2_and2_2$1_0.VSS.n201 wind_comp_0.sg13g2_and2_2$1_0.VSS.n552 3.40012
R3112 wind_comp_0.sg13g2_and2_2$1_0.VSS.n68 wind_comp_0.sg13g2_and2_2$1_0.VSS.n551 8.5005
R3113 wind_comp_0.sg13g2_and2_2$1_0.VSS.n69 wind_comp_0.sg13g2_and2_2$1_0.VSS.n550 3.39087
R3114 wind_comp_0.sg13g2_and2_2$1_0.VSS.n68 wind_comp_0.sg13g2_and2_2$1_0.VSS.n549 3.39108
R3115 wind_comp_0.sg13g2_and2_2$1_0.VSS.n68 wind_comp_0.sg13g2_and2_2$1_0.VSS.n548 3.39129
R3116 wind_comp_0.sg13g2_and2_2$1_0.VSS.n68 wind_comp_0.sg13g2_and2_2$1_0.VSS.n546 3.3915
R3117 wind_comp_0.sg13g2_and2_2$1_0.VSS.n68 wind_comp_0.sg13g2_and2_2$1_0.VSS.n545 3.39172
R3118 wind_comp_0.sg13g2_and2_2$1_0.VSS.n68 wind_comp_0.sg13g2_and2_2$1_0.VSS.n542 3.39193
R3119 wind_comp_0.sg13g2_and2_2$1_0.VSS.n68 wind_comp_0.sg13g2_and2_2$1_0.VSS.n541 3.39215
R3120 wind_comp_0.sg13g2_and2_2$1_0.VSS.n68 wind_comp_0.sg13g2_and2_2$1_0.VSS.n540 3.39236
R3121 wind_comp_0.sg13g2_and2_2$1_0.VSS.n68 wind_comp_0.sg13g2_and2_2$1_0.VSS.n539 3.39258
R3122 wind_comp_0.sg13g2_and2_2$1_0.VSS.n201 wind_comp_0.sg13g2_and2_2$1_0.VSS.n538 3.40235
R3123 wind_comp_0.sg13g2_and2_2$1_0.VSS.n68 wind_comp_0.sg13g2_and2_2$1_0.VSS.n537 3.3928
R3124 wind_comp_0.sg13g2_and2_2$1_0.VSS.n68 wind_comp_0.sg13g2_and2_2$1_0.VSS.n535 3.39302
R3125 wind_comp_0.sg13g2_and2_2$1_0.VSS.n68 wind_comp_0.sg13g2_and2_2$1_0.VSS.n534 3.39324
R3126 wind_comp_0.sg13g2_and2_2$1_0.VSS.n68 wind_comp_0.sg13g2_and2_2$1_0.VSS.n533 3.39347
R3127 wind_comp_0.sg13g2_and2_2$1_0.VSS.n68 wind_comp_0.sg13g2_and2_2$1_0.VSS.n530 3.39369
R3128 wind_comp_0.sg13g2_and2_2$1_0.VSS.n68 wind_comp_0.sg13g2_and2_2$1_0.VSS.n571 8.5005
R3129 wind_comp_0.sg13g2_and2_2$1_0.VSS.n68 wind_comp_0.sg13g2_and2_2$1_0.VSS.n572 8.5005
R3130 wind_comp_0.sg13g2_and2_2$1_0.VSS.n68 wind_comp_0.sg13g2_and2_2$1_0.VSS.n573 8.5005
R3131 wind_comp_0.sg13g2_and2_2$1_0.VSS.n68 wind_comp_0.sg13g2_and2_2$1_0.VSS.n574 8.5005
R3132 wind_comp_0.sg13g2_and2_2$1_0.VSS.n68 wind_comp_0.sg13g2_and2_2$1_0.VSS.n575 8.5005
R3133 wind_comp_0.sg13g2_and2_2$1_0.VSS.n201 wind_comp_0.sg13g2_and2_2$1_0.VSS.n576 3.40006
R3134 wind_comp_0.sg13g2_and2_2$1_0.VSS.n68 wind_comp_0.sg13g2_and2_2$1_0.VSS.n577 8.5005
R3135 wind_comp_0.sg13g2_and2_2$1_0.VSS.n68 wind_comp_0.sg13g2_and2_2$1_0.VSS.n578 3.39938
R3136 wind_comp_0.sg13g2_and2_2$1_0.VSS.n68 wind_comp_0.sg13g2_and2_2$1_0.VSS.n579 8.5005
R3137 wind_comp_0.sg13g2_and2_2$1_0.VSS.n68 wind_comp_0.sg13g2_and2_2$1_0.VSS.n580 8.5005
R3138 wind_comp_0.sg13g2_and2_2$1_0.VSS.n68 wind_comp_0.sg13g2_and2_2$1_0.VSS.n581 8.5005
R3139 wind_comp_0.sg13g2_and2_2$1_0.VSS.n68 wind_comp_0.sg13g2_and2_2$1_0.VSS.n582 8.5005
R3140 wind_comp_0.sg13g2_and2_2$1_0.VSS.n68 wind_comp_0.sg13g2_and2_2$1_0.VSS.n583 8.5005
R3141 wind_comp_0.sg13g2_and2_2$1_0.VSS.n68 wind_comp_0.sg13g2_and2_2$1_0.VSS.n584 8.5005
R3142 wind_comp_0.sg13g2_and2_2$1_0.VSS.n68 wind_comp_0.sg13g2_and2_2$1_0.VSS.n585 8.5005
R3143 wind_comp_0.sg13g2_and2_2$1_0.VSS.n68 wind_comp_0.sg13g2_and2_2$1_0.VSS.n586 8.5005
R3144 wind_comp_0.sg13g2_and2_2$1_0.VSS.n68 wind_comp_0.sg13g2_and2_2$1_0.VSS.n587 8.5005
R3145 wind_comp_0.sg13g2_and2_2$1_0.VSS.n68 wind_comp_0.sg13g2_and2_2$1_0.VSS.n588 3.39842
R3146 wind_comp_0.sg13g2_and2_2$1_0.VSS.n68 wind_comp_0.sg13g2_and2_2$1_0.VSS.n589 8.5005
R3147 wind_comp_0.sg13g2_and2_2$1_0.VSS.n68 wind_comp_0.sg13g2_and2_2$1_0.VSS.n590 8.5005
R3148 wind_comp_0.sg13g2_and2_2$1_0.VSS.n68 wind_comp_0.sg13g2_and2_2$1_0.VSS.n591 3.39985
R3149 wind_comp_0.sg13g2_and2_2$1_0.VSS.n201 wind_comp_0.sg13g2_and2_2$1_0.VSS.n592 3.39922
R3150 wind_comp_0.sg13g2_and2_2$1_0.VSS.n68 wind_comp_0.sg13g2_and2_2$1_0.VSS.n593 8.5005
R3151 wind_comp_0.sg13g2_and2_2$1_0.VSS.n68 wind_comp_0.sg13g2_and2_2$1_0.VSS.n594 8.5005
R3152 wind_comp_0.sg13g2_and2_2$1_0.VSS.n68 wind_comp_0.sg13g2_and2_2$1_0.VSS.n595 8.5005
R3153 wind_comp_0.sg13g2_and2_2$1_0.VSS.n68 wind_comp_0.sg13g2_and2_2$1_0.VSS.n596 8.5005
R3154 wind_comp_0.sg13g2_and2_2$1_0.VSS.n68 wind_comp_0.sg13g2_and2_2$1_0.VSS.n597 8.5005
R3155 wind_comp_0.sg13g2_and2_2$1_0.VSS.n68 wind_comp_0.sg13g2_and2_2$1_0.VSS.n598 8.5005
R3156 wind_comp_0.sg13g2_and2_2$1_0.VSS.n68 wind_comp_0.sg13g2_and2_2$1_0.VSS.n599 8.5005
R3157 wind_comp_0.sg13g2_and2_2$1_0.VSS.n68 wind_comp_0.sg13g2_and2_2$1_0.VSS.n600 8.5005
R3158 wind_comp_0.sg13g2_and2_2$1_0.VSS.n68 wind_comp_0.sg13g2_and2_2$1_0.VSS.n601 8.5005
R3159 wind_comp_0.sg13g2_and2_2$1_0.VSS.n68 wind_comp_0.sg13g2_and2_2$1_0.VSS.n602 8.5005
R3160 wind_comp_0.sg13g2_and2_2$1_0.VSS.n68 wind_comp_0.sg13g2_and2_2$1_0.VSS.n603 8.5005
R3161 wind_comp_0.sg13g2_and2_2$1_0.VSS.n68 wind_comp_0.sg13g2_and2_2$1_0.VSS.n604 8.5005
R3162 wind_comp_0.sg13g2_and2_2$1_0.VSS.n68 wind_comp_0.sg13g2_and2_2$1_0.VSS.n605 8.5005
R3163 wind_comp_0.sg13g2_and2_2$1_0.VSS.n83 wind_comp_0.sg13g2_and2_2$1_0.VSS.n1590 8.5005
R3164 wind_comp_0.sg13g2_and2_2$1_0.VSS.n83 wind_comp_0.sg13g2_and2_2$1_0.VSS.n1591 8.5005
R3165 wind_comp_0.sg13g2_and2_2$1_0.VSS.n83 wind_comp_0.sg13g2_and2_2$1_0.VSS.n1592 8.5005
R3166 wind_comp_0.sg13g2_and2_2$1_0.VSS.n83 wind_comp_0.sg13g2_and2_2$1_0.VSS.n1596 8.5005
R3167 wind_comp_0.sg13g2_and2_2$1_0.VSS.n83 wind_comp_0.sg13g2_and2_2$1_0.VSS.n1597 8.5005
R3168 wind_comp_0.sg13g2_and2_2$1_0.VSS.n83 wind_comp_0.sg13g2_and2_2$1_0.VSS.n1609 8.5005
R3169 wind_comp_0.sg13g2_and2_2$1_0.VSS.n83 wind_comp_0.sg13g2_and2_2$1_0.VSS.n1608 8.5005
R3170 wind_comp_0.sg13g2_and2_2$1_0.VSS.n83 wind_comp_0.sg13g2_and2_2$1_0.VSS.n1607 8.5005
R3171 wind_comp_0.sg13g2_and2_2$1_0.VSS.n83 wind_comp_0.sg13g2_and2_2$1_0.VSS.n1606 8.5005
R3172 wind_comp_0.sg13g2_and2_2$1_0.VSS.n83 wind_comp_0.sg13g2_and2_2$1_0.VSS.n1600 8.5005
R3173 wind_comp_0.sg13g2_and2_2$1_0.VSS.n83 wind_comp_0.sg13g2_and2_2$1_0.VSS.n1603 8.5005
R3174 wind_comp_0.sg13g2_and2_2$1_0.VSS.n83 wind_comp_0.sg13g2_and2_2$1_0.VSS.n1601 8.5005
R3175 wind_comp_0.sg13g2_and2_2$1_0.VSS.n83 wind_comp_0.sg13g2_and2_2$1_0.VSS.n1602 8.5005
R3176 wind_comp_0.sg13g2_and2_2$1_0.VSS.n1304 wind_comp_0.sg13g2_and2_2$1_0.VSS.n70 5.66744
R3177 wind_comp_0.sg13g2_and2_2$1_0.VSS.n101 wind_comp_0.sg13g2_and2_2$1_0.VSS.n419 5.66687
R3178 wind_comp_0.sg13g2_and2_2$1_0.VSS.n101 wind_comp_0.sg13g2_and2_2$1_0.VSS.n406 5.66967
R3179 wind_comp_0.sg13g2_and2_2$1_0.VSS.n124 wind_comp_0.sg13g2_and2_2$1_0.VSS.t339 5.66868
R3180 wind_comp_0.sg13g2_and2_2$1_0.VSS.n124 wind_comp_0.sg13g2_and2_2$1_0.VSS.n1394 5.66727
R3181 wind_comp_0.sg13g2_and2_2$1_0.VSS.n124 wind_comp_0.sg13g2_and2_2$1_0.VSS.n1382 5.66632
R3182 wind_comp_0.sg13g2_and2_2$1_0.VSS.n124 wind_comp_0.sg13g2_and2_2$1_0.VSS.n1376 5.66677
R3183 wind_comp_0.sg13g2_and2_2$1_0.VSS.n124 wind_comp_0.sg13g2_and2_2$1_0.VSS.n1374 5.66659
R3184 wind_comp_0.sg13g2_and2_2$1_0.VSS.n124 wind_comp_0.sg13g2_and2_2$1_0.VSS.n1372 5.66722
R3185 wind_comp_0.sg13g2_and2_2$1_0.VSS.n124 wind_comp_0.sg13g2_and2_2$1_0.VSS.n1363 5.66588
R3186 wind_comp_0.sg13g2_and2_2$1_0.VSS.n128 wind_comp_0.sg13g2_and2_2$1_0.VSS.n920 8.5005
R3187 wind_comp_0.sg13g2_and2_2$1_0.VSS.n128 wind_comp_0.sg13g2_and2_2$1_0.VSS.n1060 8.5005
R3188 wind_comp_0.sg13g2_and2_2$1_0.VSS.n128 wind_comp_0.sg13g2_and2_2$1_0.VSS.n1061 8.5005
R3189 wind_comp_0.sg13g2_and2_2$1_0.VSS.n128 wind_comp_0.sg13g2_and2_2$1_0.VSS.n1062 8.5005
R3190 wind_comp_0.sg13g2_and2_2$1_0.VSS.n128 wind_comp_0.sg13g2_and2_2$1_0.VSS.n1063 8.5005
R3191 wind_comp_0.sg13g2_and2_2$1_0.VSS.n128 wind_comp_0.sg13g2_and2_2$1_0.VSS.n1064 8.5005
R3192 wind_comp_0.sg13g2_and2_2$1_0.VSS.n128 wind_comp_0.sg13g2_and2_2$1_0.VSS.n1065 8.5005
R3193 wind_comp_0.sg13g2_and2_2$1_0.VSS.n128 wind_comp_0.sg13g2_and2_2$1_0.VSS.n1066 8.5005
R3194 wind_comp_0.sg13g2_and2_2$1_0.VSS.n128 wind_comp_0.sg13g2_and2_2$1_0.VSS.n1067 8.5005
R3195 wind_comp_0.sg13g2_and2_2$1_0.VSS.n128 wind_comp_0.sg13g2_and2_2$1_0.VSS.n1068 8.5005
R3196 wind_comp_0.sg13g2_and2_2$1_0.VSS.n128 wind_comp_0.sg13g2_and2_2$1_0.VSS.n1069 8.5005
R3197 wind_comp_0.sg13g2_and2_2$1_0.VSS.n128 wind_comp_0.sg13g2_and2_2$1_0.VSS.n1071 8.5005
R3198 wind_comp_0.sg13g2_and2_2$1_0.VSS.n128 wind_comp_0.sg13g2_and2_2$1_0.VSS.n1072 8.5005
R3199 wind_comp_0.sg13g2_and2_2$1_0.VSS.n128 wind_comp_0.sg13g2_and2_2$1_0.VSS.n1075 8.5005
R3200 wind_comp_0.sg13g2_and2_2$1_0.VSS.n128 wind_comp_0.sg13g2_and2_2$1_0.VSS.n1076 8.5005
R3201 wind_comp_0.sg13g2_and2_2$1_0.VSS.n128 wind_comp_0.sg13g2_and2_2$1_0.VSS.n1079 8.5005
R3202 wind_comp_0.sg13g2_and2_2$1_0.VSS.n128 wind_comp_0.sg13g2_and2_2$1_0.VSS.n1080 8.5005
R3203 wind_comp_0.sg13g2_and2_2$1_0.VSS.n128 wind_comp_0.sg13g2_and2_2$1_0.VSS.n1083 8.5005
R3204 wind_comp_0.sg13g2_and2_2$1_0.VSS.n128 wind_comp_0.sg13g2_and2_2$1_0.VSS.n1084 8.5005
R3205 wind_comp_0.sg13g2_and2_2$1_0.VSS.n128 wind_comp_0.sg13g2_and2_2$1_0.VSS.n1087 8.5005
R3206 wind_comp_0.sg13g2_and2_2$1_0.VSS.n128 wind_comp_0.sg13g2_and2_2$1_0.VSS.n1088 8.5005
R3207 wind_comp_0.sg13g2_and2_2$1_0.VSS.n128 wind_comp_0.sg13g2_and2_2$1_0.VSS.n1092 8.5005
R3208 wind_comp_0.sg13g2_and2_2$1_0.VSS.n128 wind_comp_0.sg13g2_and2_2$1_0.VSS.n1095 8.5005
R3209 wind_comp_0.sg13g2_and2_2$1_0.VSS.n128 wind_comp_0.sg13g2_and2_2$1_0.VSS.n1096 8.5005
R3210 wind_comp_0.sg13g2_and2_2$1_0.VSS.n128 wind_comp_0.sg13g2_and2_2$1_0.VSS.n1099 8.5005
R3211 wind_comp_0.sg13g2_and2_2$1_0.VSS.n128 wind_comp_0.sg13g2_and2_2$1_0.VSS.n1100 8.5005
R3212 wind_comp_0.sg13g2_and2_2$1_0.VSS.n128 wind_comp_0.sg13g2_and2_2$1_0.VSS.n1103 8.5005
R3213 wind_comp_0.sg13g2_and2_2$1_0.VSS.n128 wind_comp_0.sg13g2_and2_2$1_0.VSS.n1104 8.5005
R3214 wind_comp_0.sg13g2_and2_2$1_0.VSS.n128 wind_comp_0.sg13g2_and2_2$1_0.VSS.n1107 8.5005
R3215 wind_comp_0.sg13g2_and2_2$1_0.VSS.n128 wind_comp_0.sg13g2_and2_2$1_0.VSS.n1108 8.5005
R3216 wind_comp_0.sg13g2_and2_2$1_0.VSS.n128 wind_comp_0.sg13g2_and2_2$1_0.VSS.n1111 8.5005
R3217 wind_comp_0.sg13g2_and2_2$1_0.VSS.n128 wind_comp_0.sg13g2_and2_2$1_0.VSS.n1112 8.5005
R3218 wind_comp_0.sg13g2_and2_2$1_0.VSS.n128 wind_comp_0.sg13g2_and2_2$1_0.VSS.n1115 8.5005
R3219 wind_comp_0.sg13g2_and2_2$1_0.VSS.n128 wind_comp_0.sg13g2_and2_2$1_0.VSS.n1116 8.5005
R3220 wind_comp_0.sg13g2_and2_2$1_0.VSS.n128 wind_comp_0.sg13g2_and2_2$1_0.VSS.n1119 8.5005
R3221 wind_comp_0.sg13g2_and2_2$1_0.VSS.n128 wind_comp_0.sg13g2_and2_2$1_0.VSS.n1120 8.5005
R3222 wind_comp_0.sg13g2_and2_2$1_0.VSS.n128 wind_comp_0.sg13g2_and2_2$1_0.VSS.n1123 8.5005
R3223 wind_comp_0.sg13g2_and2_2$1_0.VSS.n128 wind_comp_0.sg13g2_and2_2$1_0.VSS.n1124 8.5005
R3224 wind_comp_0.sg13g2_and2_2$1_0.VSS.n128 wind_comp_0.sg13g2_and2_2$1_0.VSS.n1127 8.5005
R3225 wind_comp_0.sg13g2_and2_2$1_0.VSS.n128 wind_comp_0.sg13g2_and2_2$1_0.VSS.n1128 8.5005
R3226 wind_comp_0.sg13g2_and2_2$1_0.VSS.n128 wind_comp_0.sg13g2_and2_2$1_0.VSS.n1131 8.5005
R3227 wind_comp_0.sg13g2_and2_2$1_0.VSS.n128 wind_comp_0.sg13g2_and2_2$1_0.VSS.n1132 8.5005
R3228 wind_comp_0.sg13g2_and2_2$1_0.VSS.n128 wind_comp_0.sg13g2_and2_2$1_0.VSS.n1135 8.5005
R3229 wind_comp_0.sg13g2_and2_2$1_0.VSS.n128 wind_comp_0.sg13g2_and2_2$1_0.VSS.n1136 8.5005
R3230 wind_comp_0.sg13g2_and2_2$1_0.VSS.n128 wind_comp_0.sg13g2_and2_2$1_0.VSS.n1140 8.5005
R3231 wind_comp_0.sg13g2_and2_2$1_0.VSS.n128 wind_comp_0.sg13g2_and2_2$1_0.VSS.n1143 8.5005
R3232 wind_comp_0.sg13g2_and2_2$1_0.VSS.n128 wind_comp_0.sg13g2_and2_2$1_0.VSS.n1144 8.5005
R3233 wind_comp_0.sg13g2_and2_2$1_0.VSS.n128 wind_comp_0.sg13g2_and2_2$1_0.VSS.n1147 8.5005
R3234 wind_comp_0.sg13g2_and2_2$1_0.VSS.n128 wind_comp_0.sg13g2_and2_2$1_0.VSS.n1148 8.5005
R3235 wind_comp_0.sg13g2_and2_2$1_0.VSS.n128 wind_comp_0.sg13g2_and2_2$1_0.VSS.n1151 8.5005
R3236 wind_comp_0.sg13g2_and2_2$1_0.VSS.n128 wind_comp_0.sg13g2_and2_2$1_0.VSS.n1152 8.5005
R3237 wind_comp_0.sg13g2_and2_2$1_0.VSS.n128 wind_comp_0.sg13g2_and2_2$1_0.VSS.n1155 8.5005
R3238 wind_comp_0.sg13g2_and2_2$1_0.VSS.n128 wind_comp_0.sg13g2_and2_2$1_0.VSS.n1156 8.5005
R3239 wind_comp_0.sg13g2_and2_2$1_0.VSS.n128 wind_comp_0.sg13g2_and2_2$1_0.VSS.n1159 8.5005
R3240 wind_comp_0.sg13g2_and2_2$1_0.VSS.n128 wind_comp_0.sg13g2_and2_2$1_0.VSS.n1160 8.5005
R3241 wind_comp_0.sg13g2_and2_2$1_0.VSS.n128 wind_comp_0.sg13g2_and2_2$1_0.VSS.n1163 8.5005
R3242 wind_comp_0.sg13g2_and2_2$1_0.VSS.n128 wind_comp_0.sg13g2_and2_2$1_0.VSS.n1164 8.5005
R3243 wind_comp_0.sg13g2_and2_2$1_0.VSS.n128 wind_comp_0.sg13g2_and2_2$1_0.VSS.n1167 8.5005
R3244 wind_comp_0.sg13g2_and2_2$1_0.VSS.n128 wind_comp_0.sg13g2_and2_2$1_0.VSS.n1168 8.5005
R3245 wind_comp_0.sg13g2_and2_2$1_0.VSS.n128 wind_comp_0.sg13g2_and2_2$1_0.VSS.n1171 8.5005
R3246 wind_comp_0.sg13g2_and2_2$1_0.VSS.n128 wind_comp_0.sg13g2_and2_2$1_0.VSS.n1172 8.5005
R3247 wind_comp_0.sg13g2_and2_2$1_0.VSS.n128 wind_comp_0.sg13g2_and2_2$1_0.VSS.n1175 8.5005
R3248 wind_comp_0.sg13g2_and2_2$1_0.VSS.n128 wind_comp_0.sg13g2_and2_2$1_0.VSS.n1176 8.5005
R3249 wind_comp_0.sg13g2_and2_2$1_0.VSS.n128 wind_comp_0.sg13g2_and2_2$1_0.VSS.n1179 8.5005
R3250 wind_comp_0.sg13g2_and2_2$1_0.VSS.n128 wind_comp_0.sg13g2_and2_2$1_0.VSS.n1180 8.5005
R3251 wind_comp_0.sg13g2_and2_2$1_0.VSS.n128 wind_comp_0.sg13g2_and2_2$1_0.VSS.n1183 8.5005
R3252 wind_comp_0.sg13g2_and2_2$1_0.VSS.n128 wind_comp_0.sg13g2_and2_2$1_0.VSS.n1184 8.5005
R3253 wind_comp_0.sg13g2_and2_2$1_0.VSS.n128 wind_comp_0.sg13g2_and2_2$1_0.VSS.n1187 8.5005
R3254 wind_comp_0.sg13g2_and2_2$1_0.VSS.n128 wind_comp_0.sg13g2_and2_2$1_0.VSS.n1188 8.5005
R3255 wind_comp_0.sg13g2_and2_2$1_0.VSS.n128 wind_comp_0.sg13g2_and2_2$1_0.VSS.n1191 8.5005
R3256 wind_comp_0.sg13g2_and2_2$1_0.VSS.n128 wind_comp_0.sg13g2_and2_2$1_0.VSS.n1192 8.5005
R3257 wind_comp_0.sg13g2_and2_2$1_0.VSS.n128 wind_comp_0.sg13g2_and2_2$1_0.VSS.n1195 8.5005
R3258 wind_comp_0.sg13g2_and2_2$1_0.VSS.n128 wind_comp_0.sg13g2_and2_2$1_0.VSS.n1196 8.5005
R3259 wind_comp_0.sg13g2_and2_2$1_0.VSS.n2380 wind_comp_0.sg13g2_and2_2$1_0.VSS.n128 8.5005
R3260 wind_comp_0.sg13g2_and2_2$1_0.VSS.n128 wind_comp_0.sg13g2_and2_2$1_0.VSS.n804 8.5005
R3261 wind_comp_0.sg13g2_and2_2$1_0.VSS.n128 wind_comp_0.sg13g2_and2_2$1_0.VSS.n805 8.5005
R3262 wind_comp_0.sg13g2_and2_2$1_0.VSS.n128 wind_comp_0.sg13g2_and2_2$1_0.VSS.n806 8.5005
R3263 wind_comp_0.sg13g2_and2_2$1_0.VSS.n128 wind_comp_0.sg13g2_and2_2$1_0.VSS.n807 8.5005
R3264 wind_comp_0.sg13g2_and2_2$1_0.VSS.n128 wind_comp_0.sg13g2_and2_2$1_0.VSS.n808 8.5005
R3265 wind_comp_0.sg13g2_and2_2$1_0.VSS.n128 wind_comp_0.sg13g2_and2_2$1_0.VSS.n809 8.5005
R3266 wind_comp_0.sg13g2_and2_2$1_0.VSS.n128 wind_comp_0.sg13g2_and2_2$1_0.VSS.n810 8.5005
R3267 wind_comp_0.sg13g2_and2_2$1_0.VSS.n128 wind_comp_0.sg13g2_and2_2$1_0.VSS.n811 8.5005
R3268 wind_comp_0.sg13g2_and2_2$1_0.VSS.n128 wind_comp_0.sg13g2_and2_2$1_0.VSS.n812 8.5005
R3269 wind_comp_0.sg13g2_and2_2$1_0.VSS.n128 wind_comp_0.sg13g2_and2_2$1_0.VSS.n813 8.5005
R3270 wind_comp_0.sg13g2_and2_2$1_0.VSS.n128 wind_comp_0.sg13g2_and2_2$1_0.VSS.n814 8.5005
R3271 wind_comp_0.sg13g2_and2_2$1_0.VSS.n128 wind_comp_0.sg13g2_and2_2$1_0.VSS.n815 8.5005
R3272 wind_comp_0.sg13g2_and2_2$1_0.VSS.n128 wind_comp_0.sg13g2_and2_2$1_0.VSS.n816 8.5005
R3273 wind_comp_0.sg13g2_and2_2$1_0.VSS.n128 wind_comp_0.sg13g2_and2_2$1_0.VSS.n817 8.5005
R3274 wind_comp_0.sg13g2_and2_2$1_0.VSS.n128 wind_comp_0.sg13g2_and2_2$1_0.VSS.n818 8.5005
R3275 wind_comp_0.sg13g2_and2_2$1_0.VSS.n128 wind_comp_0.sg13g2_and2_2$1_0.VSS.n819 8.5005
R3276 wind_comp_0.sg13g2_and2_2$1_0.VSS.n128 wind_comp_0.sg13g2_and2_2$1_0.VSS.n820 8.5005
R3277 wind_comp_0.sg13g2_and2_2$1_0.VSS.n128 wind_comp_0.sg13g2_and2_2$1_0.VSS.n821 8.5005
R3278 wind_comp_0.sg13g2_and2_2$1_0.VSS.n128 wind_comp_0.sg13g2_and2_2$1_0.VSS.n822 8.5005
R3279 wind_comp_0.sg13g2_and2_2$1_0.VSS.n128 wind_comp_0.sg13g2_and2_2$1_0.VSS.n823 8.5005
R3280 wind_comp_0.sg13g2_and2_2$1_0.VSS.n128 wind_comp_0.sg13g2_and2_2$1_0.VSS.n824 8.5005
R3281 wind_comp_0.sg13g2_and2_2$1_0.VSS.n128 wind_comp_0.sg13g2_and2_2$1_0.VSS.n825 8.5005
R3282 wind_comp_0.sg13g2_and2_2$1_0.VSS.n128 wind_comp_0.sg13g2_and2_2$1_0.VSS.n826 8.5005
R3283 wind_comp_0.sg13g2_and2_2$1_0.VSS.n128 wind_comp_0.sg13g2_and2_2$1_0.VSS.n827 8.5005
R3284 wind_comp_0.sg13g2_and2_2$1_0.VSS.n128 wind_comp_0.sg13g2_and2_2$1_0.VSS.n828 8.5005
R3285 wind_comp_0.sg13g2_and2_2$1_0.VSS.n128 wind_comp_0.sg13g2_and2_2$1_0.VSS.n829 8.5005
R3286 wind_comp_0.sg13g2_and2_2$1_0.VSS.n128 wind_comp_0.sg13g2_and2_2$1_0.VSS.n830 8.5005
R3287 wind_comp_0.sg13g2_and2_2$1_0.VSS.n128 wind_comp_0.sg13g2_and2_2$1_0.VSS.n831 8.5005
R3288 wind_comp_0.sg13g2_and2_2$1_0.VSS.n128 wind_comp_0.sg13g2_and2_2$1_0.VSS.n832 8.5005
R3289 wind_comp_0.sg13g2_and2_2$1_0.VSS.n128 wind_comp_0.sg13g2_and2_2$1_0.VSS.n833 8.5005
R3290 wind_comp_0.sg13g2_and2_2$1_0.VSS.n128 wind_comp_0.sg13g2_and2_2$1_0.VSS.n834 8.5005
R3291 wind_comp_0.sg13g2_and2_2$1_0.VSS.n128 wind_comp_0.sg13g2_and2_2$1_0.VSS.n835 8.5005
R3292 wind_comp_0.sg13g2_and2_2$1_0.VSS.n128 wind_comp_0.sg13g2_and2_2$1_0.VSS.n836 8.5005
R3293 wind_comp_0.sg13g2_and2_2$1_0.VSS.n128 wind_comp_0.sg13g2_and2_2$1_0.VSS.n837 8.5005
R3294 wind_comp_0.sg13g2_and2_2$1_0.VSS.n128 wind_comp_0.sg13g2_and2_2$1_0.VSS.n839 8.5005
R3295 wind_comp_0.sg13g2_and2_2$1_0.VSS.n128 wind_comp_0.sg13g2_and2_2$1_0.VSS.n840 8.5005
R3296 wind_comp_0.sg13g2_and2_2$1_0.VSS.n128 wind_comp_0.sg13g2_and2_2$1_0.VSS.n841 8.5005
R3297 wind_comp_0.sg13g2_and2_2$1_0.VSS.n128 wind_comp_0.sg13g2_and2_2$1_0.VSS.n842 8.5005
R3298 wind_comp_0.sg13g2_and2_2$1_0.VSS.n128 wind_comp_0.sg13g2_and2_2$1_0.VSS.n843 8.5005
R3299 wind_comp_0.sg13g2_and2_2$1_0.VSS.n128 wind_comp_0.sg13g2_and2_2$1_0.VSS.n844 8.5005
R3300 wind_comp_0.sg13g2_and2_2$1_0.VSS.n128 wind_comp_0.sg13g2_and2_2$1_0.VSS.n162 4.2494
R3301 wind_comp_0.sg13g2_and2_2$1_0.VSS.n128 wind_comp_0.sg13g2_and2_2$1_0.VSS.n845 8.5005
R3302 wind_comp_0.sg13g2_and2_2$1_0.VSS.n128 wind_comp_0.sg13g2_and2_2$1_0.VSS.n846 8.5005
R3303 wind_comp_0.sg13g2_and2_2$1_0.VSS.n128 wind_comp_0.sg13g2_and2_2$1_0.VSS.n847 8.5005
R3304 wind_comp_0.sg13g2_and2_2$1_0.VSS.n128 wind_comp_0.sg13g2_and2_2$1_0.VSS.n848 8.5005
R3305 wind_comp_0.sg13g2_and2_2$1_0.VSS.n128 wind_comp_0.sg13g2_and2_2$1_0.VSS.n849 8.5005
R3306 wind_comp_0.sg13g2_and2_2$1_0.VSS.n128 wind_comp_0.sg13g2_and2_2$1_0.VSS.n850 8.5005
R3307 wind_comp_0.sg13g2_and2_2$1_0.VSS.n128 wind_comp_0.sg13g2_and2_2$1_0.VSS.n851 8.5005
R3308 wind_comp_0.sg13g2_and2_2$1_0.VSS.n128 wind_comp_0.sg13g2_and2_2$1_0.VSS.n852 8.5005
R3309 wind_comp_0.sg13g2_and2_2$1_0.VSS.n128 wind_comp_0.sg13g2_and2_2$1_0.VSS.n853 8.5005
R3310 wind_comp_0.sg13g2_and2_2$1_0.VSS.n128 wind_comp_0.sg13g2_and2_2$1_0.VSS.n854 8.5005
R3311 wind_comp_0.sg13g2_and2_2$1_0.VSS.n128 wind_comp_0.sg13g2_and2_2$1_0.VSS.n855 8.5005
R3312 wind_comp_0.sg13g2_and2_2$1_0.VSS.n128 wind_comp_0.sg13g2_and2_2$1_0.VSS.n856 8.5005
R3313 wind_comp_0.sg13g2_and2_2$1_0.VSS.n128 wind_comp_0.sg13g2_and2_2$1_0.VSS.n857 8.5005
R3314 wind_comp_0.sg13g2_and2_2$1_0.VSS.n128 wind_comp_0.sg13g2_and2_2$1_0.VSS.n858 8.5005
R3315 wind_comp_0.sg13g2_and2_2$1_0.VSS.n128 wind_comp_0.sg13g2_and2_2$1_0.VSS.n860 8.5005
R3316 wind_comp_0.sg13g2_and2_2$1_0.VSS.n128 wind_comp_0.sg13g2_and2_2$1_0.VSS.n861 8.5005
R3317 wind_comp_0.sg13g2_and2_2$1_0.VSS.n128 wind_comp_0.sg13g2_and2_2$1_0.VSS.n862 8.5005
R3318 wind_comp_0.sg13g2_and2_2$1_0.VSS.n128 wind_comp_0.sg13g2_and2_2$1_0.VSS.n21 1.04544
R3319 wind_comp_0.sg13g2_and2_2$1_0.VSS.n22 wind_comp_0.sg13g2_and2_2$1_0.VSS.n24 0.0551955
R3320 wind_comp_0.sg13g2_and2_2$1_0.VSS.n24 wind_comp_0.sg13g2_and2_2$1_0.VSS.n25 0.0214229
R3321 wind_comp_0.sg13g2_and2_2$1_0.VSS.n25 wind_comp_0.sg13g2_and2_2$1_0.VSS.n26 0.0783489
R3322 wind_comp_0.sg13g2_and2_2$1_0.VSS.n128 wind_comp_0.sg13g2_and2_2$1_0.VSS.n32 0.554487
R3323 wind_comp_0.sg13g2_and2_2$1_0.VSS.n32 wind_comp_0.sg13g2_and2_2$1_0.VSS.n49 0.074814
R3324 wind_comp_0.sg13g2_and2_2$1_0.VSS.n128 wind_comp_0.sg13g2_and2_2$1_0.VSS.n48 1.20966
R3325 wind_comp_0.sg13g2_and2_2$1_0.VSS.n48 wind_comp_0.sg13g2_and2_2$1_0.VSS.n135 0.0117934
R3326 wind_comp_0.sg13g2_and2_2$1_0.VSS.n128 wind_comp_0.sg13g2_and2_2$1_0.VSS.n1058 8.5005
R3327 wind_comp_0.sg13g2_and2_2$1_0.VSS.n128 wind_comp_0.sg13g2_and2_2$1_0.VSS.n526 8.5005
R3328 wind_comp_0.sg13g2_and2_2$1_0.VSS.n290 wind_comp_0.sg13g2_and2_2$1_0.VSS.n128 4.24916
R3329 wind_comp_0.sg13g2_and2_2$1_0.VSS.n128 wind_comp_0.sg13g2_and2_2$1_0.VSS.n44 0.936899
R3330 wind_comp_0.sg13g2_and2_2$1_0.VSS.n44 wind_comp_0.sg13g2_and2_2$1_0.VSS.n46 0.00579921
R3331 wind_comp_0.sg13g2_and2_2$1_0.VSS.n46 wind_comp_0.sg13g2_and2_2$1_0.VSS.n666 0.0184064
R3332 wind_comp_0.sg13g2_and2_2$1_0.VSS.n128 wind_comp_0.sg13g2_and2_2$1_0.VSS.n962 8.5005
R3333 wind_comp_0.sg13g2_and2_2$1_0.VSS.n128 wind_comp_0.sg13g2_and2_2$1_0.VSS.n959 8.5005
R3334 wind_comp_0.sg13g2_and2_2$1_0.VSS.n128 wind_comp_0.sg13g2_and2_2$1_0.VSS.n958 8.5005
R3335 wind_comp_0.sg13g2_and2_2$1_0.VSS.n128 wind_comp_0.sg13g2_and2_2$1_0.VSS.n614 8.5005
R3336 wind_comp_0.sg13g2_and2_2$1_0.VSS.n128 wind_comp_0.sg13g2_and2_2$1_0.VSS.n955 8.5005
R3337 wind_comp_0.sg13g2_and2_2$1_0.VSS.n128 wind_comp_0.sg13g2_and2_2$1_0.VSS.n952 8.5005
R3338 wind_comp_0.sg13g2_and2_2$1_0.VSS.n128 wind_comp_0.sg13g2_and2_2$1_0.VSS.n662 4.24863
R3339 wind_comp_0.sg13g2_and2_2$1_0.VSS.n128 wind_comp_0.sg13g2_and2_2$1_0.VSS.n950 8.5005
R3340 wind_comp_0.sg13g2_and2_2$1_0.VSS.n128 wind_comp_0.sg13g2_and2_2$1_0.VSS.n947 8.5005
R3341 wind_comp_0.sg13g2_and2_2$1_0.VSS.n128 wind_comp_0.sg13g2_and2_2$1_0.VSS.n90 1.69835
R3342 wind_comp_0.sg13g2_and2_2$1_0.VSS.n128 wind_comp_0.sg13g2_and2_2$1_0.VSS.n940 8.5005
R3343 wind_comp_0.sg13g2_and2_2$1_0.VSS.n128 wind_comp_0.sg13g2_and2_2$1_0.VSS.n287 4.24902
R3344 wind_comp_0.sg13g2_and2_2$1_0.VSS.n128 wind_comp_0.sg13g2_and2_2$1_0.VSS.n937 8.5005
R3345 wind_comp_0.sg13g2_and2_2$1_0.VSS.n128 wind_comp_0.sg13g2_and2_2$1_0.VSS.n934 8.5005
R3346 wind_comp_0.sg13g2_and2_2$1_0.VSS.n128 wind_comp_0.sg13g2_and2_2$1_0.VSS.n612 8.5005
R3347 wind_comp_0.sg13g2_and2_2$1_0.VSS.n128 wind_comp_0.sg13g2_and2_2$1_0.VSS.n933 8.5005
R3348 wind_comp_0.sg13g2_and2_2$1_0.VSS.n128 wind_comp_0.sg13g2_and2_2$1_0.VSS.n932 8.5005
R3349 wind_comp_0.sg13g2_and2_2$1_0.VSS.n128 wind_comp_0.sg13g2_and2_2$1_0.VSS.n660 8.5005
R3350 wind_comp_0.sg13g2_and2_2$1_0.VSS.n128 wind_comp_0.sg13g2_and2_2$1_0.VSS.n931 8.5005
R3351 wind_comp_0.sg13g2_and2_2$1_0.VSS.n128 wind_comp_0.sg13g2_and2_2$1_0.VSS.n930 8.5005
R3352 wind_comp_0.sg13g2_and2_2$1_0.VSS.n128 wind_comp_0.sg13g2_and2_2$1_0.VSS.n928 8.5005
R3353 wind_comp_0.sg13g2_and2_2$1_0.VSS.n128 wind_comp_0.sg13g2_and2_2$1_0.VSS.n926 8.5005
R3354 wind_comp_0.sg13g2_and2_2$1_0.VSS.n128 wind_comp_0.sg13g2_and2_2$1_0.VSS.n925 8.5005
R3355 wind_comp_0.sg13g2_and2_2$1_0.VSS.n128 wind_comp_0.sg13g2_and2_2$1_0.VSS.n924 8.5005
R3356 wind_comp_0.sg13g2_and2_2$1_0.VSS.n128 wind_comp_0.sg13g2_and2_2$1_0.VSS.n923 8.5005
R3357 wind_comp_0.sg13g2_and2_2$1_0.VSS.n68 wind_comp_0.sg13g2_and2_2$1_0.VSS.n531 3.3989
R3358 wind_comp_0.sg13g2_and2_2$1_0.VSS.n98 wind_comp_0.sg13g2_and2_2$1_0.VSS.n532 2.81071
R3359 wind_comp_0.sg13g2_and2_2$1_0.VSS.n128 wind_comp_0.sg13g2_and2_2$1_0.VSS.n970 8.5005
R3360 wind_comp_0.sg13g2_and2_2$1_0.VSS.n128 wind_comp_0.sg13g2_and2_2$1_0.VSS.n969 8.5005
R3361 wind_comp_0.sg13g2_and2_2$1_0.VSS.n128 wind_comp_0.sg13g2_and2_2$1_0.VSS.n968 8.5005
R3362 wind_comp_0.sg13g2_and2_2$1_0.VSS.n128 wind_comp_0.sg13g2_and2_2$1_0.VSS.n967 8.5005
R3363 wind_comp_0.sg13g2_and2_2$1_0.VSS.n128 wind_comp_0.sg13g2_and2_2$1_0.VSS.n966 8.5005
R3364 wind_comp_0.sg13g2_and2_2$1_0.VSS.n128 wind_comp_0.sg13g2_and2_2$1_0.VSS.n965 8.5005
R3365 wind_comp_0.sg13g2_and2_2$1_0.VSS.n128 wind_comp_0.sg13g2_and2_2$1_0.VSS.n964 8.5005
R3366 wind_comp_0.sg13g2_and2_2$1_0.VSS.n128 wind_comp_0.sg13g2_and2_2$1_0.VSS.n963 8.5005
R3367 wind_comp_0.sg13g2_and2_2$1_0.VSS.n128 wind_comp_0.sg13g2_and2_2$1_0.VSS.n961 8.5005
R3368 wind_comp_0.sg13g2_and2_2$1_0.VSS.n128 wind_comp_0.sg13g2_and2_2$1_0.VSS.n960 8.5005
R3369 wind_comp_0.sg13g2_and2_2$1_0.VSS.n128 wind_comp_0.sg13g2_and2_2$1_0.VSS.n957 8.5005
R3370 wind_comp_0.sg13g2_and2_2$1_0.VSS.n128 wind_comp_0.sg13g2_and2_2$1_0.VSS.n956 8.5005
R3371 wind_comp_0.sg13g2_and2_2$1_0.VSS.n128 wind_comp_0.sg13g2_and2_2$1_0.VSS.n954 8.5005
R3372 wind_comp_0.sg13g2_and2_2$1_0.VSS.n128 wind_comp_0.sg13g2_and2_2$1_0.VSS.n953 8.5005
R3373 wind_comp_0.sg13g2_and2_2$1_0.VSS.n128 wind_comp_0.sg13g2_and2_2$1_0.VSS.n949 8.5005
R3374 wind_comp_0.sg13g2_and2_2$1_0.VSS.n128 wind_comp_0.sg13g2_and2_2$1_0.VSS.n948 8.5005
R3375 wind_comp_0.sg13g2_and2_2$1_0.VSS.n128 wind_comp_0.sg13g2_and2_2$1_0.VSS.n946 8.5005
R3376 wind_comp_0.sg13g2_and2_2$1_0.VSS.n128 wind_comp_0.sg13g2_and2_2$1_0.VSS.n945 8.5005
R3377 wind_comp_0.sg13g2_and2_2$1_0.VSS.n128 wind_comp_0.sg13g2_and2_2$1_0.VSS.n944 8.5005
R3378 wind_comp_0.sg13g2_and2_2$1_0.VSS.n128 wind_comp_0.sg13g2_and2_2$1_0.VSS.n943 8.5005
R3379 wind_comp_0.sg13g2_and2_2$1_0.VSS.n128 wind_comp_0.sg13g2_and2_2$1_0.VSS.n942 8.5005
R3380 wind_comp_0.sg13g2_and2_2$1_0.VSS.n128 wind_comp_0.sg13g2_and2_2$1_0.VSS.n941 8.5005
R3381 wind_comp_0.sg13g2_and2_2$1_0.VSS.n128 wind_comp_0.sg13g2_and2_2$1_0.VSS.n939 8.5005
R3382 wind_comp_0.sg13g2_and2_2$1_0.VSS.n128 wind_comp_0.sg13g2_and2_2$1_0.VSS.n938 8.5005
R3383 wind_comp_0.sg13g2_and2_2$1_0.VSS.n128 wind_comp_0.sg13g2_and2_2$1_0.VSS.n936 8.5005
R3384 wind_comp_0.sg13g2_and2_2$1_0.VSS.n128 wind_comp_0.sg13g2_and2_2$1_0.VSS.n935 8.5005
R3385 wind_comp_0.sg13g2_and2_2$1_0.VSS.n128 wind_comp_0.sg13g2_and2_2$1_0.VSS.n80 1.48293
R3386 wind_comp_0.sg13g2_and2_2$1_0.VSS.n128 wind_comp_0.sg13g2_and2_2$1_0.VSS.n922 8.5005
R3387 wind_comp_0.sg13g2_and2_2$1_0.VSS.n128 wind_comp_0.sg13g2_and2_2$1_0.VSS.n921 8.5005
R3388 wind_comp_0.sg13g2_and2_2$1_0.VSS.n121 wind_comp_0.sg13g2_and2_2$1_0.VSS.n757 8.5005
R3389 wind_comp_0.sg13g2_and2_2$1_0.VSS.n121 wind_comp_0.sg13g2_and2_2$1_0.VSS.n803 8.5005
R3390 wind_comp_0.sg13g2_and2_2$1_0.VSS.n121 wind_comp_0.sg13g2_and2_2$1_0.VSS.n802 8.5005
R3391 wind_comp_0.sg13g2_and2_2$1_0.VSS.n121 wind_comp_0.sg13g2_and2_2$1_0.VSS.n801 8.5005
R3392 wind_comp_0.sg13g2_and2_2$1_0.VSS.n121 wind_comp_0.sg13g2_and2_2$1_0.VSS.n800 8.5005
R3393 wind_comp_0.sg13g2_and2_2$1_0.VSS.n121 wind_comp_0.sg13g2_and2_2$1_0.VSS.n799 8.5005
R3394 wind_comp_0.sg13g2_and2_2$1_0.VSS.n121 wind_comp_0.sg13g2_and2_2$1_0.VSS.n798 8.5005
R3395 wind_comp_0.sg13g2_and2_2$1_0.VSS.n66 wind_comp_0.sg13g2_and2_2$1_0.VSS.n1999 0.0606634
R3396 wind_comp_0.sg13g2_and2_2$1_0.VSS.n121 wind_comp_0.sg13g2_and2_2$1_0.VSS.n66 0.596218
R3397 wind_comp_0.sg13g2_and2_2$1_0.VSS.n34 wind_comp_0.sg13g2_and2_2$1_0.VSS.n40 0.0506774
R3398 wind_comp_0.sg13g2_and2_2$1_0.VSS.n35 wind_comp_0.sg13g2_and2_2$1_0.VSS.n34 0.0501793
R3399 wind_comp_0.sg13g2_and2_2$1_0.VSS.n121 wind_comp_0.sg13g2_and2_2$1_0.VSS.n797 8.5005
R3400 wind_comp_0.sg13g2_and2_2$1_0.VSS.n121 wind_comp_0.sg13g2_and2_2$1_0.VSS.n796 8.5005
R3401 wind_comp_0.sg13g2_and2_2$1_0.VSS.n121 wind_comp_0.sg13g2_and2_2$1_0.VSS.n795 8.5005
R3402 wind_comp_0.sg13g2_and2_2$1_0.VSS.n121 wind_comp_0.sg13g2_and2_2$1_0.VSS.n794 8.5005
R3403 wind_comp_0.sg13g2_and2_2$1_0.VSS.n121 wind_comp_0.sg13g2_and2_2$1_0.VSS.n793 8.5005
R3404 wind_comp_0.sg13g2_and2_2$1_0.VSS.n121 wind_comp_0.sg13g2_and2_2$1_0.VSS.n792 8.5005
R3405 wind_comp_0.sg13g2_and2_2$1_0.VSS.n121 wind_comp_0.sg13g2_and2_2$1_0.VSS.n167 4.24945
R3406 wind_comp_0.sg13g2_and2_2$1_0.VSS.n121 wind_comp_0.sg13g2_and2_2$1_0.VSS.n791 8.5005
R3407 wind_comp_0.sg13g2_and2_2$1_0.VSS.n121 wind_comp_0.sg13g2_and2_2$1_0.VSS.n790 8.5005
R3408 wind_comp_0.sg13g2_and2_2$1_0.VSS.n121 wind_comp_0.sg13g2_and2_2$1_0.VSS.n6 0.4298
R3409 wind_comp_0.sg13g2_and2_2$1_0.VSS.n121 wind_comp_0.sg13g2_and2_2$1_0.VSS.n773 8.5005
R3410 wind_comp_0.sg13g2_and2_2$1_0.VSS.n121 wind_comp_0.sg13g2_and2_2$1_0.VSS.n772 8.5005
R3411 wind_comp_0.sg13g2_and2_2$1_0.VSS.n121 wind_comp_0.sg13g2_and2_2$1_0.VSS.n771 8.5005
R3412 wind_comp_0.sg13g2_and2_2$1_0.VSS.n121 wind_comp_0.sg13g2_and2_2$1_0.VSS.n770 8.5005
R3413 wind_comp_0.sg13g2_and2_2$1_0.VSS.n121 wind_comp_0.sg13g2_and2_2$1_0.VSS.n769 8.5005
R3414 wind_comp_0.sg13g2_and2_2$1_0.VSS.n121 wind_comp_0.sg13g2_and2_2$1_0.VSS.n768 8.5005
R3415 wind_comp_0.sg13g2_and2_2$1_0.VSS.n121 wind_comp_0.sg13g2_and2_2$1_0.VSS.n766 8.5005
R3416 wind_comp_0.sg13g2_and2_2$1_0.VSS.n121 wind_comp_0.sg13g2_and2_2$1_0.VSS.n765 8.5005
R3417 wind_comp_0.sg13g2_and2_2$1_0.VSS.n121 wind_comp_0.sg13g2_and2_2$1_0.VSS.n764 8.5005
R3418 wind_comp_0.sg13g2_and2_2$1_0.VSS.n121 wind_comp_0.sg13g2_and2_2$1_0.VSS.n763 8.5005
R3419 wind_comp_0.sg13g2_and2_2$1_0.VSS.n121 wind_comp_0.sg13g2_and2_2$1_0.VSS.n762 8.5005
R3420 wind_comp_0.sg13g2_and2_2$1_0.VSS.n121 wind_comp_0.sg13g2_and2_2$1_0.VSS.n761 8.5005
R3421 wind_comp_0.sg13g2_and2_2$1_0.VSS.n121 wind_comp_0.sg13g2_and2_2$1_0.VSS.n760 8.5005
R3422 wind_comp_0.sg13g2_and2_2$1_0.VSS.n121 wind_comp_0.sg13g2_and2_2$1_0.VSS.n215 4.24945
R3423 wind_comp_0.sg13g2_and2_2$1_0.VSS.n121 wind_comp_0.sg13g2_and2_2$1_0.VSS.n759 8.5005
R3424 wind_comp_0.sg13g2_and2_2$1_0.VSS.n121 wind_comp_0.sg13g2_and2_2$1_0.VSS.n758 8.5005
R3425 wind_comp_0.sg13g2_and2_2$1_0.VSS.n8 wind_comp_0.sg13g2_and2_2$1_0.VSS.n10 0.410376
R3426 wind_comp_0.sg13g2_and2_2$1_0.VSS.n148 wind_comp_0.sg13g2_and2_2$1_0.VSS.n8 0.858683
R3427 wind_comp_0.sg13g2_and2_2$1_0.VSS.n8 wind_comp_0.sg13g2_and2_2$1_0.VSS.n193 8.50044
R3428 wind_comp_0.sg13g2_and2_2$1_0.VSS.n198 wind_comp_0.sg13g2_and2_2$1_0.VSS.n106 0.00261458
R3429 wind_comp_0.sg13g2_and2_2$1_0.VSS.n201 wind_comp_0.sg13g2_and2_2$1_0.VSS.n106 1.88811
R3430 wind_comp_0.sg13g2_and2_2$1_0.VSS.n118 wind_comp_0.sg13g2_and2_2$1_0.VSS.n117 0.770519
R3431 wind_comp_0.sg13g2_and2_2$1_0.VSS.n149 wind_comp_0.sg13g2_and2_2$1_0.VSS.n68 2.12177
R3432 wind_comp_0.sg13g2_and2_2$1_0.VSS.n156 wind_comp_0.sg13g2_and2_2$1_0.VSS.n155 0.0106098
R3433 wind_comp_0.sg13g2_and2_2$1_0.VSS.n68 wind_comp_0.sg13g2_and2_2$1_0.VSS.n194 5.66525
R3434 wind_comp_0.sg13g2_and2_2$1_0.VSS.n79 wind_comp_0.sg13g2_and2_2$1_0.VSS.n882 8.499
R3435 wind_comp_0.sg13g2_and2_2$1_0.VSS.n4 wind_comp_0.sg13g2_and2_2$1_0.VSS.n756 8.499
R3436 wind_comp_0.sg13g2_and2_2$1_0.VSS.n4 wind_comp_0.sg13g2_and2_2$1_0.VSS.n753 8.499
R3437 wind_comp_0.sg13g2_and2_2$1_0.VSS.n4 wind_comp_0.sg13g2_and2_2$1_0.VSS.n752 8.499
R3438 wind_comp_0.sg13g2_and2_2$1_0.VSS.n8 wind_comp_0.sg13g2_and2_2$1_0.VSS.n621 8.49855
R3439 wind_comp_0.sg13g2_and2_2$1_0.VSS.n79 wind_comp_0.sg13g2_and2_2$1_0.VSS.n872 8.49855
R3440 wind_comp_0.sg13g2_and2_2$1_0.VSS.n233 wind_comp_0.sg13g2_and2_2$1_0.VSS.n2227 0.0101204
R3441 wind_comp_0.sg13g2_and2_2$1_0.VSS.n79 wind_comp_0.sg13g2_and2_2$1_0.VSS.n625 8.49855
R3442 wind_comp_0.sg13g2_and2_2$1_0.VSS.n2527 wind_comp_0.sg13g2_and2_2$1_0.VSS.n1615 8.49741
R3443 wind_comp_0.sg13g2_and2_2$1_0.VSS.n2527 wind_comp_0.sg13g2_and2_2$1_0.VSS.n1618 8.49741
R3444 wind_comp_0.sg13g2_and2_2$1_0.VSS.n2527 wind_comp_0.sg13g2_and2_2$1_0.VSS.n1621 8.49741
R3445 wind_comp_0.sg13g2_and2_2$1_0.VSS.n2527 wind_comp_0.sg13g2_and2_2$1_0.VSS.n1689 8.49741
R3446 wind_comp_0.sg13g2_and2_2$1_0.VSS.n2527 wind_comp_0.sg13g2_and2_2$1_0.VSS.n1685 8.49741
R3447 wind_comp_0.sg13g2_and2_2$1_0.VSS.n2527 wind_comp_0.sg13g2_and2_2$1_0.VSS.n1683 8.49741
R3448 wind_comp_0.sg13g2_and2_2$1_0.VSS.n2527 wind_comp_0.sg13g2_and2_2$1_0.VSS.n1680 8.49741
R3449 wind_comp_0.sg13g2_and2_2$1_0.VSS.n2527 wind_comp_0.sg13g2_and2_2$1_0.VSS.n1672 8.49741
R3450 wind_comp_0.sg13g2_and2_2$1_0.VSS.n2527 wind_comp_0.sg13g2_and2_2$1_0.VSS.n1670 8.49741
R3451 wind_comp_0.sg13g2_and2_2$1_0.VSS.n2527 wind_comp_0.sg13g2_and2_2$1_0.VSS.n1665 8.49741
R3452 wind_comp_0.sg13g2_and2_2$1_0.VSS.n2527 wind_comp_0.sg13g2_and2_2$1_0.VSS.n1636 8.49741
R3453 wind_comp_0.sg13g2_and2_2$1_0.VSS.n2527 wind_comp_0.sg13g2_and2_2$1_0.VSS.n1638 8.49741
R3454 wind_comp_0.sg13g2_and2_2$1_0.VSS.n2527 wind_comp_0.sg13g2_and2_2$1_0.VSS.n1641 8.49741
R3455 wind_comp_0.sg13g2_and2_2$1_0.VSS.n2527 wind_comp_0.sg13g2_and2_2$1_0.VSS.n1647 8.49741
R3456 wind_comp_0.sg13g2_and2_2$1_0.VSS.n1587 wind_comp_0.sg13g2_and2_2$1_0.VSS.n1308 8.49741
R3457 wind_comp_0.sg13g2_and2_2$1_0.VSS.n1522 wind_comp_0.sg13g2_and2_2$1_0.VSS.n1411 8.49741
R3458 wind_comp_0.sg13g2_and2_2$1_0.VSS.n1522 wind_comp_0.sg13g2_and2_2$1_0.VSS.n1416 8.49741
R3459 wind_comp_0.sg13g2_and2_2$1_0.VSS.n1522 wind_comp_0.sg13g2_and2_2$1_0.VSS.n1421 8.49741
R3460 wind_comp_0.sg13g2_and2_2$1_0.VSS.n1522 wind_comp_0.sg13g2_and2_2$1_0.VSS.n1425 8.49741
R3461 wind_comp_0.sg13g2_and2_2$1_0.VSS.n1522 wind_comp_0.sg13g2_and2_2$1_0.VSS.n1496 8.49741
R3462 wind_comp_0.sg13g2_and2_2$1_0.VSS.n1522 wind_comp_0.sg13g2_and2_2$1_0.VSS.n1491 8.49741
R3463 wind_comp_0.sg13g2_and2_2$1_0.VSS.n1522 wind_comp_0.sg13g2_and2_2$1_0.VSS.n1480 8.49741
R3464 wind_comp_0.sg13g2_and2_2$1_0.VSS.n1522 wind_comp_0.sg13g2_and2_2$1_0.VSS.n1482 8.49741
R3465 wind_comp_0.sg13g2_and2_2$1_0.VSS.n1522 wind_comp_0.sg13g2_and2_2$1_0.VSS.n1476 8.49741
R3466 wind_comp_0.sg13g2_and2_2$1_0.VSS.n1522 wind_comp_0.sg13g2_and2_2$1_0.VSS.n1472 8.49741
R3467 wind_comp_0.sg13g2_and2_2$1_0.VSS.n1522 wind_comp_0.sg13g2_and2_2$1_0.VSS.n1468 8.49741
R3468 wind_comp_0.sg13g2_and2_2$1_0.VSS.n1522 wind_comp_0.sg13g2_and2_2$1_0.VSS.n1446 8.49741
R3469 wind_comp_0.sg13g2_and2_2$1_0.VSS.n1522 wind_comp_0.sg13g2_and2_2$1_0.VSS.n1450 8.49741
R3470 wind_comp_0.sg13g2_and2_2$1_0.VSS.n1522 wind_comp_0.sg13g2_and2_2$1_0.VSS.n1454 8.49741
R3471 wind_comp_0.sg13g2_and2_2$1_0.VSS.n68 wind_comp_0.sg13g2_and2_2$1_0.VSS.n1776 8.49379
R3472 wind_comp_0.sg13g2_and2_2$1_0.VSS.n8 wind_comp_0.sg13g2_and2_2$1_0.VSS.n720 8.49211
R3473 wind_comp_0.sg13g2_and2_2$1_0.VSS.n68 wind_comp_0.sg13g2_and2_2$1_0.VSS.n1758 8.49211
R3474 wind_comp_0.sg13g2_and2_2$1_0.VSS.n124 wind_comp_0.sg13g2_and2_2$1_0.VSS.n1317 8.47769
R3475 wind_comp_0.sg13g2_and2_2$1_0.VSS.n124 wind_comp_0.sg13g2_and2_2$1_0.VSS.n1333 8.47769
R3476 wind_comp_0.sg13g2_and2_2$1_0.VSS.n101 wind_comp_0.sg13g2_and2_2$1_0.VSS.n1706 8.47769
R3477 wind_comp_0.sg13g2_and2_2$1_0.VSS.n101 wind_comp_0.sg13g2_and2_2$1_0.VSS.n103 5.62647
R3478 wind_comp_0.sg13g2_and2_2$1_0.VSS.n124 wind_comp_0.sg13g2_and2_2$1_0.VSS.n1336 8.47769
R3479 wind_comp_0.sg13g2_and2_2$1_0.VSS.n45 wind_comp_0.sg13g2_and2_2$1_0.VSS.n4 0.514988
R3480 wind_comp_0.sg13g2_and2_2$1_0.VSS.n671 wind_comp_0.sg13g2_and2_2$1_0.VSS.n45 0.363182
R3481 wind_comp_0.sg13g2_and2_2$1_0.VSS.n101 wind_comp_0.sg13g2_and2_2$1_0.VSS.n1707 8.46745
R3482 wind_comp_0.sg13g2_and2_2$1_0.VSS.n1703 wind_comp_0.sg13g2_and2_2$1_0.VSS.n101 8.46745
R3483 wind_comp_0.sg13g2_and2_2$1_0.VSS.n2630 wind_comp_0.sg13g2_and2_2$1_0.VSS.t52 8.46606
R3484 wind_comp_0.sg13g2_and2_2$1_0.VSS.t52 wind_comp_0.sg13g2_and2_2$1_0.VSS.n2619 8.46606
R3485 wind_comp_0.sg13g2_and2_2$1_0.VSS.t50 wind_comp_0.sg13g2_and2_2$1_0.VSS.n2598 8.46606
R3486 wind_comp_0.sg13g2_and2_2$1_0.VSS.t50 wind_comp_0.sg13g2_and2_2$1_0.VSS.n2602 8.46606
R3487 wind_comp_0.sg13g2_and2_2$1_0.VSS.t232 wind_comp_0.sg13g2_and2_2$1_0.VSS.n2239 8.46606
R3488 wind_comp_0.sg13g2_and2_2$1_0.VSS.t232 wind_comp_0.sg13g2_and2_2$1_0.VSS.n2243 8.46606
R3489 wind_comp_0.sg13g2_and2_2$1_0.VSS.t229 wind_comp_0.sg13g2_and2_2$1_0.VSS.n2260 8.46606
R3490 wind_comp_0.sg13g2_and2_2$1_0.VSS.t229 wind_comp_0.sg13g2_and2_2$1_0.VSS.n2264 8.46606
R3491 wind_comp_0.sg13g2_and2_2$1_0.VSS.n1273 wind_comp_0.sg13g2_and2_2$1_0.VSS.n207 0.687853
R3492 wind_comp_0.sg13g2_and2_2$1_0.VSS.n213 wind_comp_0.sg13g2_and2_2$1_0.VSS.n70 5.43906
R3493 wind_comp_0.sg13g2_and2_2$1_0.VSS.n1278 wind_comp_0.sg13g2_and2_2$1_0.VSS.n212 1.44153
R3494 wind_comp_0.sg13g2_and2_2$1_0.VSS.n1280 wind_comp_0.sg13g2_and2_2$1_0.VSS.n209 1.44153
R3495 wind_comp_0.sg13g2_and2_2$1_0.VSS.n951 wind_comp_0.sg13g2_and2_2$1_0.VSS.n438 7.79976
R3496 wind_comp_0.sg13g2_and2_2$1_0.VSS.n210 wind_comp_0.sg13g2_and2_2$1_0.VSS.n70 4.99556
R3497 wind_comp_0.sg13g2_and2_2$1_0.VSS.n211 wind_comp_0.sg13g2_and2_2$1_0.VSS.n70 4.99556
R3498 wind_comp_0.sg13g2_and2_2$1_0.VSS.n205 wind_comp_0.sg13g2_and2_2$1_0.VSS.n70 4.92258
R3499 wind_comp_0.sg13g2_and2_2$1_0.VSS.n204 wind_comp_0.sg13g2_and2_2$1_0.VSS.n70 4.92258
R3500 wind_comp_0.sg13g2_and2_2$1_0.VSS.n130 wind_comp_0.sg13g2_and2_2$1_0.VSS.n121 2.01889
R3501 wind_comp_0.sg13g2_and2_2$1_0.VSS.n1586 wind_comp_0.sg13g2_and2_2$1_0.VSS.n1585 7.07951
R3502 wind_comp_0.sg13g2_and2_2$1_0.VSS.n1304 wind_comp_0.sg13g2_and2_2$1_0.VSS.n1228 6.65048
R3503 wind_comp_0.sg13g2_and2_2$1_0.VSS.n1305 wind_comp_0.sg13g2_and2_2$1_0.VSS.n1227 6.65048
R3504 wind_comp_0.sg13g2_and2_2$1_0.VSS.n1584 wind_comp_0.sg13g2_and2_2$1_0.VSS.n1582 6.22145
R3505 wind_comp_0.sg13g2_and2_2$1_0.VSS.n1206 wind_comp_0.sg13g2_and2_2$1_0.VSS.n274 6.13633
R3506 wind_comp_0.sg13g2_and2_2$1_0.VSS.n1427 wind_comp_0.sg13g2_and2_2$1_0.VSS.t347 6.00694
R3507 wind_comp_0.sg13g2_and2_2$1_0.VSS.n249 wind_comp_0.sg13g2_and2_2$1_0.VSS.n1 1.18087
R3508 wind_comp_0.sg13g2_and2_2$1_0.VSS.n2563 wind_comp_0.sg13g2_and2_2$1_0.VSS.n2548 5.93152
R3509 wind_comp_0.sg13g2_and2_2$1_0.VSS.n1570 wind_comp_0.sg13g2_and2_2$1_0.VSS.n248 5.91198
R3510 wind_comp_0.sg13g2_and2_2$1_0.VSS.n606 wind_comp_0.sg13g2_and2_2$1_0.VSS.n74 5.87129
R3511 wind_comp_0.sg13g2_and2_2$1_0.VSS.n214 wind_comp_0.sg13g2_and2_2$1_0.VSS.n70 5.85963
R3512 wind_comp_0.sg13g2_and2_2$1_0.VSS.n124 wind_comp_0.sg13g2_and2_2$1_0.VSS.n606 5.85913
R3513 wind_comp_0.sg13g2_and2_2$1_0.VSS.n607 wind_comp_0.sg13g2_and2_2$1_0.VSS.n70 5.835
R3514 wind_comp_0.sg13g2_and2_2$1_0.VSS.n1537 wind_comp_0.sg13g2_and2_2$1_0.VSS.n81 5.83459
R3515 wind_comp_0.sg13g2_and2_2$1_0.VSS.n935 wind_comp_0.sg13g2_and2_2$1_0.VSS.n427 5.71855
R3516 wind_comp_0.sg13g2_and2_2$1_0.VSS.n936 wind_comp_0.sg13g2_and2_2$1_0.VSS.n425 5.71855
R3517 wind_comp_0.sg13g2_and2_2$1_0.VSS.n939 wind_comp_0.sg13g2_and2_2$1_0.VSS.n429 5.71855
R3518 wind_comp_0.sg13g2_and2_2$1_0.VSS.n941 wind_comp_0.sg13g2_and2_2$1_0.VSS.n430 5.71855
R3519 wind_comp_0.sg13g2_and2_2$1_0.VSS.n942 wind_comp_0.sg13g2_and2_2$1_0.VSS.n431 5.71855
R3520 wind_comp_0.sg13g2_and2_2$1_0.VSS.n943 wind_comp_0.sg13g2_and2_2$1_0.VSS.n432 5.71855
R3521 wind_comp_0.sg13g2_and2_2$1_0.VSS.n944 wind_comp_0.sg13g2_and2_2$1_0.VSS.n433 5.71855
R3522 wind_comp_0.sg13g2_and2_2$1_0.VSS.n946 wind_comp_0.sg13g2_and2_2$1_0.VSS.n435 5.71855
R3523 wind_comp_0.sg13g2_and2_2$1_0.VSS.n948 wind_comp_0.sg13g2_and2_2$1_0.VSS.n436 5.71855
R3524 wind_comp_0.sg13g2_and2_2$1_0.VSS.n949 wind_comp_0.sg13g2_and2_2$1_0.VSS.n437 5.71855
R3525 wind_comp_0.sg13g2_and2_2$1_0.VSS.n1666 wind_comp_0.sg13g2_and2_2$1_0.VSS.n101 5.66778
R3526 wind_comp_0.sg13g2_and2_2$1_0.VSS.n8 wind_comp_0.sg13g2_and2_2$1_0.VSS.n464 3.39804
R3527 wind_comp_0.sg13g2_and2_2$1_0.VSS.n8 wind_comp_0.sg13g2_and2_2$1_0.VSS.n498 3.38583
R3528 wind_comp_0.sg13g2_and2_2$1_0.VSS.n8 wind_comp_0.sg13g2_and2_2$1_0.VSS.n500 3.40002
R3529 wind_comp_0.sg13g2_and2_2$1_0.VSS.n201 wind_comp_0.sg13g2_and2_2$1_0.VSS.n536 3.39818
R3530 wind_comp_0.sg13g2_and2_2$1_0.VSS.n201 wind_comp_0.sg13g2_and2_2$1_0.VSS.n543 3.39974
R3531 wind_comp_0.sg13g2_and2_2$1_0.VSS.n201 wind_comp_0.sg13g2_and2_2$1_0.VSS.n544 3.39962
R3532 wind_comp_0.sg13g2_and2_2$1_0.VSS.n201 wind_comp_0.sg13g2_and2_2$1_0.VSS.n547 3.39866
R3533 wind_comp_0.sg13g2_and2_2$1_0.VSS.n201 wind_comp_0.sg13g2_and2_2$1_0.VSS.n69 0.017881
R3534 wind_comp_0.sg13g2_and2_2$1_0.VSS.n201 wind_comp_0.sg13g2_and2_2$1_0.VSS.n551 5.66717
R3535 wind_comp_0.sg13g2_and2_2$1_0.VSS.n201 wind_comp_0.sg13g2_and2_2$1_0.VSS.n553 5.66717
R3536 wind_comp_0.sg13g2_and2_2$1_0.VSS.n201 wind_comp_0.sg13g2_and2_2$1_0.VSS.n554 5.66717
R3537 wind_comp_0.sg13g2_and2_2$1_0.VSS.n201 wind_comp_0.sg13g2_and2_2$1_0.VSS.n555 5.66717
R3538 wind_comp_0.sg13g2_and2_2$1_0.VSS.n201 wind_comp_0.sg13g2_and2_2$1_0.VSS.n556 5.66717
R3539 wind_comp_0.sg13g2_and2_2$1_0.VSS.n201 wind_comp_0.sg13g2_and2_2$1_0.VSS.n557 5.66717
R3540 wind_comp_0.sg13g2_and2_2$1_0.VSS.n201 wind_comp_0.sg13g2_and2_2$1_0.VSS.n558 5.66717
R3541 wind_comp_0.sg13g2_and2_2$1_0.VSS.n201 wind_comp_0.sg13g2_and2_2$1_0.VSS.n559 5.66717
R3542 wind_comp_0.sg13g2_and2_2$1_0.VSS.n201 wind_comp_0.sg13g2_and2_2$1_0.VSS.n560 5.66717
R3543 wind_comp_0.sg13g2_and2_2$1_0.VSS.n201 wind_comp_0.sg13g2_and2_2$1_0.VSS.n561 5.66717
R3544 wind_comp_0.sg13g2_and2_2$1_0.VSS.n201 wind_comp_0.sg13g2_and2_2$1_0.VSS.n562 5.66717
R3545 wind_comp_0.sg13g2_and2_2$1_0.VSS.n201 wind_comp_0.sg13g2_and2_2$1_0.VSS.n563 5.66717
R3546 wind_comp_0.sg13g2_and2_2$1_0.VSS.n201 wind_comp_0.sg13g2_and2_2$1_0.VSS.n565 5.66717
R3547 wind_comp_0.sg13g2_and2_2$1_0.VSS.n68 wind_comp_0.sg13g2_and2_2$1_0.VSS.n566 3.39575
R3548 wind_comp_0.sg13g2_and2_2$1_0.VSS.n201 wind_comp_0.sg13g2_and2_2$1_0.VSS.n567 5.66717
R3549 wind_comp_0.sg13g2_and2_2$1_0.VSS.n201 wind_comp_0.sg13g2_and2_2$1_0.VSS.n568 3.39853
R3550 wind_comp_0.sg13g2_and2_2$1_0.VSS.n201 wind_comp_0.sg13g2_and2_2$1_0.VSS.n569 3.39919
R3551 wind_comp_0.sg13g2_and2_2$1_0.VSS.n201 wind_comp_0.sg13g2_and2_2$1_0.VSS.n570 3.39914
R3552 wind_comp_0.sg13g2_and2_2$1_0.VSS.n201 wind_comp_0.sg13g2_and2_2$1_0.VSS.n571 5.66717
R3553 wind_comp_0.sg13g2_and2_2$1_0.VSS.n201 wind_comp_0.sg13g2_and2_2$1_0.VSS.n572 5.66717
R3554 wind_comp_0.sg13g2_and2_2$1_0.VSS.n201 wind_comp_0.sg13g2_and2_2$1_0.VSS.n573 5.66717
R3555 wind_comp_0.sg13g2_and2_2$1_0.VSS.n201 wind_comp_0.sg13g2_and2_2$1_0.VSS.n574 5.66717
R3556 wind_comp_0.sg13g2_and2_2$1_0.VSS.n201 wind_comp_0.sg13g2_and2_2$1_0.VSS.n575 5.66717
R3557 wind_comp_0.sg13g2_and2_2$1_0.VSS.n201 wind_comp_0.sg13g2_and2_2$1_0.VSS.n577 5.66717
R3558 wind_comp_0.sg13g2_and2_2$1_0.VSS.n201 wind_comp_0.sg13g2_and2_2$1_0.VSS.n579 5.66717
R3559 wind_comp_0.sg13g2_and2_2$1_0.VSS.n201 wind_comp_0.sg13g2_and2_2$1_0.VSS.n580 5.66717
R3560 wind_comp_0.sg13g2_and2_2$1_0.VSS.n201 wind_comp_0.sg13g2_and2_2$1_0.VSS.n581 5.66717
R3561 wind_comp_0.sg13g2_and2_2$1_0.VSS.n201 wind_comp_0.sg13g2_and2_2$1_0.VSS.n582 5.66717
R3562 wind_comp_0.sg13g2_and2_2$1_0.VSS.n201 wind_comp_0.sg13g2_and2_2$1_0.VSS.n583 5.66717
R3563 wind_comp_0.sg13g2_and2_2$1_0.VSS.n201 wind_comp_0.sg13g2_and2_2$1_0.VSS.n584 5.66717
R3564 wind_comp_0.sg13g2_and2_2$1_0.VSS.n201 wind_comp_0.sg13g2_and2_2$1_0.VSS.n585 5.66717
R3565 wind_comp_0.sg13g2_and2_2$1_0.VSS.n201 wind_comp_0.sg13g2_and2_2$1_0.VSS.n586 5.66717
R3566 wind_comp_0.sg13g2_and2_2$1_0.VSS.n201 wind_comp_0.sg13g2_and2_2$1_0.VSS.n587 5.66717
R3567 wind_comp_0.sg13g2_and2_2$1_0.VSS.n201 wind_comp_0.sg13g2_and2_2$1_0.VSS.n589 5.66717
R3568 wind_comp_0.sg13g2_and2_2$1_0.VSS.n201 wind_comp_0.sg13g2_and2_2$1_0.VSS.n590 5.66717
R3569 wind_comp_0.sg13g2_and2_2$1_0.VSS.n201 wind_comp_0.sg13g2_and2_2$1_0.VSS.n593 5.66717
R3570 wind_comp_0.sg13g2_and2_2$1_0.VSS.n201 wind_comp_0.sg13g2_and2_2$1_0.VSS.n594 5.66717
R3571 wind_comp_0.sg13g2_and2_2$1_0.VSS.n201 wind_comp_0.sg13g2_and2_2$1_0.VSS.n595 5.66717
R3572 wind_comp_0.sg13g2_and2_2$1_0.VSS.n201 wind_comp_0.sg13g2_and2_2$1_0.VSS.n596 5.66717
R3573 wind_comp_0.sg13g2_and2_2$1_0.VSS.n201 wind_comp_0.sg13g2_and2_2$1_0.VSS.n597 5.66717
R3574 wind_comp_0.sg13g2_and2_2$1_0.VSS.n201 wind_comp_0.sg13g2_and2_2$1_0.VSS.n598 5.66717
R3575 wind_comp_0.sg13g2_and2_2$1_0.VSS.n201 wind_comp_0.sg13g2_and2_2$1_0.VSS.n599 5.66717
R3576 wind_comp_0.sg13g2_and2_2$1_0.VSS.n201 wind_comp_0.sg13g2_and2_2$1_0.VSS.n600 5.66717
R3577 wind_comp_0.sg13g2_and2_2$1_0.VSS.n201 wind_comp_0.sg13g2_and2_2$1_0.VSS.n601 5.66717
R3578 wind_comp_0.sg13g2_and2_2$1_0.VSS.n201 wind_comp_0.sg13g2_and2_2$1_0.VSS.n602 5.66717
R3579 wind_comp_0.sg13g2_and2_2$1_0.VSS.n201 wind_comp_0.sg13g2_and2_2$1_0.VSS.n603 5.66717
R3580 wind_comp_0.sg13g2_and2_2$1_0.VSS.n201 wind_comp_0.sg13g2_and2_2$1_0.VSS.n604 5.66717
R3581 wind_comp_0.sg13g2_and2_2$1_0.VSS.n201 wind_comp_0.sg13g2_and2_2$1_0.VSS.n605 5.66717
R3582 wind_comp_0.sg13g2_and2_2$1_0.VSS.n83 wind_comp_0.sg13g2_and2_2$1_0.VSS.n394 3.39197
R3583 wind_comp_0.sg13g2_and2_2$1_0.VSS.n83 wind_comp_0.sg13g2_and2_2$1_0.VSS.n393 4.24481
R3584 wind_comp_0.sg13g2_and2_2$1_0.VSS.n83 wind_comp_0.sg13g2_and2_2$1_0.VSS.n395 3.39827
R3585 wind_comp_0.sg13g2_and2_2$1_0.VSS.n72 wind_comp_0.sg13g2_and2_2$1_0.VSS.n81 0.00215156
R3586 wind_comp_0.sg13g2_and2_2$1_0.VSS.n201 wind_comp_0.sg13g2_and2_2$1_0.VSS.n532 5.66717
R3587 wind_comp_0.sg13g2_and2_2$1_0.VSS.n79 wind_comp_0.sg13g2_and2_2$1_0.VSS.n667 5.66423
R3588 wind_comp_0.sg13g2_and2_2$1_0.VSS.n79 wind_comp_0.sg13g2_and2_2$1_0.VSS.n893 5.66423
R3589 wind_comp_0.sg13g2_and2_2$1_0.VSS.n79 wind_comp_0.sg13g2_and2_2$1_0.VSS.n878 5.66423
R3590 wind_comp_0.sg13g2_and2_2$1_0.VSS.n79 wind_comp_0.sg13g2_and2_2$1_0.VSS.n877 5.66423
R3591 wind_comp_0.sg13g2_and2_2$1_0.VSS.n4 wind_comp_0.sg13g2_and2_2$1_0.VSS.n751 5.66423
R3592 wind_comp_0.sg13g2_and2_2$1_0.VSS.n4 wind_comp_0.sg13g2_and2_2$1_0.VSS.n528 5.66423
R3593 wind_comp_0.sg13g2_and2_2$1_0.VSS.n2527 wind_comp_0.sg13g2_and2_2$1_0.VSS.n1624 5.66141
R3594 wind_comp_0.sg13g2_and2_2$1_0.VSS.n2527 wind_comp_0.sg13g2_and2_2$1_0.VSS.n1662 5.66141
R3595 wind_comp_0.sg13g2_and2_2$1_0.VSS.n2527 wind_comp_0.sg13g2_and2_2$1_0.VSS.n1644 5.66141
R3596 wind_comp_0.sg13g2_and2_2$1_0.VSS.n1587 wind_comp_0.sg13g2_and2_2$1_0.VSS.n1579 5.66141
R3597 wind_comp_0.sg13g2_and2_2$1_0.VSS.n1522 wind_comp_0.sg13g2_and2_2$1_0.VSS.n1409 5.66141
R3598 wind_comp_0.sg13g2_and2_2$1_0.VSS.n1522 wind_comp_0.sg13g2_and2_2$1_0.VSS.n1429 5.66141
R3599 wind_comp_0.sg13g2_and2_2$1_0.VSS.n1522 wind_comp_0.sg13g2_and2_2$1_0.VSS.n1465 5.66141
R3600 wind_comp_0.sg13g2_and2_2$1_0.VSS.n70 wind_comp_0.sg13g2_and2_2$1_0.VSS.n208 1.25088
R3601 wind_comp_0.sg13g2_and2_2$1_0.VSS.n101 wind_comp_0.sg13g2_and2_2$1_0.VSS.n2525 5.62647
R3602 wind_comp_0.sg13g2_and2_2$1_0.VSS.n4 wind_comp_0.sg13g2_and2_2$1_0.VSS.n202 0.549256
R3603 wind_comp_0.sg13g2_and2_2$1_0.VSS.n2530 wind_comp_0.sg13g2_and2_2$1_0.VSS.n1574 5.5779
R3604 wind_comp_0.sg13g2_and2_2$1_0.VSS.n1604 wind_comp_0.sg13g2_and2_2$1_0.VSS.n394 5.5779
R3605 wind_comp_0.sg13g2_and2_2$1_0.VSS.n1605 wind_comp_0.sg13g2_and2_2$1_0.VSS.n393 5.5779
R3606 wind_comp_0.sg13g2_and2_2$1_0.VSS.n1206 wind_comp_0.sg13g2_and2_2$1_0.VSS.n260 5.51254
R3607 wind_comp_0.sg13g2_and2_2$1_0.VSS.t30 wind_comp_0.sg13g2_and2_2$1_0.VSS.n428 5.40665
R3608 wind_comp_0.sg13g2_and2_2$1_0.VSS.n1505 wind_comp_0.sg13g2_and2_2$1_0.VSS.n1504 5.36339
R3609 wind_comp_0.sg13g2_and2_2$1_0.VSS.n1266 wind_comp_0.sg13g2_and2_2$1_0.VSS.n1265 5.36339
R3610 wind_comp_0.sg13g2_and2_2$1_0.VSS.n1404 wind_comp_0.sg13g2_and2_2$1_0.VSS.n1403 5.36339
R3611 wind_comp_0.sg13g2_and2_2$1_0.VSS.n1268 wind_comp_0.sg13g2_and2_2$1_0.VSS.n1267 5.36339
R3612 wind_comp_0.sg13g2_and2_2$1_0.VSS.n1270 wind_comp_0.sg13g2_and2_2$1_0.VSS.n1269 5.36339
R3613 wind_comp_0.sg13g2_and2_2$1_0.VSS.n953 wind_comp_0.sg13g2_and2_2$1_0.VSS.n439 5.30269
R3614 wind_comp_0.sg13g2_and2_2$1_0.VSS.n954 wind_comp_0.sg13g2_and2_2$1_0.VSS.n440 5.30269
R3615 wind_comp_0.sg13g2_and2_2$1_0.VSS.n956 wind_comp_0.sg13g2_and2_2$1_0.VSS.n441 5.30269
R3616 wind_comp_0.sg13g2_and2_2$1_0.VSS.n957 wind_comp_0.sg13g2_and2_2$1_0.VSS.n442 5.30269
R3617 wind_comp_0.sg13g2_and2_2$1_0.VSS.n961 wind_comp_0.sg13g2_and2_2$1_0.VSS.n444 5.30269
R3618 wind_comp_0.sg13g2_and2_2$1_0.VSS.n963 wind_comp_0.sg13g2_and2_2$1_0.VSS.n445 5.30269
R3619 wind_comp_0.sg13g2_and2_2$1_0.VSS.n964 wind_comp_0.sg13g2_and2_2$1_0.VSS.n446 5.30269
R3620 wind_comp_0.sg13g2_and2_2$1_0.VSS.n965 wind_comp_0.sg13g2_and2_2$1_0.VSS.n447 5.30269
R3621 wind_comp_0.sg13g2_and2_2$1_0.VSS.n966 wind_comp_0.sg13g2_and2_2$1_0.VSS.n448 5.30269
R3622 wind_comp_0.sg13g2_and2_2$1_0.VSS.n968 wind_comp_0.sg13g2_and2_2$1_0.VSS.n450 5.30269
R3623 wind_comp_0.sg13g2_and2_2$1_0.VSS.n969 wind_comp_0.sg13g2_and2_2$1_0.VSS.n451 5.30269
R3624 wind_comp_0.sg13g2_and2_2$1_0.VSS.n590 wind_comp_0.sg13g2_and2_2$1_0.VSS.n1164 5.14887
R3625 wind_comp_0.sg13g2_and2_2$1_0.VSS.n589 wind_comp_0.sg13g2_and2_2$1_0.VSS.n1163 5.14887
R3626 wind_comp_0.sg13g2_and2_2$1_0.VSS.n587 wind_comp_0.sg13g2_and2_2$1_0.VSS.n1159 5.14887
R3627 wind_comp_0.sg13g2_and2_2$1_0.VSS.n586 wind_comp_0.sg13g2_and2_2$1_0.VSS.n1156 5.14887
R3628 wind_comp_0.sg13g2_and2_2$1_0.VSS.n580 wind_comp_0.sg13g2_and2_2$1_0.VSS.n1144 5.14887
R3629 wind_comp_0.sg13g2_and2_2$1_0.VSS.n577 wind_comp_0.sg13g2_and2_2$1_0.VSS.n1138 5.14887
R3630 wind_comp_0.sg13g2_and2_2$1_0.VSS.n300 wind_comp_0.sg13g2_and2_2$1_0.VSS.n1573 4.94063
R3631 wind_comp_0.sg13g2_and2_2$1_0.VSS.n1503 wind_comp_0.sg13g2_and2_2$1_0.VSS.n1501 4.93436
R3632 wind_comp_0.sg13g2_and2_2$1_0.VSS.n1570 wind_comp_0.sg13g2_and2_2$1_0.VSS.n214 4.86494
R3633 wind_comp_0.sg13g2_and2_2$1_0.VSS.n1431 wind_comp_0.sg13g2_and2_2$1_0.VSS.t344 4.71984
R3634 wind_comp_0.sg13g2_and2_2$1_0.VSS.n1498 wind_comp_0.sg13g2_and2_2$1_0.VSS.n489 4.71984
R3635 wind_comp_0.sg13g2_and2_2$1_0.VSS.n1260 wind_comp_0.sg13g2_and2_2$1_0.VSS.t350 4.71984
R3636 wind_comp_0.sg13g2_and2_2$1_0.VSS.t356 wind_comp_0.sg13g2_and2_2$1_0.VSS.n1508 4.71984
R3637 wind_comp_0.sg13g2_and2_2$1_0.VSS.n1581 wind_comp_0.sg13g2_and2_2$1_0.VSS.n1580 4.50533
R3638 wind_comp_0.sg13g2_and2_2$1_0.VSS.n1580 wind_comp_0.sg13g2_and2_2$1_0.VSS.t413 4.50533
R3639 wind_comp_0.sg13g2_and2_2$1_0.VSS.n595 wind_comp_0.sg13g2_and2_2$1_0.VSS.n1600 4.50533
R3640 wind_comp_0.sg13g2_and2_2$1_0.VSS.n593 wind_comp_0.sg13g2_and2_2$1_0.VSS.n1601 4.50533
R3641 wind_comp_0.sg13g2_and2_2$1_0.VSS.n584 wind_comp_0.sg13g2_and2_2$1_0.VSS.t367 4.50533
R3642 wind_comp_0.sg13g2_and2_2$1_0.VSS.n572 wind_comp_0.sg13g2_and2_2$1_0.VSS.t380 4.50533
R3643 wind_comp_0.sg13g2_and2_2$1_0.VSS.n569 wind_comp_0.sg13g2_and2_2$1_0.VSS.t383 4.50533
R3644 wind_comp_0.sg13g2_and2_2$1_0.VSS.n1555 wind_comp_0.sg13g2_and2_2$1_0.VSS.n607 4.4225
R3645 wind_comp_0.sg13g2_and2_2$1_0.VSS.n1563 wind_comp_0.sg13g2_and2_2$1_0.VSS.n1545 4.4225
R3646 wind_comp_0.sg13g2_and2_2$1_0.VSS.n1572 wind_comp_0.sg13g2_and2_2$1_0.VSS.n1571 4.40557
R3647 wind_comp_0.sg13g2_and2_2$1_0.VSS.n1900 wind_comp_0.sg13g2_and2_2$1_0.VSS.t246 4.39807
R3648 wind_comp_0.sg13g2_and2_2$1_0.VSS.n1549 wind_comp_0.sg13g2_and2_2$1_0.VSS.n1548 4.34962
R3649 wind_comp_0.sg13g2_and2_2$1_0.VSS.n1314 wind_comp_0.sg13g2_and2_2$1_0.VSS.n1313 4.29081
R3650 wind_comp_0.sg13g2_and2_2$1_0.VSS.n1357 wind_comp_0.sg13g2_and2_2$1_0.VSS.n1356 4.29081
R3651 wind_comp_0.sg13g2_and2_2$1_0.VSS.n1361 wind_comp_0.sg13g2_and2_2$1_0.VSS.n1360 4.29081
R3652 wind_comp_0.sg13g2_and2_2$1_0.VSS.t260 wind_comp_0.sg13g2_and2_2$1_0.VSS.n1367 4.29081
R3653 wind_comp_0.sg13g2_and2_2$1_0.VSS.t263 wind_comp_0.sg13g2_and2_2$1_0.VSS.n1371 4.29081
R3654 wind_comp_0.sg13g2_and2_2$1_0.VSS.n1226 wind_comp_0.sg13g2_and2_2$1_0.VSS.t342 4.29081
R3655 wind_comp_0.sg13g2_and2_2$1_0.VSS.n1199 wind_comp_0.sg13g2_and2_2$1_0.VSS.t345 4.29081
R3656 wind_comp_0.sg13g2_and2_2$1_0.VSS.t357 wind_comp_0.sg13g2_and2_2$1_0.VSS.n1406 4.29081
R3657 wind_comp_0.sg13g2_and2_2$1_0.VSS.n213 wind_comp_0.sg13g2_and2_2$1_0.VSS.n1274 4.63472
R3658 wind_comp_0.sg13g2_and2_2$1_0.VSS.n212 wind_comp_0.sg13g2_and2_2$1_0.VSS.n1277 5.01155
R3659 wind_comp_0.sg13g2_and2_2$1_0.VSS.n591 wind_comp_0.sg13g2_and2_2$1_0.VSS.n1650 4.29081
R3660 wind_comp_0.sg13g2_and2_2$1_0.VSS.t369 wind_comp_0.sg13g2_and2_2$1_0.VSS.n1148 4.29081
R3661 wind_comp_0.sg13g2_and2_2$1_0.VSS.t375 wind_comp_0.sg13g2_and2_2$1_0.VSS.n1136 4.29081
R3662 wind_comp_0.sg13g2_and2_2$1_0.VSS.t378 wind_comp_0.sg13g2_and2_2$1_0.VSS.n1131 4.29081
R3663 wind_comp_0.sg13g2_and2_2$1_0.VSS.t381 wind_comp_0.sg13g2_and2_2$1_0.VSS.n1124 4.29081
R3664 wind_comp_0.sg13g2_and2_2$1_0.VSS.n1880 wind_comp_0.sg13g2_and2_2$1_0.VSS.n85 0.895369
R3665 wind_comp_0.sg13g2_and2_2$1_0.VSS.n70 wind_comp_0.sg13g2_and2_2$1_0.VSS.n356 1.6027
R3666 wind_comp_0.sg13g2_and2_2$1_0.VSS.n68 wind_comp_0.sg13g2_and2_2$1_0.VSS.n1784 4.2505
R3667 wind_comp_0.sg13g2_and2_2$1_0.VSS.n79 wind_comp_0.sg13g2_and2_2$1_0.VSS.n80 0.918262
R3668 wind_comp_0.sg13g2_and2_2$1_0.VSS.n79 wind_comp_0.sg13g2_and2_2$1_0.VSS.n426 3.39473
R3669 wind_comp_0.sg13g2_and2_2$1_0.VSS.n79 wind_comp_0.sg13g2_and2_2$1_0.VSS.n427 3.39488
R3670 wind_comp_0.sg13g2_and2_2$1_0.VSS.n79 wind_comp_0.sg13g2_and2_2$1_0.VSS.n428 3.39503
R3671 wind_comp_0.sg13g2_and2_2$1_0.VSS.n79 wind_comp_0.sg13g2_and2_2$1_0.VSS.n429 3.40025
R3672 wind_comp_0.sg13g2_and2_2$1_0.VSS.n79 wind_comp_0.sg13g2_and2_2$1_0.VSS.n430 3.39518
R3673 wind_comp_0.sg13g2_and2_2$1_0.VSS.n79 wind_comp_0.sg13g2_and2_2$1_0.VSS.n431 3.39533
R3674 wind_comp_0.sg13g2_and2_2$1_0.VSS.n79 wind_comp_0.sg13g2_and2_2$1_0.VSS.n432 3.39548
R3675 wind_comp_0.sg13g2_and2_2$1_0.VSS.n79 wind_comp_0.sg13g2_and2_2$1_0.VSS.n433 3.39563
R3676 wind_comp_0.sg13g2_and2_2$1_0.VSS.n79 wind_comp_0.sg13g2_and2_2$1_0.VSS.n434 3.39578
R3677 wind_comp_0.sg13g2_and2_2$1_0.VSS.n79 wind_comp_0.sg13g2_and2_2$1_0.VSS.n435 3.39594
R3678 wind_comp_0.sg13g2_and2_2$1_0.VSS.n79 wind_comp_0.sg13g2_and2_2$1_0.VSS.n436 3.39609
R3679 wind_comp_0.sg13g2_and2_2$1_0.VSS.n79 wind_comp_0.sg13g2_and2_2$1_0.VSS.n437 3.39624
R3680 wind_comp_0.sg13g2_and2_2$1_0.VSS.n79 wind_comp_0.sg13g2_and2_2$1_0.VSS.n438 3.3964
R3681 wind_comp_0.sg13g2_and2_2$1_0.VSS.n79 wind_comp_0.sg13g2_and2_2$1_0.VSS.n439 3.39655
R3682 wind_comp_0.sg13g2_and2_2$1_0.VSS.n79 wind_comp_0.sg13g2_and2_2$1_0.VSS.n440 3.3967
R3683 wind_comp_0.sg13g2_and2_2$1_0.VSS.n79 wind_comp_0.sg13g2_and2_2$1_0.VSS.n441 3.39686
R3684 wind_comp_0.sg13g2_and2_2$1_0.VSS.n79 wind_comp_0.sg13g2_and2_2$1_0.VSS.n442 3.39701
R3685 wind_comp_0.sg13g2_and2_2$1_0.VSS.n79 wind_comp_0.sg13g2_and2_2$1_0.VSS.n443 3.39717
R3686 wind_comp_0.sg13g2_and2_2$1_0.VSS.n79 wind_comp_0.sg13g2_and2_2$1_0.VSS.n444 3.39732
R3687 wind_comp_0.sg13g2_and2_2$1_0.VSS.n79 wind_comp_0.sg13g2_and2_2$1_0.VSS.n445 3.39748
R3688 wind_comp_0.sg13g2_and2_2$1_0.VSS.n79 wind_comp_0.sg13g2_and2_2$1_0.VSS.n447 3.39764
R3689 wind_comp_0.sg13g2_and2_2$1_0.VSS.n79 wind_comp_0.sg13g2_and2_2$1_0.VSS.n448 3.39923
R3690 wind_comp_0.sg13g2_and2_2$1_0.VSS.n79 wind_comp_0.sg13g2_and2_2$1_0.VSS.n449 3.39888
R3691 wind_comp_0.sg13g2_and2_2$1_0.VSS.n79 wind_comp_0.sg13g2_and2_2$1_0.VSS.n450 3.39997
R3692 wind_comp_0.sg13g2_and2_2$1_0.VSS.n79 wind_comp_0.sg13g2_and2_2$1_0.VSS.n451 3.40057
R3693 wind_comp_0.sg13g2_and2_2$1_0.VSS.n79 wind_comp_0.sg13g2_and2_2$1_0.VSS.n161 0.572755
R3694 wind_comp_0.sg13g2_and2_2$1_0.VSS.n2207 wind_comp_0.sg13g2_and2_2$1_0.VSS.n121 4.24855
R3695 wind_comp_0.sg13g2_and2_2$1_0.VSS.n2134 wind_comp_0.sg13g2_and2_2$1_0.VSS.n121 4.24855
R3696 wind_comp_0.sg13g2_and2_2$1_0.VSS.n2041 wind_comp_0.sg13g2_and2_2$1_0.VSS.n121 4.24855
R3697 wind_comp_0.sg13g2_and2_2$1_0.VSS.n2048 wind_comp_0.sg13g2_and2_2$1_0.VSS.n121 4.24855
R3698 wind_comp_0.sg13g2_and2_2$1_0.VSS.n128 wind_comp_0.sg13g2_and2_2$1_0.VSS.n1059 4.24855
R3699 wind_comp_0.sg13g2_and2_2$1_0.VSS.n128 wind_comp_0.sg13g2_and2_2$1_0.VSS.n929 4.24855
R3700 wind_comp_0.sg13g2_and2_2$1_0.VSS.n128 wind_comp_0.sg13g2_and2_2$1_0.VSS.n927 4.24855
R3701 wind_comp_0.sg13g2_and2_2$1_0.VSS.n121 wind_comp_0.sg13g2_and2_2$1_0.VSS.n35 0.501436
R3702 wind_comp_0.sg13g2_and2_2$1_0.VSS.n121 wind_comp_0.sg13g2_and2_2$1_0.VSS.n767 4.24837
R3703 wind_comp_0.sg13g2_and2_2$1_0.VSS.n128 wind_comp_0.sg13g2_and2_2$1_0.VSS.n838 4.24829
R3704 wind_comp_0.sg13g2_and2_2$1_0.VSS.n128 wind_comp_0.sg13g2_and2_2$1_0.VSS.n859 4.24829
R3705 wind_comp_0.sg13g2_and2_2$1_0.VSS.n79 wind_comp_0.sg13g2_and2_2$1_0.VSS.n881 4.24602
R3706 wind_comp_0.sg13g2_and2_2$1_0.VSS.n8 wind_comp_0.sg13g2_and2_2$1_0.VSS.n244 4.23697
R3707 wind_comp_0.sg13g2_and2_2$1_0.VSS.n101 wind_comp_0.sg13g2_and2_2$1_0.VSS.n1718 4.1933
R3708 wind_comp_0.sg13g2_and2_2$1_0.VSS.n1583 wind_comp_0.sg13g2_and2_2$1_0.VSS.n1578 4.15775
R3709 wind_comp_0.sg13g2_and2_2$1_0.VSS.n1586 wind_comp_0.sg13g2_and2_2$1_0.VSS.n128 5.24972
R3710 wind_comp_0.sg13g2_and2_2$1_0.VSS.n1569 wind_comp_0.sg13g2_and2_2$1_0.VSS.n124 4.11285
R3711 wind_comp_0.sg13g2_and2_2$1_0.VSS.n1548 wind_comp_0.sg13g2_and2_2$1_0.VSS.n1545 4.0925
R3712 wind_comp_0.sg13g2_and2_2$1_0.VSS.n1455 wind_comp_0.sg13g2_and2_2$1_0.VSS.n9 6.43141
R3713 wind_comp_0.sg13g2_and2_2$1_0.VSS.n1445 wind_comp_0.sg13g2_and2_2$1_0.VSS.t257 4.0763
R3714 wind_comp_0.sg13g2_and2_2$1_0.VSS.n1517 wind_comp_0.sg13g2_and2_2$1_0.VSS.n1516 4.0763
R3715 wind_comp_0.sg13g2_and2_2$1_0.VSS.n1582 wind_comp_0.sg13g2_and2_2$1_0.VSS.t328 4.0763
R3716 wind_comp_0.sg13g2_and2_2$1_0.VSS.n1213 wind_comp_0.sg13g2_and2_2$1_0.VSS.n266 4.05512
R3717 wind_comp_0.sg13g2_and2_2$1_0.VSS.n1214 wind_comp_0.sg13g2_and2_2$1_0.VSS.n268 4.05512
R3718 wind_comp_0.sg13g2_and2_2$1_0.VSS.n1212 wind_comp_0.sg13g2_and2_2$1_0.VSS.n265 4.05512
R3719 wind_comp_0.sg13g2_and2_2$1_0.VSS.n1215 wind_comp_0.sg13g2_and2_2$1_0.VSS.n269 4.05512
R3720 wind_comp_0.sg13g2_and2_2$1_0.VSS.n1211 wind_comp_0.sg13g2_and2_2$1_0.VSS.n264 4.05512
R3721 wind_comp_0.sg13g2_and2_2$1_0.VSS.n1216 wind_comp_0.sg13g2_and2_2$1_0.VSS.n270 4.05512
R3722 wind_comp_0.sg13g2_and2_2$1_0.VSS.n1210 wind_comp_0.sg13g2_and2_2$1_0.VSS.n263 4.05512
R3723 wind_comp_0.sg13g2_and2_2$1_0.VSS.n1217 wind_comp_0.sg13g2_and2_2$1_0.VSS.n271 4.05512
R3724 wind_comp_0.sg13g2_and2_2$1_0.VSS.n1218 wind_comp_0.sg13g2_and2_2$1_0.VSS.n272 4.05512
R3725 wind_comp_0.sg13g2_and2_2$1_0.VSS.n1208 wind_comp_0.sg13g2_and2_2$1_0.VSS.n261 4.05512
R3726 wind_comp_0.sg13g2_and2_2$1_0.VSS.n1219 wind_comp_0.sg13g2_and2_2$1_0.VSS.n273 4.05512
R3727 wind_comp_0.sg13g2_and2_2$1_0.VSS.n1207 wind_comp_0.sg13g2_and2_2$1_0.VSS.n260 4.05512
R3728 wind_comp_0.sg13g2_and2_2$1_0.VSS.n1543 wind_comp_0.sg13g2_and2_2$1_0.VSS.n1542 4.0205
R3729 wind_comp_0.comparator_0.dynamic_pcell$2_0.SRC_NET_MNO wind_comp_0.sg13g2_and2_2$1_0.VSS.t27 3.99722
R3730 wind_comp_0.comparator_1.dynamic_pcell$2_0.SRC_NET_MNO wind_comp_0.sg13g2_and2_2$1_0.VSS.t139 3.99722
R3731 wind_comp_0.comparator_1.dynamic_pcell$2_0.SRC_NET_MNO wind_comp_0.sg13g2_and2_2$1_0.VSS.t136 3.99722
R3732 wind_comp_0.comparator_0.dynamic_pcell$2_0.SRC_NET_MNO wind_comp_0.sg13g2_and2_2$1_0.VSS.t42 3.99722
R3733 wind_comp_0.sg13g2_and2_2$1_0.VSS.n596 wind_comp_0.sg13g2_and2_2$1_0.VSS.t411 3.96904
R3734 wind_comp_0.sg13g2_and2_2$1_0.VSS.n1264 wind_comp_0.sg13g2_and2_2$1_0.VSS.t275 3.86178
R3735 wind_comp_0.sg13g2_and2_2$1_0.VSS.n1512 wind_comp_0.sg13g2_and2_2$1_0.VSS.n1511 3.86178
R3736 wind_comp_0.sg13g2_and2_2$1_0.VSS.n2569 wind_comp_0.sg13g2_and2_2$1_0.VSS.n2568 3.86178
R3737 wind_comp_0.sg13g2_and2_2$1_0.VSS.n574 wind_comp_0.sg13g2_and2_2$1_0.VSS.n1635 3.86178
R3738 wind_comp_0.sg13g2_and2_2$1_0.VSS.n530 wind_comp_0.sg13g2_and2_2$1_0.VSS.n920 3.86178
R3739 wind_comp_0.sg13g2_and2_2$1_0.VSS.n951 wind_comp_0.sg13g2_and2_2$1_0.VSS.n437 3.84911
R3740 wind_comp_0.sg13g2_and2_2$1_0.VSS.t408 wind_comp_0.sg13g2_and2_2$1_0.VSS.n1279 3.75452
R3741 wind_comp_0.sg13g2_and2_2$1_0.VSS.n531 wind_comp_0.sg13g2_and2_2$1_0.VSS.n922 3.74322
R3742 wind_comp_0.sg13g2_and2_2$1_0.VSS.n98 wind_comp_0.sg13g2_and2_2$1_0.VSS.n128 4.22769
R3743 wind_comp_0.sg13g2_and2_2$1_0.VSS.t249 wind_comp_0.sg13g2_and2_2$1_0.VSS.n1355 3.64726
R3744 wind_comp_0.sg13g2_and2_2$1_0.VSS.n1359 wind_comp_0.sg13g2_and2_2$1_0.VSS.t253 3.64726
R3745 wind_comp_0.sg13g2_and2_2$1_0.VSS.n1363 wind_comp_0.sg13g2_and2_2$1_0.VSS.t256 3.64726
R3746 wind_comp_0.sg13g2_and2_2$1_0.VSS.n1366 wind_comp_0.sg13g2_and2_2$1_0.VSS.t259 3.64726
R3747 wind_comp_0.sg13g2_and2_2$1_0.VSS.n1370 wind_comp_0.sg13g2_and2_2$1_0.VSS.t262 3.64726
R3748 wind_comp_0.sg13g2_and2_2$1_0.VSS.n1470 wind_comp_0.sg13g2_and2_2$1_0.VSS.n1372 3.64726
R3749 wind_comp_0.sg13g2_and2_2$1_0.VSS.n1500 wind_comp_0.sg13g2_and2_2$1_0.VSS.n1499 3.64726
R3750 wind_comp_0.sg13g2_and2_2$1_0.VSS.n1423 wind_comp_0.sg13g2_and2_2$1_0.VSS.t348 3.64726
R3751 wind_comp_0.sg13g2_and2_2$1_0.VSS.t79 wind_comp_0.sg13g2_and2_2$1_0.VSS.t353 3.64726
R3752 wind_comp_0.sg13g2_and2_2$1_0.VSS.t372 wind_comp_0.sg13g2_and2_2$1_0.VSS.t97 3.64726
R3753 wind_comp_0.sg13g2_and2_2$1_0.VSS.n1659 wind_comp_0.sg13g2_and2_2$1_0.VSS.t377 3.64726
R3754 wind_comp_0.sg13g2_and2_2$1_0.VSS.n967 wind_comp_0.sg13g2_and2_2$1_0.VSS.t36 3.63926
R3755 wind_comp_0.sg13g2_and2_2$1_0.VSS.n1220 wind_comp_0.sg13g2_and2_2$1_0.VSS.n259 3.63926
R3756 wind_comp_0.sg13g2_and2_2$1_0.VSS.n1205 wind_comp_0.sg13g2_and2_2$1_0.VSS.n275 3.63926
R3757 wind_comp_0.sg13g2_and2_2$1_0.VSS.n1221 wind_comp_0.sg13g2_and2_2$1_0.VSS.n258 3.63926
R3758 wind_comp_0.sg13g2_and2_2$1_0.VSS.n1222 wind_comp_0.sg13g2_and2_2$1_0.VSS.n257 3.63926
R3759 wind_comp_0.sg13g2_and2_2$1_0.VSS.n1203 wind_comp_0.sg13g2_and2_2$1_0.VSS.n277 3.63926
R3760 wind_comp_0.sg13g2_and2_2$1_0.VSS.n1223 wind_comp_0.sg13g2_and2_2$1_0.VSS.n256 3.63926
R3761 wind_comp_0.sg13g2_and2_2$1_0.VSS.n1202 wind_comp_0.sg13g2_and2_2$1_0.VSS.n278 3.63926
R3762 wind_comp_0.sg13g2_and2_2$1_0.VSS.n1224 wind_comp_0.sg13g2_and2_2$1_0.VSS.n255 3.63926
R3763 wind_comp_0.sg13g2_and2_2$1_0.VSS.n1225 wind_comp_0.sg13g2_and2_2$1_0.VSS.n254 3.63926
R3764 wind_comp_0.sg13g2_and2_2$1_0.VSS.n1200 wind_comp_0.sg13g2_and2_2$1_0.VSS.n280 3.63926
R3765 wind_comp_0.sg13g2_and2_2$1_0.VSS.t24 wind_comp_0.sg13g2_and2_2$1_0.VSS.n11 3.80033
R3766 wind_comp_0.sg13g2_and2_2$1_0.VSS.t359 wind_comp_0.sg13g2_and2_2$1_0.VSS.n434 3.53529
R3767 wind_comp_0.sg13g2_and2_2$1_0.VSS.t361 wind_comp_0.sg13g2_and2_2$1_0.VSS.n443 3.53529
R3768 wind_comp_0.sg13g2_and2_2$1_0.VSS.t283 wind_comp_0.sg13g2_and2_2$1_0.VSS.n262 3.53529
R3769 wind_comp_0.sg13g2_and2_2$1_0.VSS.t285 wind_comp_0.sg13g2_and2_2$1_0.VSS.n276 3.53529
R3770 wind_comp_0.sg13g2_and2_2$1_0.VSS.n1500 wind_comp_0.sg13g2_and2_2$1_0.VSS.n492 3.43275
R3771 wind_comp_0.sg13g2_and2_2$1_0.VSS.n601 wind_comp_0.sg13g2_and2_2$1_0.VSS.n1599 3.43275
R3772 wind_comp_0.sg13g2_and2_2$1_0.VSS.n600 wind_comp_0.sg13g2_and2_2$1_0.VSS.n1597 3.43275
R3773 wind_comp_0.sg13g2_and2_2$1_0.VSS.n599 wind_comp_0.sg13g2_and2_2$1_0.VSS.n1609 3.43275
R3774 wind_comp_0.sg13g2_and2_2$1_0.VSS.n597 wind_comp_0.sg13g2_and2_2$1_0.VSS.n1607 3.43275
R3775 wind_comp_0.sg13g2_and2_2$1_0.VSS.n1648 wind_comp_0.sg13g2_and2_2$1_0.VSS.n1155 3.43275
R3776 wind_comp_0.sg13g2_and2_2$1_0.VSS.t299 wind_comp_0.sg13g2_and2_2$1_0.VSS.n1151 3.43275
R3777 wind_comp_0.sg13g2_and2_2$1_0.VSS.n581 wind_comp_0.sg13g2_and2_2$1_0.VSS.n1657 3.43275
R3778 wind_comp_0.sg13g2_and2_2$1_0.VSS.n566 wind_comp_0.sg13g2_and2_2$1_0.VSS.n1119 3.43275
R3779 wind_comp_0.sg13g2_and2_2$1_0.VSS.n563 wind_comp_0.sg13g2_and2_2$1_0.VSS.n1112 3.43275
R3780 wind_comp_0.sg13g2_and2_2$1_0.VSS.n560 wind_comp_0.sg13g2_and2_2$1_0.VSS.n1107 3.43275
R3781 wind_comp_0.sg13g2_and2_2$1_0.VSS.n559 wind_comp_0.sg13g2_and2_2$1_0.VSS.n1104 3.43275
R3782 wind_comp_0.sg13g2_and2_2$1_0.VSS.n557 wind_comp_0.sg13g2_and2_2$1_0.VSS.n1100 3.43275
R3783 wind_comp_0.sg13g2_and2_2$1_0.VSS.n556 wind_comp_0.sg13g2_and2_2$1_0.VSS.n1099 3.43275
R3784 wind_comp_0.sg13g2_and2_2$1_0.VSS.n554 wind_comp_0.sg13g2_and2_2$1_0.VSS.n1095 3.43275
R3785 wind_comp_0.sg13g2_and2_2$1_0.VSS.n553 wind_comp_0.sg13g2_and2_2$1_0.VSS.n1092 3.43275
R3786 wind_comp_0.sg13g2_and2_2$1_0.VSS.n550 wind_comp_0.sg13g2_and2_2$1_0.VSS.n1087 3.43275
R3787 wind_comp_0.sg13g2_and2_2$1_0.VSS.n547 wind_comp_0.sg13g2_and2_2$1_0.VSS.n1080 3.43275
R3788 wind_comp_0.sg13g2_and2_2$1_0.VSS.n544 wind_comp_0.sg13g2_and2_2$1_0.VSS.n1075 3.43275
R3789 wind_comp_0.sg13g2_and2_2$1_0.VSS.n542 wind_comp_0.sg13g2_and2_2$1_0.VSS.n1071 3.43275
R3790 wind_comp_0.sg13g2_and2_2$1_0.VSS.n539 wind_comp_0.sg13g2_and2_2$1_0.VSS.n1067 3.43275
R3791 wind_comp_0.sg13g2_and2_2$1_0.VSS.n536 wind_comp_0.sg13g2_and2_2$1_0.VSS.n1064 3.43275
R3792 wind_comp_0.sg13g2_and2_2$1_0.VSS.n535 wind_comp_0.sg13g2_and2_2$1_0.VSS.n1063 3.43275
R3793 wind_comp_0.sg13g2_and2_2$1_0.VSS.n533 wind_comp_0.sg13g2_and2_2$1_0.VSS.n1061 3.43275
R3794 wind_comp_0.sg13g2_and2_2$1_0.VSS.n530 wind_comp_0.sg13g2_and2_2$1_0.VSS.n1060 3.43275
R3795 wind_comp_0.sg13g2_and2_2$1_0.VSS.n1220 wind_comp_0.sg13g2_and2_2$1_0.VSS.n274 3.43133
R3796 wind_comp_0.sg13g2_and2_2$1_0.VSS.n1205 wind_comp_0.sg13g2_and2_2$1_0.VSS.n259 3.43133
R3797 wind_comp_0.sg13g2_and2_2$1_0.VSS.n1221 wind_comp_0.sg13g2_and2_2$1_0.VSS.n275 3.43133
R3798 wind_comp_0.sg13g2_and2_2$1_0.VSS.n1204 wind_comp_0.sg13g2_and2_2$1_0.VSS.n258 3.43133
R3799 wind_comp_0.sg13g2_and2_2$1_0.VSS.n1222 wind_comp_0.sg13g2_and2_2$1_0.VSS.n276 3.43133
R3800 wind_comp_0.sg13g2_and2_2$1_0.VSS.n1203 wind_comp_0.sg13g2_and2_2$1_0.VSS.n257 3.43133
R3801 wind_comp_0.sg13g2_and2_2$1_0.VSS.n1223 wind_comp_0.sg13g2_and2_2$1_0.VSS.n277 3.43133
R3802 wind_comp_0.sg13g2_and2_2$1_0.VSS.n1202 wind_comp_0.sg13g2_and2_2$1_0.VSS.n256 3.43133
R3803 wind_comp_0.sg13g2_and2_2$1_0.VSS.n1224 wind_comp_0.sg13g2_and2_2$1_0.VSS.n278 3.43133
R3804 wind_comp_0.sg13g2_and2_2$1_0.VSS.n1201 wind_comp_0.sg13g2_and2_2$1_0.VSS.n255 3.43133
R3805 wind_comp_0.sg13g2_and2_2$1_0.VSS.n1225 wind_comp_0.sg13g2_and2_2$1_0.VSS.n279 3.43133
R3806 wind_comp_0.sg13g2_and2_2$1_0.VSS.n1200 wind_comp_0.sg13g2_and2_2$1_0.VSS.n254 3.43133
R3807 wind_comp_0.sg13g2_and2_2$1_0.VSS.t201 wind_comp_0.sg13g2_and2_2$1_0.VSS.n101 0.89503
R3808 wind_comp_0.sg13g2_and2_2$1_0.VSS.n85 wind_comp_0.sg13g2_and2_2$1_0.VSS.n281 2.83186
R3809 wind_comp_0.sg13g2_and2_2$1_0.VSS.n73 wind_comp_0.sg13g2_and2_2$1_0.VSS.n81 0.00524865
R3810 wind_comp_0.sg13g2_and2_2$1_0.VSS.n79 wind_comp_0.sg13g2_and2_2$1_0.VSS.n876 3.39452
R3811 wind_comp_0.sg13g2_and2_2$1_0.VSS.n1486 wind_comp_0.sg13g2_and2_2$1_0.VSS.n70 3.35683
R3812 wind_comp_0.sg13g2_and2_2$1_0.VSS.n532 wind_comp_0.sg13g2_and2_2$1_0.VSS.n922 3.32736
R3813 wind_comp_0.sg13g2_and2_2$1_0.VSS.n80 wind_comp_0.sg13g2_and2_2$1_0.VSS.t12 5.26595
R3814 wind_comp_0.sg13g2_and2_2$1_0.VSS.n1463 wind_comp_0.sg13g2_and2_2$1_0.VSS.n1462 3.21823
R3815 wind_comp_0.sg13g2_and2_2$1_0.VSS.n1376 wind_comp_0.sg13g2_and2_2$1_0.VSS.n474 3.21823
R3816 wind_comp_0.sg13g2_and2_2$1_0.VSS.n1377 wind_comp_0.sg13g2_and2_2$1_0.VSS.n475 3.21823
R3817 wind_comp_0.sg13g2_and2_2$1_0.VSS.n1381 wind_comp_0.sg13g2_and2_2$1_0.VSS.n477 3.21823
R3818 wind_comp_0.sg13g2_and2_2$1_0.VSS.n1382 wind_comp_0.sg13g2_and2_2$1_0.VSS.n478 3.21823
R3819 wind_comp_0.sg13g2_and2_2$1_0.VSS.n1386 wind_comp_0.sg13g2_and2_2$1_0.VSS.n480 3.21823
R3820 wind_comp_0.sg13g2_and2_2$1_0.VSS.n1387 wind_comp_0.sg13g2_and2_2$1_0.VSS.n481 3.21823
R3821 wind_comp_0.sg13g2_and2_2$1_0.VSS.n1388 wind_comp_0.sg13g2_and2_2$1_0.VSS.n482 3.21823
R3822 wind_comp_0.sg13g2_and2_2$1_0.VSS.t336 wind_comp_0.sg13g2_and2_2$1_0.VSS.n484 3.21823
R3823 wind_comp_0.sg13g2_and2_2$1_0.VSS.n1396 wind_comp_0.sg13g2_and2_2$1_0.VSS.n485 3.21823
R3824 wind_comp_0.sg13g2_and2_2$1_0.VSS.t339 wind_comp_0.sg13g2_and2_2$1_0.VSS.n486 3.21823
R3825 wind_comp_0.sg13g2_and2_2$1_0.VSS.n1564 wind_comp_0.sg13g2_and2_2$1_0.VSS.n1523 3.21823
R3826 wind_comp_0.sg13g2_and2_2$1_0.VSS.n1414 wind_comp_0.sg13g2_and2_2$1_0.VSS.n1412 3.21823
R3827 wind_comp_0.sg13g2_and2_2$1_0.VSS.n210 wind_comp_0.sg13g2_and2_2$1_0.VSS.n1281 4.22738
R3828 wind_comp_0.sg13g2_and2_2$1_0.VSS.n211 wind_comp_0.sg13g2_and2_2$1_0.VSS.n1286 4.22738
R3829 wind_comp_0.sg13g2_and2_2$1_0.VSS.t160 wind_comp_0.sg13g2_and2_2$1_0.VSS.n1289 3.21823
R3830 wind_comp_0.sg13g2_and2_2$1_0.VSS.n1290 wind_comp_0.sg13g2_and2_2$1_0.VSS.n1288 3.21823
R3831 wind_comp_0.sg13g2_and2_2$1_0.VSS.n356 wind_comp_0.sg13g2_and2_2$1_0.VSS.n1291 3.54241
R3832 wind_comp_0.sg13g2_and2_2$1_0.VSS.n1302 wind_comp_0.sg13g2_and2_2$1_0.VSS.t84 3.21823
R3833 wind_comp_0.sg13g2_and2_2$1_0.VSS.n1585 wind_comp_0.sg13g2_and2_2$1_0.VSS.t328 3.21823
R3834 wind_comp_0.sg13g2_and2_2$1_0.VSS.n2529 wind_comp_0.sg13g2_and2_2$1_0.VSS.n2528 3.21823
R3835 wind_comp_0.sg13g2_and2_2$1_0.VSS.n566 wind_comp_0.sg13g2_and2_2$1_0.VSS.t386 3.21823
R3836 wind_comp_0.sg13g2_and2_2$1_0.VSS.n565 wind_comp_0.sg13g2_and2_2$1_0.VSS.n424 3.21823
R3837 wind_comp_0.sg13g2_and2_2$1_0.VSS.n563 wind_comp_0.sg13g2_and2_2$1_0.VSS.t389 3.21823
R3838 wind_comp_0.sg13g2_and2_2$1_0.VSS.n560 wind_comp_0.sg13g2_and2_2$1_0.VSS.n402 3.21823
R3839 wind_comp_0.sg13g2_and2_2$1_0.VSS.n559 wind_comp_0.sg13g2_and2_2$1_0.VSS.n422 3.21823
R3840 wind_comp_0.sg13g2_and2_2$1_0.VSS.n558 wind_comp_0.sg13g2_and2_2$1_0.VSS.n403 3.21823
R3841 wind_comp_0.sg13g2_and2_2$1_0.VSS.n556 wind_comp_0.sg13g2_and2_2$1_0.VSS.n404 3.21823
R3842 wind_comp_0.sg13g2_and2_2$1_0.VSS.n555 wind_comp_0.sg13g2_and2_2$1_0.VSS.n420 3.21823
R3843 wind_comp_0.sg13g2_and2_2$1_0.VSS.n553 wind_comp_0.sg13g2_and2_2$1_0.VSS.n419 3.21823
R3844 wind_comp_0.sg13g2_and2_2$1_0.VSS.n552 wind_comp_0.sg13g2_and2_2$1_0.VSS.n406 3.21823
R3845 wind_comp_0.sg13g2_and2_2$1_0.VSS.t326 wind_comp_0.sg13g2_and2_2$1_0.VSS.n1583 3.08517
R3846 wind_comp_0.sg13g2_and2_2$1_0.VSS.n1213 wind_comp_0.sg13g2_and2_2$1_0.VSS.n267 3.01547
R3847 wind_comp_0.sg13g2_and2_2$1_0.VSS.n1214 wind_comp_0.sg13g2_and2_2$1_0.VSS.n266 3.01547
R3848 wind_comp_0.sg13g2_and2_2$1_0.VSS.n1215 wind_comp_0.sg13g2_and2_2$1_0.VSS.n265 3.01547
R3849 wind_comp_0.sg13g2_and2_2$1_0.VSS.n1211 wind_comp_0.sg13g2_and2_2$1_0.VSS.n269 3.01547
R3850 wind_comp_0.sg13g2_and2_2$1_0.VSS.n1216 wind_comp_0.sg13g2_and2_2$1_0.VSS.n264 3.01547
R3851 wind_comp_0.sg13g2_and2_2$1_0.VSS.n1210 wind_comp_0.sg13g2_and2_2$1_0.VSS.n270 3.01547
R3852 wind_comp_0.sg13g2_and2_2$1_0.VSS.n1217 wind_comp_0.sg13g2_and2_2$1_0.VSS.n263 3.01547
R3853 wind_comp_0.sg13g2_and2_2$1_0.VSS.n1209 wind_comp_0.sg13g2_and2_2$1_0.VSS.n271 3.01547
R3854 wind_comp_0.sg13g2_and2_2$1_0.VSS.n1218 wind_comp_0.sg13g2_and2_2$1_0.VSS.n262 3.01547
R3855 wind_comp_0.sg13g2_and2_2$1_0.VSS.n1208 wind_comp_0.sg13g2_and2_2$1_0.VSS.n272 3.01547
R3856 wind_comp_0.sg13g2_and2_2$1_0.VSS.n1219 wind_comp_0.sg13g2_and2_2$1_0.VSS.n261 3.01547
R3857 wind_comp_0.sg13g2_and2_2$1_0.VSS.n1207 wind_comp_0.sg13g2_and2_2$1_0.VSS.n273 3.01547
R3858 wind_comp_0.sg13g2_and2_2$1_0.VSS.n1442 wind_comp_0.sg13g2_and2_2$1_0.VSS.t265 3.00372
R3859 wind_comp_0.sg13g2_and2_2$1_0.VSS.n1374 wind_comp_0.sg13g2_and2_2$1_0.VSS.n1373 3.00372
R3860 wind_comp_0.sg13g2_and2_2$1_0.VSS.n1473 wind_comp_0.sg13g2_and2_2$1_0.VSS.n1376 3.00372
R3861 wind_comp_0.sg13g2_and2_2$1_0.VSS.n1379 wind_comp_0.sg13g2_and2_2$1_0.VSS.n1378 3.00372
R3862 wind_comp_0.sg13g2_and2_2$1_0.VSS.n1381 wind_comp_0.sg13g2_and2_2$1_0.VSS.n1380 3.00372
R3863 wind_comp_0.sg13g2_and2_2$1_0.VSS.n1384 wind_comp_0.sg13g2_and2_2$1_0.VSS.n1383 3.00372
R3864 wind_comp_0.sg13g2_and2_2$1_0.VSS.n1386 wind_comp_0.sg13g2_and2_2$1_0.VSS.n1385 3.00372
R3865 wind_comp_0.sg13g2_and2_2$1_0.VSS.n1436 wind_comp_0.sg13g2_and2_2$1_0.VSS.n1387 3.00372
R3866 wind_comp_0.sg13g2_and2_2$1_0.VSS.n1390 wind_comp_0.sg13g2_and2_2$1_0.VSS.n1389 3.00372
R3867 wind_comp_0.sg13g2_and2_2$1_0.VSS.n1392 wind_comp_0.sg13g2_and2_2$1_0.VSS.n1391 3.00372
R3868 wind_comp_0.sg13g2_and2_2$1_0.VSS.n1394 wind_comp_0.sg13g2_and2_2$1_0.VSS.n1393 3.00372
R3869 wind_comp_0.sg13g2_and2_2$1_0.VSS.n1398 wind_comp_0.sg13g2_and2_2$1_0.VSS.n1397 3.00372
R3870 wind_comp_0.sg13g2_and2_2$1_0.VSS.n1432 wind_comp_0.sg13g2_and2_2$1_0.VSS.t341 3.00372
R3871 wind_comp_0.sg13g2_and2_2$1_0.VSS.n1564 wind_comp_0.sg13g2_and2_2$1_0.VSS.n1524 3.00372
R3872 wind_comp_0.sg13g2_and2_2$1_0.VSS.n2517 wind_comp_0.sg13g2_and2_2$1_0.VSS.n1596 3.00372
R3873 wind_comp_0.sg13g2_and2_2$1_0.VSS.n604 wind_comp_0.sg13g2_and2_2$1_0.VSS.n1591 3.00372
R3874 wind_comp_0.sg13g2_and2_2$1_0.VSS.n603 wind_comp_0.sg13g2_and2_2$1_0.VSS.n1592 3.00372
R3875 wind_comp_0.sg13g2_and2_2$1_0.VSS.n602 wind_comp_0.sg13g2_and2_2$1_0.VSS.n1816 3.00372
R3876 wind_comp_0.sg13g2_and2_2$1_0.VSS.t384 wind_comp_0.sg13g2_and2_2$1_0.VSS.n1120 3.00372
R3877 wind_comp_0.sg13g2_and2_2$1_0.VSS.n567 wind_comp_0.sg13g2_and2_2$1_0.VSS.n1667 3.00372
R3878 wind_comp_0.sg13g2_and2_2$1_0.VSS.t390 wind_comp_0.sg13g2_and2_2$1_0.VSS.n1108 3.00372
R3879 wind_comp_0.sg13g2_and2_2$1_0.VSS.n1627 wind_comp_0.sg13g2_and2_2$1_0.VSS.n1088 3.00372
R3880 wind_comp_0.sg13g2_and2_2$1_0.VSS.n121 wind_comp_0.sg13g2_and2_2$1_0.VSS.n1206 3.00271
R3881 wind_comp_0.sg13g2_and2_2$1_0.VSS.n128 wind_comp_0.sg13g2_and2_2$1_0.VSS.n951 3.00271
R3882 wind_comp_0.sg13g2_and2_2$1_0.VSS.n1583 wind_comp_0.sg13g2_and2_2$1_0.VSS.n121 2.92343
R3883 wind_comp_0.sg13g2_and2_2$1_0.VSS.n4 wind_comp_0.sg13g2_and2_2$1_0.VSS.n245 2.91532
R3884 wind_comp_0.sg13g2_and2_2$1_0.VSS.n1520 wind_comp_0.sg13g2_and2_2$1_0.VSS.t407 2.89646
R3885 wind_comp_0.sg13g2_and2_2$1_0.VSS.n1285 wind_comp_0.sg13g2_and2_2$1_0.VSS.t409 2.89646
R3886 wind_comp_0.sg13g2_and2_2$1_0.VSS.t394 wind_comp_0.sg13g2_and2_2$1_0.VSS.n1590 2.89646
R3887 wind_comp_0.sg13g2_and2_2$1_0.VSS.t412 wind_comp_0.sg13g2_and2_2$1_0.VSS.n1603 2.89646
R3888 wind_comp_0.sg13g2_and2_2$1_0.VSS.n588 wind_comp_0.sg13g2_and2_2$1_0.VSS.t405 2.89646
R3889 wind_comp_0.sg13g2_and2_2$1_0.VSS.n1485 wind_comp_0.sg13g2_and2_2$1_0.VSS.n1484 2.7892
R3890 wind_comp_0.sg13g2_and2_2$1_0.VSS.n1434 wind_comp_0.sg13g2_and2_2$1_0.VSS.n1390 2.7892
R3891 wind_comp_0.sg13g2_and2_2$1_0.VSS.n1493 wind_comp_0.sg13g2_and2_2$1_0.VSS.t339 2.7892
R3892 wind_comp_0.sg13g2_and2_2$1_0.VSS.t342 wind_comp_0.sg13g2_and2_2$1_0.VSS.n487 2.7892
R3893 wind_comp_0.sg13g2_and2_2$1_0.VSS.t345 wind_comp_0.sg13g2_and2_2$1_0.VSS.n490 2.7892
R3894 wind_comp_0.sg13g2_and2_2$1_0.VSS.t348 wind_comp_0.sg13g2_and2_2$1_0.VSS.n493 2.7892
R3895 wind_comp_0.sg13g2_and2_2$1_0.VSS.t399 wind_comp_0.sg13g2_and2_2$1_0.VSS.n207 3.13311
R3896 wind_comp_0.sg13g2_and2_2$1_0.VSS.n297 wind_comp_0.sg13g2_and2_2$1_0.VSS.n1294 3.14675
R3897 wind_comp_0.sg13g2_and2_2$1_0.VSS.n1298 wind_comp_0.sg13g2_and2_2$1_0.VSS.n1296 2.7892
R3898 wind_comp_0.sg13g2_and2_2$1_0.VSS.n205 wind_comp_0.sg13g2_and2_2$1_0.VSS.n1299 3.90781
R3899 wind_comp_0.sg13g2_and2_2$1_0.VSS.n1302 wind_comp_0.sg13g2_and2_2$1_0.VSS.t248 2.7892
R3900 wind_comp_0.sg13g2_and2_2$1_0.VSS.n1927 wind_comp_0.sg13g2_and2_2$1_0.VSS.n204 3.90781
R3901 wind_comp_0.sg13g2_and2_2$1_0.VSS.t401 wind_comp_0.sg13g2_and2_2$1_0.VSS.n1602 2.7892
R3902 wind_comp_0.sg13g2_and2_2$1_0.VSS.n1677 wind_comp_0.sg13g2_and2_2$1_0.VSS.n423 2.7892
R3903 wind_comp_0.sg13g2_and2_2$1_0.VSS.n193 wind_comp_0.sg13g2_and2_2$1_0.VSS.n2546 2.72667
R3904 wind_comp_0.sg13g2_and2_2$1_0.VSS.n193 wind_comp_0.sg13g2_and2_2$1_0.VSS.n2539 2.72667
R3905 wind_comp_0.sg13g2_and2_2$1_0.VSS.n193 wind_comp_0.sg13g2_and2_2$1_0.VSS.n2531 2.72667
R3906 wind_comp_0.sg13g2_and2_2$1_0.VSS.n193 wind_comp_0.sg13g2_and2_2$1_0.VSS.n2532 2.72667
R3907 wind_comp_0.sg13g2_and2_2$1_0.VSS.n2563 wind_comp_0.sg13g2_and2_2$1_0.VSS.n1309 2.72667
R3908 wind_comp_0.sg13g2_and2_2$1_0.VSS.n2563 wind_comp_0.sg13g2_and2_2$1_0.VSS.n1310 2.72667
R3909 wind_comp_0.sg13g2_and2_2$1_0.VSS.n2563 wind_comp_0.sg13g2_and2_2$1_0.VSS.n2562 2.72667
R3910 wind_comp_0.sg13g2_and2_2$1_0.VSS.n2563 wind_comp_0.sg13g2_and2_2$1_0.VSS.n2555 2.72667
R3911 wind_comp_0.sg13g2_and2_2$1_0.VSS.t403 wind_comp_0.sg13g2_and2_2$1_0.VSS.n1514 2.68194
R3912 wind_comp_0.sg13g2_and2_2$1_0.VSS.t392 wind_comp_0.sg13g2_and2_2$1_0.VSS.n1198 2.68194
R3913 wind_comp_0.sg13g2_and2_2$1_0.VSS.t158 wind_comp_0.sg13g2_and2_2$1_0.VSS.n1451 2.57469
R3914 wind_comp_0.sg13g2_and2_2$1_0.VSS.n1442 wind_comp_0.sg13g2_and2_2$1_0.VSS.n472 2.57469
R3915 wind_comp_0.sg13g2_and2_2$1_0.VSS.t67 wind_comp_0.sg13g2_and2_2$1_0.VSS.n483 2.57469
R3916 wind_comp_0.sg13g2_and2_2$1_0.VSS.t395 wind_comp_0.sg13g2_and2_2$1_0.VSS.n1515 2.57469
R3917 wind_comp_0.sg13g2_and2_2$1_0.VSS.n571 wind_comp_0.sg13g2_and2_2$1_0.VSS.n1634 2.57469
R3918 wind_comp_0.sg13g2_and2_2$1_0.VSS.n1634 wind_comp_0.sg13g2_and2_2$1_0.VSS.n1127 2.57469
R3919 wind_comp_0.sg13g2_and2_2$1_0.VSS.t387 wind_comp_0.sg13g2_and2_2$1_0.VSS.t112 2.57469
R3920 wind_comp_0.sg13g2_and2_2$1_0.VSS.n562 wind_comp_0.sg13g2_and2_2$1_0.VSS.n1631 2.57469
R3921 wind_comp_0.sg13g2_and2_2$1_0.VSS.n562 wind_comp_0.sg13g2_and2_2$1_0.VSS.t119 2.57469
R3922 wind_comp_0.sg13g2_and2_2$1_0.VSS.n1678 wind_comp_0.sg13g2_and2_2$1_0.VSS.n1103 2.57469
R3923 wind_comp_0.sg13g2_and2_2$1_0.VSS.n550 wind_comp_0.sg13g2_and2_2$1_0.VSS.n1686 2.57469
R3924 wind_comp_0.sg13g2_and2_2$1_0.VSS.n538 wind_comp_0.sg13g2_and2_2$1_0.VSS.n1692 2.57469
R3925 wind_comp_0.sg13g2_and2_2$1_0.VSS.t12 wind_comp_0.sg13g2_and2_2$1_0.VSS.n426 2.49565
R3926 wind_comp_0.sg13g2_and2_2$1_0.VSS.t8 wind_comp_0.sg13g2_and2_2$1_0.VSS.n267 2.49565
R3927 wind_comp_0.sg13g2_and2_2$1_0.VSS.t24 wind_comp_0.sg13g2_and2_2$1_0.VSS.n280 2.49565
R3928 wind_comp_0.sg13g2_and2_2$1_0.VSS.n356 wind_comp_0.sg13g2_and2_2$1_0.VSS.n1292 2.58915
R3929 wind_comp_0.sg13g2_and2_2$1_0.VSS.n124 wind_comp_0.sg13g2_and2_2$1_0.VSS.n1271 2.36342
R3930 wind_comp_0.sg13g2_and2_2$1_0.VSS.n101 wind_comp_0.sg13g2_and2_2$1_0.VSS.n1613 2.36337
R3931 wind_comp_0.sg13g2_and2_2$1_0.VSS.n1466 wind_comp_0.sg13g2_and2_2$1_0.VSS.n1368 2.36017
R3932 wind_comp_0.sg13g2_and2_2$1_0.VSS.n1498 wind_comp_0.sg13g2_and2_2$1_0.VSS.n1497 2.36017
R3933 wind_comp_0.sg13g2_and2_2$1_0.VSS.n1419 wind_comp_0.sg13g2_and2_2$1_0.VSS.t351 2.36017
R3934 wind_comp_0.sg13g2_and2_2$1_0.VSS.n1298 wind_comp_0.sg13g2_and2_2$1_0.VSS.t163 2.36017
R3935 wind_comp_0.sg13g2_and2_2$1_0.VSS.n1658 wind_comp_0.sg13g2_and2_2$1_0.VSS.t374 2.36017
R3936 wind_comp_0.sg13g2_and2_2$1_0.VSS.t291 wind_comp_0.sg13g2_and2_2$1_0.VSS.n1625 2.36017
R3937 wind_comp_0.sg13g2_and2_2$1_0.VSS.n206 wind_comp_0.sg13g2_and2_2$1_0.VSS.n70 1.78981
R3938 wind_comp_0.sg13g2_and2_2$1_0.VSS.n945 wind_comp_0.sg13g2_and2_2$1_0.VSS.t359 2.18375
R3939 wind_comp_0.sg13g2_and2_2$1_0.VSS.n1448 wind_comp_0.sg13g2_and2_2$1_0.VSS.t55 2.14566
R3940 wind_comp_0.sg13g2_and2_2$1_0.VSS.n1596 wind_comp_0.sg13g2_and2_2$1_0.VSS.n1196 2.14566
R3941 wind_comp_0.sg13g2_and2_2$1_0.VSS.n1590 wind_comp_0.sg13g2_and2_2$1_0.VSS.n1195 2.14566
R3942 wind_comp_0.sg13g2_and2_2$1_0.VSS.n1591 wind_comp_0.sg13g2_and2_2$1_0.VSS.n1192 2.14566
R3943 wind_comp_0.sg13g2_and2_2$1_0.VSS.n1592 wind_comp_0.sg13g2_and2_2$1_0.VSS.n1191 2.14566
R3944 wind_comp_0.sg13g2_and2_2$1_0.VSS.n1816 wind_comp_0.sg13g2_and2_2$1_0.VSS.n1188 2.14566
R3945 wind_comp_0.sg13g2_and2_2$1_0.VSS.n598 wind_comp_0.sg13g2_and2_2$1_0.VSS.t398 2.14566
R3946 wind_comp_0.sg13g2_and2_2$1_0.VSS.t397 wind_comp_0.sg13g2_and2_2$1_0.VSS.n1160 2.14566
R3947 wind_comp_0.sg13g2_and2_2$1_0.VSS.n578 wind_comp_0.sg13g2_and2_2$1_0.VSS.n1658 2.14566
R3948 wind_comp_0.sg13g2_and2_2$1_0.VSS.n574 wind_comp_0.sg13g2_and2_2$1_0.VSS.n1135 2.14566
R3949 wind_comp_0.sg13g2_and2_2$1_0.VSS.n573 wind_comp_0.sg13g2_and2_2$1_0.VSS.n1132 2.14566
R3950 wind_comp_0.sg13g2_and2_2$1_0.VSS.n571 wind_comp_0.sg13g2_and2_2$1_0.VSS.n1128 2.14566
R3951 wind_comp_0.sg13g2_and2_2$1_0.VSS.n570 wind_comp_0.sg13g2_and2_2$1_0.VSS.n1127 2.14566
R3952 wind_comp_0.sg13g2_and2_2$1_0.VSS.n568 wind_comp_0.sg13g2_and2_2$1_0.VSS.n1123 2.14566
R3953 wind_comp_0.sg13g2_and2_2$1_0.VSS.n1633 wind_comp_0.sg13g2_and2_2$1_0.VSS.n1116 2.14566
R3954 wind_comp_0.sg13g2_and2_2$1_0.VSS.n1691 wind_comp_0.sg13g2_and2_2$1_0.VSS.n1069 2.14566
R3955 wind_comp_0.sg13g2_and2_2$1_0.VSS.n83 wind_comp_0.sg13g2_and2_2$1_0.VSS.n1599 2.12716
R3956 wind_comp_0.sg13g2_and2_2$1_0.VSS.n70 wind_comp_0.sg13g2_and2_2$1_0.VSS.n297 1.57296
R3957 wind_comp_0.sg13g2_and2_2$1_0.VSS.n68 wind_comp_0.comparator_1.dynamic_pcell$1_0.VSS 2.1255
R3958 wind_comp_0.sg13g2_and2_2$1_0.VSS.n1260 wind_comp_0.sg13g2_and2_2$1_0.VSS.n72 0.894784
R3959 wind_comp_0.sg13g2_and2_2$1_0.VSS.n83 wind_comp_0.sg13g2_and2_2$1_0.VSS.n1593 2.11226
R3960 wind_comp_0.sg13g2_and2_2$1_0.VSS.n70 wind_comp_0.sg13g2_and2_2$1_0.VSS.n1293 2.11207
R3961 wind_comp_0.sg13g2_and2_2$1_0.VSS.n1541 wind_comp_0.sg13g2_and2_2$1_0.VSS.n1540 2.09363
R3962 wind_comp_0.sg13g2_and2_2$1_0.VSS.n8 wind_comp_0.sg13g2_and2_2$1_0.VSS.n702 2.0795
R3963 wind_comp_0.sg13g2_and2_2$1_0.VSS.n1201 wind_comp_0.sg13g2_and2_2$1_0.VSS.t21 1.97583
R3964 wind_comp_0.sg13g2_and2_2$1_0.VSS.t154 wind_comp_0.sg13g2_and2_2$1_0.VSS.n455 1.93114
R3965 wind_comp_0.sg13g2_and2_2$1_0.VSS.n1314 wind_comp_0.sg13g2_and2_2$1_0.VSS.n456 1.93114
R3966 wind_comp_0.sg13g2_and2_2$1_0.VSS.n1355 wind_comp_0.sg13g2_and2_2$1_0.VSS.n457 1.93114
R3967 wind_comp_0.sg13g2_and2_2$1_0.VSS.n1359 wind_comp_0.sg13g2_and2_2$1_0.VSS.n460 1.93114
R3968 wind_comp_0.sg13g2_and2_2$1_0.VSS.t254 wind_comp_0.sg13g2_and2_2$1_0.VSS.n461 1.93114
R3969 wind_comp_0.sg13g2_and2_2$1_0.VSS.n1363 wind_comp_0.sg13g2_and2_2$1_0.VSS.n463 1.93114
R3970 wind_comp_0.sg13g2_and2_2$1_0.VSS.t257 wind_comp_0.sg13g2_and2_2$1_0.VSS.n464 1.93114
R3971 wind_comp_0.sg13g2_and2_2$1_0.VSS.n1364 wind_comp_0.sg13g2_and2_2$1_0.VSS.n465 1.93114
R3972 wind_comp_0.sg13g2_and2_2$1_0.VSS.n1366 wind_comp_0.sg13g2_and2_2$1_0.VSS.n466 1.93114
R3973 wind_comp_0.sg13g2_and2_2$1_0.VSS.t260 wind_comp_0.sg13g2_and2_2$1_0.VSS.n467 1.93114
R3974 wind_comp_0.sg13g2_and2_2$1_0.VSS.n1466 wind_comp_0.sg13g2_and2_2$1_0.VSS.t0 1.93114
R3975 wind_comp_0.sg13g2_and2_2$1_0.VSS.n1368 wind_comp_0.sg13g2_and2_2$1_0.VSS.n468 1.93114
R3976 wind_comp_0.sg13g2_and2_2$1_0.VSS.t263 wind_comp_0.sg13g2_and2_2$1_0.VSS.n470 1.93114
R3977 wind_comp_0.sg13g2_and2_2$1_0.VSS.n1372 wind_comp_0.sg13g2_and2_2$1_0.VSS.n471 1.93114
R3978 wind_comp_0.sg13g2_and2_2$1_0.VSS.t266 wind_comp_0.sg13g2_and2_2$1_0.VSS.n473 1.93114
R3979 wind_comp_0.sg13g2_and2_2$1_0.VSS.n1438 wind_comp_0.sg13g2_and2_2$1_0.VSS.n1382 1.93114
R3980 wind_comp_0.sg13g2_and2_2$1_0.VSS.t272 wind_comp_0.sg13g2_and2_2$1_0.VSS.n479 1.93114
R3981 wind_comp_0.sg13g2_and2_2$1_0.VSS.t64 wind_comp_0.sg13g2_and2_2$1_0.VSS.n1395 1.93114
R3982 wind_comp_0.sg13g2_and2_2$1_0.VSS.n1419 wind_comp_0.sg13g2_and2_2$1_0.VSS.n1417 1.93114
R3983 wind_comp_0.sg13g2_and2_2$1_0.VSS.t396 wind_comp_0.sg13g2_and2_2$1_0.VSS.n1283 1.93114
R3984 wind_comp_0.sg13g2_and2_2$1_0.VSS.n1581 wind_comp_0.sg13g2_and2_2$1_0.VSS.t6 1.93114
R3985 wind_comp_0.sg13g2_and2_2$1_0.VSS.n557 wind_comp_0.sg13g2_and2_2$1_0.VSS.t303 1.93114
R3986 wind_comp_0.sg13g2_and2_2$1_0.VSS.n551 wind_comp_0.sg13g2_and2_2$1_0.VSS.t308 1.93114
R3987 wind_comp_0.sg13g2_and2_2$1_0.VSS.n549 wind_comp_0.sg13g2_and2_2$1_0.VSS.n407 1.93114
R3988 wind_comp_0.sg13g2_and2_2$1_0.VSS.n407 wind_comp_0.sg13g2_and2_2$1_0.VSS.n1083 1.93114
R3989 wind_comp_0.sg13g2_and2_2$1_0.VSS.n548 wind_comp_0.sg13g2_and2_2$1_0.VSS.t311 1.93114
R3990 wind_comp_0.sg13g2_and2_2$1_0.VSS.t311 wind_comp_0.sg13g2_and2_2$1_0.VSS.n1080 1.93114
R3991 wind_comp_0.sg13g2_and2_2$1_0.VSS.n408 wind_comp_0.sg13g2_and2_2$1_0.VSS.n1079 1.93114
R3992 wind_comp_0.sg13g2_and2_2$1_0.VSS.n546 wind_comp_0.sg13g2_and2_2$1_0.VSS.n417 1.93114
R3993 wind_comp_0.sg13g2_and2_2$1_0.VSS.n417 wind_comp_0.sg13g2_and2_2$1_0.VSS.n1076 1.93114
R3994 wind_comp_0.sg13g2_and2_2$1_0.VSS.n545 wind_comp_0.sg13g2_and2_2$1_0.VSS.t314 1.93114
R3995 wind_comp_0.sg13g2_and2_2$1_0.VSS.t314 wind_comp_0.sg13g2_and2_2$1_0.VSS.n1075 1.93114
R3996 wind_comp_0.sg13g2_and2_2$1_0.VSS.n544 wind_comp_0.sg13g2_and2_2$1_0.VSS.n416 1.93114
R3997 wind_comp_0.sg13g2_and2_2$1_0.VSS.n416 wind_comp_0.sg13g2_and2_2$1_0.VSS.n1072 1.93114
R3998 wind_comp_0.sg13g2_and2_2$1_0.VSS.n543 wind_comp_0.sg13g2_and2_2$1_0.VSS.n409 1.93114
R3999 wind_comp_0.sg13g2_and2_2$1_0.VSS.n542 wind_comp_0.sg13g2_and2_2$1_0.VSS.t317 1.93114
R4000 wind_comp_0.sg13g2_and2_2$1_0.VSS.t317 wind_comp_0.sg13g2_and2_2$1_0.VSS.n1069 1.93114
R4001 wind_comp_0.sg13g2_and2_2$1_0.VSS.n541 wind_comp_0.sg13g2_and2_2$1_0.VSS.n410 1.93114
R4002 wind_comp_0.sg13g2_and2_2$1_0.VSS.n410 wind_comp_0.sg13g2_and2_2$1_0.VSS.n1068 1.93114
R4003 wind_comp_0.sg13g2_and2_2$1_0.VSS.n415 wind_comp_0.sg13g2_and2_2$1_0.VSS.n1067 1.93114
R4004 wind_comp_0.sg13g2_and2_2$1_0.VSS.n539 wind_comp_0.sg13g2_and2_2$1_0.VSS.t320 1.93114
R4005 wind_comp_0.sg13g2_and2_2$1_0.VSS.n538 wind_comp_0.sg13g2_and2_2$1_0.VSS.n414 1.93114
R4006 wind_comp_0.sg13g2_and2_2$1_0.VSS.n414 wind_comp_0.sg13g2_and2_2$1_0.VSS.n1065 1.93114
R4007 wind_comp_0.sg13g2_and2_2$1_0.VSS.n411 wind_comp_0.sg13g2_and2_2$1_0.VSS.n1064 1.93114
R4008 wind_comp_0.sg13g2_and2_2$1_0.VSS.n535 wind_comp_0.sg13g2_and2_2$1_0.VSS.n412 1.93114
R4009 wind_comp_0.sg13g2_and2_2$1_0.VSS.n412 wind_comp_0.sg13g2_and2_2$1_0.VSS.n1062 1.93114
R4010 wind_comp_0.sg13g2_and2_2$1_0.VSS.n534 wind_comp_0.sg13g2_and2_2$1_0.VSS.n413 1.93114
R4011 wind_comp_0.sg13g2_and2_2$1_0.VSS.n413 wind_comp_0.sg13g2_and2_2$1_0.VSS.n1061 1.93114
R4012 wind_comp_0.sg13g2_and2_2$1_0.VSS.t201 wind_comp_0.sg13g2_and2_2$1_0.VSS.n533 1.93114
R4013 wind_comp_0.sg13g2_and2_2$1_0.VSS.n70 wind_comp_0.sg13g2_and2_2$1_0.VSS.n1306 1.87344
R4014 wind_comp_0.sg13g2_and2_2$1_0.VSS.n83 wind_comp_0.sg13g2_and2_2$1_0.VSS.n1589 1.8731
R4015 wind_comp_0.sg13g2_and2_2$1_0.VSS.t289 wind_comp_0.sg13g2_and2_2$1_0.VSS.n2123 1.87176
R4016 wind_comp_0.sg13g2_and2_2$1_0.VSS.t284 wind_comp_0.sg13g2_and2_2$1_0.VSS.n2572 1.87176
R4017 wind_comp_0.sg13g2_and2_2$1_0.VSS.t365 wind_comp_0.sg13g2_and2_2$1_0.VSS.n2286 1.87176
R4018 wind_comp_0.sg13g2_and2_2$1_0.VSS.t360 wind_comp_0.sg13g2_and2_2$1_0.VSS.n2280 1.87176
R4019 wind_comp_0.sg13g2_and2_2$1_0.VSS.n1542 wind_comp_0.sg13g2_and2_2$1_0.VSS.n1541 1.8605
R4020 wind_comp_0.sg13g2_and2_2$1_0.VSS.n83 wind_comp_0.sg13g2_and2_2$1_0.VSS.n357 0.565854
R4021 wind_comp_0.sg13g2_and2_2$1_0.VSS.n353 wind_comp_0.sg13g2_and2_2$1_0.VSS.n70 0.932414
R4022 wind_comp_0.sg13g2_and2_2$1_0.VSS.n2565 wind_comp_0.sg13g2_and2_2$1_0.VSS.n70 1.84649
R4023 wind_comp_0.sg13g2_and2_2$1_0.VSS.n83 wind_comp_0.sg13g2_and2_2$1_0.VSS.n1576 1.84636
R4024 wind_comp_0.sg13g2_and2_2$1_0.VSS.t246 wind_comp_0.sg13g2_and2_2$1_0.VSS.t87 1.82388
R4025 wind_comp_0.sg13g2_and2_2$1_0.VSS.t16 wind_comp_0.sg13g2_and2_2$1_0.VSS.t392 1.82388
R4026 wind_comp_0.sg13g2_and2_2$1_0.VSS.n953 wind_comp_0.sg13g2_and2_2$1_0.VSS.n438 1.7679
R4027 wind_comp_0.sg13g2_and2_2$1_0.VSS.n954 wind_comp_0.sg13g2_and2_2$1_0.VSS.n439 1.7679
R4028 wind_comp_0.sg13g2_and2_2$1_0.VSS.n956 wind_comp_0.sg13g2_and2_2$1_0.VSS.n440 1.7679
R4029 wind_comp_0.sg13g2_and2_2$1_0.VSS.n957 wind_comp_0.sg13g2_and2_2$1_0.VSS.n441 1.7679
R4030 wind_comp_0.sg13g2_and2_2$1_0.VSS.n960 wind_comp_0.sg13g2_and2_2$1_0.VSS.n442 1.7679
R4031 wind_comp_0.sg13g2_and2_2$1_0.VSS.n960 wind_comp_0.sg13g2_and2_2$1_0.VSS.t361 1.7679
R4032 wind_comp_0.sg13g2_and2_2$1_0.VSS.n961 wind_comp_0.sg13g2_and2_2$1_0.VSS.n443 1.7679
R4033 wind_comp_0.sg13g2_and2_2$1_0.VSS.n963 wind_comp_0.sg13g2_and2_2$1_0.VSS.n444 1.7679
R4034 wind_comp_0.sg13g2_and2_2$1_0.VSS.n964 wind_comp_0.sg13g2_and2_2$1_0.VSS.n445 1.7679
R4035 wind_comp_0.sg13g2_and2_2$1_0.VSS.n965 wind_comp_0.sg13g2_and2_2$1_0.VSS.n446 1.7679
R4036 wind_comp_0.sg13g2_and2_2$1_0.VSS.n966 wind_comp_0.sg13g2_and2_2$1_0.VSS.n447 1.7679
R4037 wind_comp_0.sg13g2_and2_2$1_0.VSS.n967 wind_comp_0.sg13g2_and2_2$1_0.VSS.n448 1.7679
R4038 wind_comp_0.sg13g2_and2_2$1_0.VSS.n968 wind_comp_0.sg13g2_and2_2$1_0.VSS.n449 1.7679
R4039 wind_comp_0.sg13g2_and2_2$1_0.VSS.n969 wind_comp_0.sg13g2_and2_2$1_0.VSS.n450 1.7679
R4040 wind_comp_0.sg13g2_and2_2$1_0.VSS.n970 wind_comp_0.sg13g2_and2_2$1_0.VSS.n451 1.7679
R4041 wind_comp_0.sg13g2_and2_2$1_0.VSS.n161 wind_comp_0.sg13g2_and2_2$1_0.VSS.t32 6.26033
R4042 wind_comp_0.sg13g2_and2_2$1_0.VSS.n128 wind_comp_0.sg13g2_and2_2$1_0.VSS.n161 2.09506
R4043 wind_comp_0.comparator_0.dynamic_pcell$2_0.SRC_NET_MNO wind_comp_0.sg13g2_and2_2$1_0.VSS.n680 1.76004
R4044 wind_comp_0.sg13g2_and2_2$1_0.VSS.n2290 wind_comp_0.comparator_1.dynamic_pcell$2_0.SRC_NET_MNO 1.76004
R4045 wind_comp_0.sg13g2_and2_2$1_0.VSS.n2123 wind_comp_0.comparator_0.dynamic_pcell$2_0.SRC_NET_MNO 1.74145
R4046 wind_comp_0.sg13g2_and2_2$1_0.VSS.n2572 wind_comp_0.comparator_0.dynamic_pcell$2_0.SRC_NET_MNO 1.74145
R4047 wind_comp_0.sg13g2_and2_2$1_0.VSS.n2286 wind_comp_0.comparator_1.dynamic_pcell$2_0.SRC_NET_MNO 1.74145
R4048 wind_comp_0.sg13g2_and2_2$1_0.VSS.n2280 wind_comp_0.comparator_1.dynamic_pcell$2_0.SRC_NET_MNO 1.74145
R4049 wind_comp_0.sg13g2_and2_2$1_0.VSS.n205 wind_comp_0.sg13g2_and2_2$1_0.VSS.n1300 2.23732
R4050 wind_comp_0.sg13g2_and2_2$1_0.VSS.n204 wind_comp_0.sg13g2_and2_2$1_0.VSS.n1303 2.23732
R4051 wind_comp_0.sg13g2_and2_2$1_0.VSS.n1461 wind_comp_0.sg13g2_and2_2$1_0.VSS.n462 1.71662
R4052 wind_comp_0.sg13g2_and2_2$1_0.VSS.n1440 wind_comp_0.sg13g2_and2_2$1_0.VSS.t268 1.71662
R4053 wind_comp_0.sg13g2_and2_2$1_0.VSS.n1433 wind_comp_0.sg13g2_and2_2$1_0.VSS.t338 1.71662
R4054 wind_comp_0.sg13g2_and2_2$1_0.VSS.n1431 wind_comp_0.sg13g2_and2_2$1_0.VSS.n488 1.71662
R4055 wind_comp_0.sg13g2_and2_2$1_0.VSS.n1260 wind_comp_0.sg13g2_and2_2$1_0.VSS.n494 1.71662
R4056 wind_comp_0.sg13g2_and2_2$1_0.VSS.n1502 wind_comp_0.sg13g2_and2_2$1_0.VSS.n495 1.71662
R4057 wind_comp_0.sg13g2_and2_2$1_0.VSS.n1418 wind_comp_0.sg13g2_and2_2$1_0.VSS.n496 1.71662
R4058 wind_comp_0.sg13g2_and2_2$1_0.VSS.n1262 wind_comp_0.sg13g2_and2_2$1_0.VSS.n497 1.71662
R4059 wind_comp_0.sg13g2_and2_2$1_0.VSS.n1413 wind_comp_0.sg13g2_and2_2$1_0.VSS.n499 1.71662
R4060 wind_comp_0.sg13g2_and2_2$1_0.VSS.n1264 wind_comp_0.sg13g2_and2_2$1_0.VSS.n501 1.71662
R4061 wind_comp_0.sg13g2_and2_2$1_0.VSS.n1407 wind_comp_0.sg13g2_and2_2$1_0.VSS.n502 1.71662
R4062 wind_comp_0.sg13g2_and2_2$1_0.VSS.n1511 wind_comp_0.sg13g2_and2_2$1_0.VSS.n503 1.71662
R4063 wind_comp_0.sg13g2_and2_2$1_0.VSS.n1266 wind_comp_0.sg13g2_and2_2$1_0.VSS.n504 1.71662
R4064 wind_comp_0.sg13g2_and2_2$1_0.VSS.n1515 wind_comp_0.sg13g2_and2_2$1_0.VSS.n506 1.71662
R4065 wind_comp_0.sg13g2_and2_2$1_0.VSS.n1268 wind_comp_0.sg13g2_and2_2$1_0.VSS.n507 1.71662
R4066 wind_comp_0.sg13g2_and2_2$1_0.VSS.n1270 wind_comp_0.sg13g2_and2_2$1_0.VSS.n508 1.71662
R4067 wind_comp_0.sg13g2_and2_2$1_0.VSS.n1272 wind_comp_0.sg13g2_and2_2$1_0.VSS.n509 1.71662
R4068 wind_comp_0.sg13g2_and2_2$1_0.VSS.n1273 wind_comp_0.sg13g2_and2_2$1_0.VSS.n510 1.71662
R4069 wind_comp_0.sg13g2_and2_2$1_0.VSS.n1275 wind_comp_0.sg13g2_and2_2$1_0.VSS.n511 1.71662
R4070 wind_comp_0.sg13g2_and2_2$1_0.VSS.n1521 wind_comp_0.sg13g2_and2_2$1_0.VSS.n512 1.71662
R4071 wind_comp_0.sg13g2_and2_2$1_0.VSS.n394 wind_comp_0.sg13g2_and2_2$1_0.VSS.n1574 1.71662
R4072 wind_comp_0.sg13g2_and2_2$1_0.VSS.n393 wind_comp_0.sg13g2_and2_2$1_0.VSS.n1604 1.71662
R4073 wind_comp_0.sg13g2_and2_2$1_0.VSS.n395 wind_comp_0.sg13g2_and2_2$1_0.VSS.n1605 1.71662
R4074 wind_comp_0.sg13g2_and2_2$1_0.VSS.n363 wind_comp_0.sg13g2_and2_2$1_0.VSS.n1198 1.71662
R4075 wind_comp_0.sg13g2_and2_2$1_0.VSS.n364 wind_comp_0.sg13g2_and2_2$1_0.VSS.n1196 1.71662
R4076 wind_comp_0.sg13g2_and2_2$1_0.VSS.n366 wind_comp_0.sg13g2_and2_2$1_0.VSS.n1192 1.71662
R4077 wind_comp_0.sg13g2_and2_2$1_0.VSS.n368 wind_comp_0.sg13g2_and2_2$1_0.VSS.n1188 1.71662
R4078 wind_comp_0.sg13g2_and2_2$1_0.VSS.n1599 wind_comp_0.sg13g2_and2_2$1_0.VSS.n1187 1.71662
R4079 wind_comp_0.sg13g2_and2_2$1_0.VSS.n369 wind_comp_0.sg13g2_and2_2$1_0.VSS.n1187 1.71662
R4080 wind_comp_0.sg13g2_and2_2$1_0.VSS.n370 wind_comp_0.sg13g2_and2_2$1_0.VSS.n1184 1.71662
R4081 wind_comp_0.sg13g2_and2_2$1_0.VSS.n1609 wind_comp_0.sg13g2_and2_2$1_0.VSS.n1183 1.71662
R4082 wind_comp_0.sg13g2_and2_2$1_0.VSS.n371 wind_comp_0.sg13g2_and2_2$1_0.VSS.n1183 1.71662
R4083 wind_comp_0.sg13g2_and2_2$1_0.VSS.n1608 wind_comp_0.sg13g2_and2_2$1_0.VSS.n1180 1.71662
R4084 wind_comp_0.sg13g2_and2_2$1_0.VSS.n1607 wind_comp_0.sg13g2_and2_2$1_0.VSS.n1179 1.71662
R4085 wind_comp_0.sg13g2_and2_2$1_0.VSS.n373 wind_comp_0.sg13g2_and2_2$1_0.VSS.n1179 1.71662
R4086 wind_comp_0.sg13g2_and2_2$1_0.VSS.n374 wind_comp_0.sg13g2_and2_2$1_0.VSS.n1176 1.71662
R4087 wind_comp_0.sg13g2_and2_2$1_0.VSS.n375 wind_comp_0.sg13g2_and2_2$1_0.VSS.n1175 1.71662
R4088 wind_comp_0.sg13g2_and2_2$1_0.VSS.n593 wind_comp_0.sg13g2_and2_2$1_0.VSS.n1651 1.71662
R4089 wind_comp_0.sg13g2_and2_2$1_0.VSS.n592 wind_comp_0.sg13g2_and2_2$1_0.VSS.n376 1.71662
R4090 wind_comp_0.sg13g2_and2_2$1_0.VSS.n591 wind_comp_0.sg13g2_and2_2$1_0.VSS.n377 1.71662
R4091 wind_comp_0.sg13g2_and2_2$1_0.VSS.n590 wind_comp_0.sg13g2_and2_2$1_0.VSS.n378 1.71662
R4092 wind_comp_0.sg13g2_and2_2$1_0.VSS.n589 wind_comp_0.sg13g2_and2_2$1_0.VSS.n379 1.71662
R4093 wind_comp_0.sg13g2_and2_2$1_0.VSS.n588 wind_comp_0.sg13g2_and2_2$1_0.VSS.n380 1.71662
R4094 wind_comp_0.sg13g2_and2_2$1_0.VSS.n587 wind_comp_0.sg13g2_and2_2$1_0.VSS.n381 1.71662
R4095 wind_comp_0.sg13g2_and2_2$1_0.VSS.n585 wind_comp_0.sg13g2_and2_2$1_0.VSS.n383 1.71662
R4096 wind_comp_0.sg13g2_and2_2$1_0.VSS.n585 wind_comp_0.sg13g2_and2_2$1_0.VSS.n1648 1.71662
R4097 wind_comp_0.sg13g2_and2_2$1_0.VSS.n584 wind_comp_0.sg13g2_and2_2$1_0.VSS.n384 1.71662
R4098 wind_comp_0.sg13g2_and2_2$1_0.VSS.n583 wind_comp_0.sg13g2_and2_2$1_0.VSS.n385 1.71662
R4099 wind_comp_0.sg13g2_and2_2$1_0.VSS.n583 wind_comp_0.sg13g2_and2_2$1_0.VSS.t299 1.71662
R4100 wind_comp_0.sg13g2_and2_2$1_0.VSS.n582 wind_comp_0.sg13g2_and2_2$1_0.VSS.n386 1.71662
R4101 wind_comp_0.sg13g2_and2_2$1_0.VSS.n580 wind_comp_0.sg13g2_and2_2$1_0.VSS.n388 1.71662
R4102 wind_comp_0.sg13g2_and2_2$1_0.VSS.n578 wind_comp_0.sg13g2_and2_2$1_0.VSS.n390 1.71662
R4103 wind_comp_0.sg13g2_and2_2$1_0.VSS.n577 wind_comp_0.sg13g2_and2_2$1_0.VSS.n391 1.71662
R4104 wind_comp_0.sg13g2_and2_2$1_0.VSS.n576 wind_comp_0.sg13g2_and2_2$1_0.VSS.n392 1.71662
R4105 wind_comp_0.sg13g2_and2_2$1_0.VSS.n575 wind_comp_0.sg13g2_and2_2$1_0.VSS.n1880 1.71662
R4106 wind_comp_0.sg13g2_and2_2$1_0.VSS.n1660 wind_comp_0.sg13g2_and2_2$1_0.VSS.n1131 1.71662
R4107 wind_comp_0.sg13g2_and2_2$1_0.VSS.n569 wind_comp_0.sg13g2_and2_2$1_0.VSS.n1663 1.71662
R4108 wind_comp_0.sg13g2_and2_2$1_0.VSS.n564 wind_comp_0.sg13g2_and2_2$1_0.VSS.n1671 1.71662
R4109 wind_comp_0.sg13g2_and2_2$1_0.VSS.t297 wind_comp_0.sg13g2_and2_2$1_0.VSS.n1090 1.71662
R4110 wind_comp_0.sg13g2_and2_2$1_0.VSS.n552 wind_comp_0.sg13g2_and2_2$1_0.VSS.t297 1.71662
R4111 wind_comp_0.sg13g2_and2_2$1_0.VSS.t309 wind_comp_0.sg13g2_and2_2$1_0.VSS.n1084 1.71662
R4112 wind_comp_0.sg13g2_and2_2$1_0.VSS.n549 wind_comp_0.sg13g2_and2_2$1_0.VSS.t309 1.71662
R4113 wind_comp_0.sg13g2_and2_2$1_0.VSS.n1626 wind_comp_0.sg13g2_and2_2$1_0.VSS.n1083 1.71662
R4114 wind_comp_0.sg13g2_and2_2$1_0.VSS.n548 wind_comp_0.sg13g2_and2_2$1_0.VSS.n1626 1.71662
R4115 wind_comp_0.sg13g2_and2_2$1_0.VSS.t312 wind_comp_0.sg13g2_and2_2$1_0.VSS.n1079 1.71662
R4116 wind_comp_0.sg13g2_and2_2$1_0.VSS.n546 wind_comp_0.sg13g2_and2_2$1_0.VSS.t312 1.71662
R4117 wind_comp_0.sg13g2_and2_2$1_0.VSS.t315 wind_comp_0.sg13g2_and2_2$1_0.VSS.n1072 1.71662
R4118 wind_comp_0.sg13g2_and2_2$1_0.VSS.n543 wind_comp_0.sg13g2_and2_2$1_0.VSS.t315 1.71662
R4119 wind_comp_0.sg13g2_and2_2$1_0.VSS.t318 wind_comp_0.sg13g2_and2_2$1_0.VSS.n1068 1.71662
R4120 wind_comp_0.sg13g2_and2_2$1_0.VSS.n540 wind_comp_0.sg13g2_and2_2$1_0.VSS.t318 1.71662
R4121 wind_comp_0.sg13g2_and2_2$1_0.VSS.n540 wind_comp_0.sg13g2_and2_2$1_0.VSS.n1619 1.71662
R4122 wind_comp_0.sg13g2_and2_2$1_0.VSS.t321 wind_comp_0.sg13g2_and2_2$1_0.VSS.n1065 1.71662
R4123 wind_comp_0.sg13g2_and2_2$1_0.VSS.n537 wind_comp_0.sg13g2_and2_2$1_0.VSS.t321 1.71662
R4124 wind_comp_0.sg13g2_and2_2$1_0.VSS.t324 wind_comp_0.sg13g2_and2_2$1_0.VSS.n1062 1.71662
R4125 wind_comp_0.sg13g2_and2_2$1_0.VSS.n2526 wind_comp_0.sg13g2_and2_2$1_0.VSS.n1060 1.71662
R4126 wind_comp_0.sg13g2_and2_2$1_0.VSS.n1573 wind_comp_0.comparator_0.dynamic_pcell$7_0.VSS 1.69369
R4127 wind_comp_0.sg13g2_and2_2$1_0.VSS.n2548 wind_comp_0.comparator_1.dynamic_pcell$7_0.VSS 1.69297
R4128 wind_comp_0.sg13g2_and2_2$1_0.VSS.n79 wind_comp_0.sg13g2_and2_2$1_0.VSS.n880 1.68658
R4129 wind_comp_0.sg13g2_and2_2$1_0.VSS.n2578 wind_comp_0.sg13g2_and2_2$1_0.VSS.n2577 1.67156
R4130 wind_comp_0.sg13g2_and2_2$1_0.VSS.n2589 wind_comp_0.sg13g2_and2_2$1_0.VSS.n2588 1.67152
R4131 wind_comp_0.sg13g2_and2_2$1_0.VSS.n1020 wind_comp_0.sg13g2_and2_2$1_0.VSS.n1015 1.6713
R4132 wind_comp_0.sg13g2_and2_2$1_0.VSS.n39 wind_comp_0.sg13g2_and2_2$1_0.VSS.n1998 1.67122
R4133 wind_comp_0.sg13g2_and2_2$1_0.VSS.n1987 wind_comp_0.sg13g2_and2_2$1_0.VSS.n1983 1.67122
R4134 wind_comp_0.sg13g2_and2_2$1_0.VSS.n2027 wind_comp_0.sg13g2_and2_2$1_0.VSS.n2026 1.67122
R4135 wind_comp_0.sg13g2_and2_2$1_0.VSS.n2583 wind_comp_0.sg13g2_and2_2$1_0.VSS.n2582 1.67122
R4136 wind_comp_0.sg13g2_and2_2$1_0.VSS.n1053 wind_comp_0.sg13g2_and2_2$1_0.VSS.n1048 1.67122
R4137 wind_comp_0.sg13g2_and2_2$1_0.VSS.n891 wind_comp_0.sg13g2_and2_2$1_0.VSS.n890 1.67122
R4138 wind_comp_0.sg13g2_and2_2$1_0.VSS.n2112 wind_comp_0.sg13g2_and2_2$1_0.VSS.n2095 1.67122
R4139 wind_comp_0.sg13g2_and2_2$1_0.VSS.n897 wind_comp_0.sg13g2_and2_2$1_0.VSS.n896 1.67121
R4140 wind_comp_0.sg13g2_and2_2$1_0.VSS.n1986 wind_comp_0.sg13g2_and2_2$1_0.VSS.n1985 1.67121
R4141 wind_comp_0.sg13g2_and2_2$1_0.VSS.n785 wind_comp_0.sg13g2_and2_2$1_0.VSS.n784 1.67121
R4142 wind_comp_0.sg13g2_and2_2$1_0.VSS.n973 wind_comp_0.sg13g2_and2_2$1_0.VSS.n972 1.67121
R4143 wind_comp_0.sg13g2_and2_2$1_0.VSS.n1022 wind_comp_0.sg13g2_and2_2$1_0.VSS.n1021 1.67121
R4144 wind_comp_0.sg13g2_and2_2$1_0.VSS.n141 wind_comp_0.sg13g2_and2_2$1_0.VSS.n2229 1.67121
R4145 wind_comp_0.sg13g2_and2_2$1_0.VSS.n2231 wind_comp_0.sg13g2_and2_2$1_0.VSS.n2230 1.67118
R4146 wind_comp_0.sg13g2_and2_2$1_0.VSS.n885 wind_comp_0.sg13g2_and2_2$1_0.VSS.n884 1.67118
R4147 wind_comp_0.sg13g2_and2_2$1_0.VSS.n899 wind_comp_0.sg13g2_and2_2$1_0.VSS.n894 1.67118
R4148 wind_comp_0.sg13g2_and2_2$1_0.VSS.n995 wind_comp_0.sg13g2_and2_2$1_0.VSS.n994 1.67118
R4149 wind_comp_0.sg13g2_and2_2$1_0.VSS.n2314 wind_comp_0.sg13g2_and2_2$1_0.VSS.n2309 1.67115
R4150 wind_comp_0.sg13g2_and2_2$1_0.VSS.n990 wind_comp_0.sg13g2_and2_2$1_0.VSS.n989 1.67114
R4151 wind_comp_0.sg13g2_and2_2$1_0.VSS.n2312 wind_comp_0.sg13g2_and2_2$1_0.VSS.n2311 1.67114
R4152 wind_comp_0.sg13g2_and2_2$1_0.VSS.n2586 wind_comp_0.sg13g2_and2_2$1_0.VSS.n2584 1.67111
R4153 wind_comp_0.sg13g2_and2_2$1_0.VSS.n1992 wind_comp_0.sg13g2_and2_2$1_0.VSS.n1991 1.67107
R4154 wind_comp_0.sg13g2_and2_2$1_0.VSS.n2021 wind_comp_0.sg13g2_and2_2$1_0.VSS.n2020 1.67107
R4155 wind_comp_0.sg13g2_and2_2$1_0.VSS.n776 wind_comp_0.sg13g2_and2_2$1_0.VSS.n774 1.67107
R4156 wind_comp_0.sg13g2_and2_2$1_0.VSS.n30 wind_comp_0.sg13g2_and2_2$1_0.VSS.n977 1.67107
R4157 wind_comp_0.sg13g2_and2_2$1_0.VSS.n1055 wind_comp_0.sg13g2_and2_2$1_0.VSS.n1054 1.67107
R4158 wind_comp_0.sg13g2_and2_2$1_0.VSS.n2108 wind_comp_0.sg13g2_and2_2$1_0.VSS.n2096 1.67107
R4159 wind_comp_0.sg13g2_and2_2$1_0.VSS.n778 wind_comp_0.sg13g2_and2_2$1_0.VSS.n777 1.67091
R4160 wind_comp_0.sg13g2_and2_2$1_0.VSS.n3 wind_comp_0.sg13g2_and2_2$1_0.VSS.n783 1.67073
R4161 wind_comp_0.sg13g2_and2_2$1_0.VSS.n787 wind_comp_0.sg13g2_and2_2$1_0.VSS.n783 1.66928
R4162 wind_comp_0.sg13g2_and2_2$1_0.VSS.n777 wind_comp_0.sg13g2_and2_2$1_0.VSS.n775 1.66919
R4163 wind_comp_0.sg13g2_and2_2$1_0.VSS.n1993 wind_comp_0.sg13g2_and2_2$1_0.VSS.n1991 1.66913
R4164 wind_comp_0.sg13g2_and2_2$1_0.VSS.n2022 wind_comp_0.sg13g2_and2_2$1_0.VSS.n2020 1.66913
R4165 wind_comp_0.sg13g2_and2_2$1_0.VSS.n781 wind_comp_0.sg13g2_and2_2$1_0.VSS.n774 1.66913
R4166 wind_comp_0.sg13g2_and2_2$1_0.VSS.n977 wind_comp_0.sg13g2_and2_2$1_0.VSS.n976 1.66913
R4167 wind_comp_0.sg13g2_and2_2$1_0.VSS.n1054 wind_comp_0.sg13g2_and2_2$1_0.VSS.n1049 1.66913
R4168 wind_comp_0.sg13g2_and2_2$1_0.VSS.n2109 wind_comp_0.sg13g2_and2_2$1_0.VSS.n2108 1.66913
R4169 wind_comp_0.sg13g2_and2_2$1_0.VSS.n991 wind_comp_0.sg13g2_and2_2$1_0.VSS.n989 1.66909
R4170 wind_comp_0.sg13g2_and2_2$1_0.VSS.n2311 wind_comp_0.sg13g2_and2_2$1_0.VSS.n2310 1.66909
R4171 wind_comp_0.sg13g2_and2_2$1_0.VSS.n2585 wind_comp_0.sg13g2_and2_2$1_0.VSS.n2584 1.66907
R4172 wind_comp_0.sg13g2_and2_2$1_0.VSS.n2232 wind_comp_0.sg13g2_and2_2$1_0.VSS.n2231 1.66904
R4173 wind_comp_0.sg13g2_and2_2$1_0.VSS.n886 wind_comp_0.sg13g2_and2_2$1_0.VSS.n884 1.66904
R4174 wind_comp_0.sg13g2_and2_2$1_0.VSS.n896 wind_comp_0.sg13g2_and2_2$1_0.VSS.n895 1.66899
R4175 wind_comp_0.sg13g2_and2_2$1_0.VSS.n1985 wind_comp_0.sg13g2_and2_2$1_0.VSS.n1984 1.66899
R4176 wind_comp_0.sg13g2_and2_2$1_0.VSS.n786 wind_comp_0.sg13g2_and2_2$1_0.VSS.n785 1.66899
R4177 wind_comp_0.sg13g2_and2_2$1_0.VSS.n974 wind_comp_0.sg13g2_and2_2$1_0.VSS.n972 1.66899
R4178 wind_comp_0.sg13g2_and2_2$1_0.VSS.n1021 wind_comp_0.sg13g2_and2_2$1_0.VSS.n1016 1.66899
R4179 wind_comp_0.sg13g2_and2_2$1_0.VSS.n2234 wind_comp_0.sg13g2_and2_2$1_0.VSS.n2229 1.66899
R4180 wind_comp_0.sg13g2_and2_2$1_0.VSS.n2317 wind_comp_0.sg13g2_and2_2$1_0.VSS.n2309 1.66894
R4181 wind_comp_0.sg13g2_and2_2$1_0.VSS.n902 wind_comp_0.sg13g2_and2_2$1_0.VSS.n894 1.66892
R4182 wind_comp_0.sg13g2_and2_2$1_0.VSS.n994 wind_comp_0.sg13g2_and2_2$1_0.VSS.n993 1.66892
R4183 wind_comp_0.sg13g2_and2_2$1_0.VSS.n33 wind_comp_0.sg13g2_and2_2$1_0.VSS.n1983 1.66892
R4184 wind_comp_0.sg13g2_and2_2$1_0.VSS.n890 wind_comp_0.sg13g2_and2_2$1_0.VSS.n889 1.66892
R4185 wind_comp_0.sg13g2_and2_2$1_0.VSS.n2107 wind_comp_0.sg13g2_and2_2$1_0.VSS.n2095 1.66892
R4186 wind_comp_0.sg13g2_and2_2$1_0.VSS.n1998 wind_comp_0.sg13g2_and2_2$1_0.VSS.n1997 1.66892
R4187 wind_comp_0.sg13g2_and2_2$1_0.VSS.n2026 wind_comp_0.sg13g2_and2_2$1_0.VSS.n2025 1.66892
R4188 wind_comp_0.sg13g2_and2_2$1_0.VSS.n2582 wind_comp_0.sg13g2_and2_2$1_0.VSS.n2581 1.66892
R4189 wind_comp_0.sg13g2_and2_2$1_0.VSS.n23 wind_comp_0.sg13g2_and2_2$1_0.VSS.n1048 1.66892
R4190 wind_comp_0.sg13g2_and2_2$1_0.VSS.n1025 wind_comp_0.sg13g2_and2_2$1_0.VSS.n1015 1.66888
R4191 wind_comp_0.sg13g2_and2_2$1_0.VSS.n236 wind_comp_0.sg13g2_and2_2$1_0.VSS.n2589 1.66877
R4192 wind_comp_0.sg13g2_and2_2$1_0.VSS.n2579 wind_comp_0.sg13g2_and2_2$1_0.VSS.n2577 1.66872
R4193 wind_comp_0.sg13g2_and2_2$1_0.VSS.t36 wind_comp_0.sg13g2_and2_2$1_0.VSS.n449 1.66393
R4194 wind_comp_0.sg13g2_and2_2$1_0.VSS.t19 wind_comp_0.sg13g2_and2_2$1_0.VSS.n268 1.66393
R4195 wind_comp_0.sg13g2_and2_2$1_0.VSS.t21 wind_comp_0.sg13g2_and2_2$1_0.VSS.n279 1.66393
R4196 wind_comp_0.sg13g2_and2_2$1_0.VSS.n1 wind_comp_0.comparator_0.dynamic_pcell$2_0.VSS 1.17899
R4197 wind_comp_0.sg13g2_and2_2$1_0.VSS.n2530 wind_comp_0.sg13g2_and2_2$1_0.VSS.n126 1.60937
R4198 wind_comp_0.sg13g2_and2_2$1_0.VSS.n594 wind_comp_0.sg13g2_and2_2$1_0.VSS.t412 1.60937
R4199 wind_comp_0.sg13g2_and2_2$1_0.VSS.n12 wind_comp_0.sg13g2_and2_2$1_0.VSS.t8 4.17304
R4200 wind_comp_0.sg13g2_and2_2$1_0.VSS.n210 wind_comp_0.sg13g2_and2_2$1_0.VSS.n1282 2.01838
R4201 wind_comp_0.sg13g2_and2_2$1_0.VSS.n211 wind_comp_0.sg13g2_and2_2$1_0.VSS.n1287 2.01838
R4202 wind_comp_0.sg13g2_and2_2$1_0.VSS.n125 wind_comp_0.comparator_0.dynamic_pcell_0.VSS 1.69387
R4203 wind_comp_0.sg13g2_and2_2$1_0.VSS.n1928 wind_comp_0.sg13g2_and2_2$1_0.VSS.n8 0.460697
R4204 wind_comp_0.comparator_0.dynamic_pcell$7_0.VSS wind_comp_0.sg13g2_and2_2$1_0.VSS.n1572 1.51485
R4205 wind_comp_0.sg13g2_and2_2$1_0.VSS.n1452 wind_comp_0.sg13g2_and2_2$1_0.VSS.t251 1.50211
R4206 wind_comp_0.sg13g2_and2_2$1_0.VSS.n1460 wind_comp_0.sg13g2_and2_2$1_0.VSS.n1357 1.50211
R4207 wind_comp_0.sg13g2_and2_2$1_0.VSS.n1448 wind_comp_0.sg13g2_and2_2$1_0.VSS.n1447 1.50211
R4208 wind_comp_0.sg13g2_and2_2$1_0.VSS.n1489 wind_comp_0.sg13g2_and2_2$1_0.VSS.n1488 1.50211
R4209 wind_comp_0.sg13g2_and2_2$1_0.VSS.n1489 wind_comp_0.sg13g2_and2_2$1_0.VSS.t336 1.50211
R4210 wind_comp_0.sg13g2_and2_2$1_0.VSS.n1433 wind_comp_0.sg13g2_and2_2$1_0.VSS.n1394 1.50211
R4211 wind_comp_0.sg13g2_and2_2$1_0.VSS.t275 wind_comp_0.sg13g2_and2_2$1_0.VSS.n1263 1.50211
R4212 wind_comp_0.sg13g2_and2_2$1_0.VSS.n1512 wind_comp_0.sg13g2_and2_2$1_0.VSS.n1510 1.50211
R4213 wind_comp_0.sg13g2_and2_2$1_0.VSS.t163 wind_comp_0.sg13g2_and2_2$1_0.VSS.n1297 1.50211
R4214 wind_comp_0.sg13g2_and2_2$1_0.VSS.n367 wind_comp_0.sg13g2_and2_2$1_0.VSS.t177 1.50211
R4215 wind_comp_0.sg13g2_and2_2$1_0.VSS.t196 wind_comp_0.sg13g2_and2_2$1_0.VSS.n1184 1.50211
R4216 wind_comp_0.sg13g2_and2_2$1_0.VSS.n1671 wind_comp_0.sg13g2_and2_2$1_0.VSS.n400 1.50211
R4217 wind_comp_0.sg13g2_and2_2$1_0.VSS.n555 wind_comp_0.sg13g2_and2_2$1_0.VSS.t293 1.50211
R4218 wind_comp_0.sg13g2_and2_2$1_0.VSS.n1616 wind_comp_0.sg13g2_and2_2$1_0.VSS.n411 1.50211
R4219 wind_comp_0.sg13g2_and2_2$1_0.VSS.t198 wind_comp_0.sg13g2_and2_2$1_0.VSS.t323 1.50211
R4220 wind_comp_0.sg13g2_and2_2$1_0.VSS.n2547 wind_comp_0.sg13g2_and2_2$1_0.VSS.n97 1.5001
R4221 wind_comp_0.sg13g2_and2_2$1_0.VSS.n2595 wind_comp_0.comparator_0.dynamic_pcell$2_0.SRC_NET_MNO 1.4877
R4222 wind_comp_0.sg13g2_and2_2$1_0.VSS.n2257 wind_comp_0.comparator_1.dynamic_pcell$2_0.SRC_NET_MNO 1.4877
R4223 wind_comp_0.comparator_1.dynamic_pcell$7_0.VSS wind_comp_0.sg13g2_and2_2$1_0.VSS.n2547 1.46806
R4224 wind_comp_0.sg13g2_and2_2$1_0.VSS.n123 wind_comp_0.sg13g2_and2_2$1_0.VSS.n453 1.12802
R4225 wind_comp_0.sg13g2_and2_2$1_0.VSS.n101 wind_comp_0.sg13g2_and2_2$1_0.VSS.n1612 1.44367
R4226 wind_comp_0.sg13g2_and2_2$1_0.VSS.n124 wind_comp_0.sg13g2_and2_2$1_0.VSS.n608 1.44361
R4227 wind_comp_0.sg13g2_and2_2$1_0.VSS.n101 wind_comp_0.sg13g2_and2_2$1_0.VSS.n2529 0.895379
R4228 wind_comp_0.sg13g2_and2_2$1_0.VSS.n121 wind_comp_0.sg13g2_and2_2$1_0.VSS.n158 1.40736
R4229 wind_comp_0.sg13g2_and2_2$1_0.VSS.t407 wind_comp_0.sg13g2_and2_2$1_0.VSS.n1519 1.39485
R4230 wind_comp_0.comparator_1.dynamic_pcell$1_0.VSS wind_comp_0.sg13g2_and2_2$1_0.VSS.n200 1.38459
R4231 wind_comp_0.sg13g2_and2_2$1_0.VSS.n2563 wind_comp_0.sg13g2_and2_2$1_0.VSS.n357 0.395781
R4232 wind_comp_0.comparator_0.dynamic_pcell$1_0.VSS wind_comp_0.sg13g2_and2_2$1_0.VSS.n8 0.668691
R4233 wind_comp_0.comparator_1.dynamic_pcell$1_0.VSS wind_comp_0.sg13g2_and2_2$1_0.VSS.n185 1.37279
R4234 wind_comp_0.comparator_1.dynamic_pcell$1_0.VSS wind_comp_0.sg13g2_and2_2$1_0.VSS.n151 1.38058
R4235 wind_comp_0.comparator_1.dynamic_pcell$1_0.VSS wind_comp_0.sg13g2_and2_2$1_0.VSS.n67 1.37001
R4236 wind_comp_0.comparator_0.dynamic_pcell$1_0.VSS wind_comp_0.sg13g2_and2_2$1_0.VSS.n8 0.669779
R4237 wind_comp_0.sg13g2_and2_2$1_0.VSS.n935 wind_comp_0.sg13g2_and2_2$1_0.VSS.n426 1.35204
R4238 wind_comp_0.sg13g2_and2_2$1_0.VSS.n936 wind_comp_0.sg13g2_and2_2$1_0.VSS.n427 1.35204
R4239 wind_comp_0.sg13g2_and2_2$1_0.VSS.n938 wind_comp_0.sg13g2_and2_2$1_0.VSS.n425 1.35204
R4240 wind_comp_0.sg13g2_and2_2$1_0.VSS.n939 wind_comp_0.sg13g2_and2_2$1_0.VSS.n428 1.35204
R4241 wind_comp_0.sg13g2_and2_2$1_0.VSS.n941 wind_comp_0.sg13g2_and2_2$1_0.VSS.n429 1.35204
R4242 wind_comp_0.sg13g2_and2_2$1_0.VSS.n942 wind_comp_0.sg13g2_and2_2$1_0.VSS.n430 1.35204
R4243 wind_comp_0.sg13g2_and2_2$1_0.VSS.n943 wind_comp_0.sg13g2_and2_2$1_0.VSS.n431 1.35204
R4244 wind_comp_0.sg13g2_and2_2$1_0.VSS.n944 wind_comp_0.sg13g2_and2_2$1_0.VSS.n432 1.35204
R4245 wind_comp_0.sg13g2_and2_2$1_0.VSS.n945 wind_comp_0.sg13g2_and2_2$1_0.VSS.n433 1.35204
R4246 wind_comp_0.sg13g2_and2_2$1_0.VSS.n946 wind_comp_0.sg13g2_and2_2$1_0.VSS.n434 1.35204
R4247 wind_comp_0.sg13g2_and2_2$1_0.VSS.n948 wind_comp_0.sg13g2_and2_2$1_0.VSS.n435 1.35204
R4248 wind_comp_0.sg13g2_and2_2$1_0.VSS.n949 wind_comp_0.sg13g2_and2_2$1_0.VSS.n436 1.35204
R4249 wind_comp_0.sg13g2_and2_2$1_0.VSS.n1212 wind_comp_0.sg13g2_and2_2$1_0.VSS.t19 1.35204
R4250 wind_comp_0.sg13g2_and2_2$1_0.VSS.n1571 wind_comp_0.sg13g2_and2_2$1_0.VSS.n1570 1.3505
R4251 wind_comp_0.sg13g2_and2_2$1_0.VSS.n1613 wind_comp_0.sg13g2_and2_2$1_0.VSS.n82 1.3432
R4252 wind_comp_0.sg13g2_and2_2$1_0.VSS.n1528 wind_comp_0.sg13g2_and2_2$1_0.VSS.n1525 1.3405
R4253 wind_comp_0.sg13g2_and2_2$1_0.VSS.n1562 wind_comp_0.sg13g2_and2_2$1_0.VSS.n1554 1.3405
R4254 wind_comp_0.sg13g2_and2_2$1_0.VSS.n203 wind_comp_0.sg13g2_and2_2$1_0.VSS.n1271 1.33754
R4255 wind_comp_0.sg13g2_and2_2$1_0.VSS.n27 wind_comp_0.sg13g2_and2_2$1_0.VSS.n452 1.40895
R4256 wind_comp_0.sg13g2_and2_2$1_0.VSS.n2227 wind_comp_0.sg13g2_and2_2$1_0.VSS.n75 1.33412
R4257 wind_comp_0.sg13g2_and2_2$1_0.VSS.n76 wind_comp_0.sg13g2_and2_2$1_0.VSS.n529 1.33376
R4258 wind_comp_0.sg13g2_and2_2$1_0.VSS.n2452 wind_comp_0.sg13g2_and2_2$1_0.VSS.n2451 1.29461
R4259 wind_comp_0.sg13g2_and2_2$1_0.VSS.n2378 wind_comp_0.sg13g2_and2_2$1_0.VSS.n181 1.29461
R4260 wind_comp_0.sg13g2_and2_2$1_0.VSS.n2054 wind_comp_0.sg13g2_and2_2$1_0.VSS.n2053 1.29461
R4261 wind_comp_0.sg13g2_and2_2$1_0.VSS.n2154 wind_comp_0.sg13g2_and2_2$1_0.VSS.n176 1.29461
R4262 wind_comp_0.sg13g2_and2_2$1_0.VSS.n2564 wind_comp_0.sg13g2_and2_2$1_0.VSS.n353 0.524159
R4263 wind_comp_0.sg13g2_and2_2$1_0.VSS.n357 wind_comp_0.sg13g2_and2_2$1_0.VSS.n1575 0.675966
R4264 wind_comp_0.sg13g2_and2_2$1_0.VSS.n1443 wind_comp_0.sg13g2_and2_2$1_0.VSS.n469 1.28759
R4265 wind_comp_0.sg13g2_and2_2$1_0.VSS.n1374 wind_comp_0.sg13g2_and2_2$1_0.VSS.t266 1.28759
R4266 wind_comp_0.sg13g2_and2_2$1_0.VSS.t269 wind_comp_0.sg13g2_and2_2$1_0.VSS.n1379 1.28759
R4267 wind_comp_0.sg13g2_and2_2$1_0.VSS.n1405 wind_comp_0.sg13g2_and2_2$1_0.VSS.n505 1.28759
R4268 wind_comp_0.sg13g2_and2_2$1_0.VSS.n1285 wind_comp_0.sg13g2_and2_2$1_0.VSS.t396 1.28759
R4269 wind_comp_0.sg13g2_and2_2$1_0.VSS.t413 wind_comp_0.sg13g2_and2_2$1_0.VSS.n1578 1.28759
R4270 wind_comp_0.sg13g2_and2_2$1_0.VSS.t398 wind_comp_0.sg13g2_and2_2$1_0.VSS.n1608 1.28759
R4271 wind_comp_0.sg13g2_and2_2$1_0.VSS.n592 wind_comp_0.sg13g2_and2_2$1_0.VSS.n1654 1.28759
R4272 wind_comp_0.sg13g2_and2_2$1_0.VSS.n586 wind_comp_0.sg13g2_and2_2$1_0.VSS.n1655 1.28759
R4273 wind_comp_0.sg13g2_and2_2$1_0.VSS.n1635 wind_comp_0.sg13g2_and2_2$1_0.VSS.n1132 1.28759
R4274 wind_comp_0.sg13g2_and2_2$1_0.VSS.n2528 wind_comp_0.sg13g2_and2_2$1_0.VSS.n568 1.28759
R4275 wind_comp_0.sg13g2_and2_2$1_0.VSS.n565 wind_comp_0.sg13g2_and2_2$1_0.VSS.n1633 1.28759
R4276 wind_comp_0.sg13g2_and2_2$1_0.VSS.n1681 wind_comp_0.sg13g2_and2_2$1_0.VSS.n1096 1.28759
R4277 wind_comp_0.sg13g2_and2_2$1_0.VSS.t306 wind_comp_0.sg13g2_and2_2$1_0.VSS.n405 1.28759
R4278 wind_comp_0.sg13g2_and2_2$1_0.VSS.t308 wind_comp_0.sg13g2_and2_2$1_0.VSS.n418 1.28759
R4279 wind_comp_0.sg13g2_and2_2$1_0.VSS.n1686 wind_comp_0.sg13g2_and2_2$1_0.VSS.n1084 1.28759
R4280 wind_comp_0.sg13g2_and2_2$1_0.VSS.n547 wind_comp_0.sg13g2_and2_2$1_0.VSS.n1690 1.28759
R4281 wind_comp_0.sg13g2_and2_2$1_0.VSS.n541 wind_comp_0.sg13g2_and2_2$1_0.VSS.n1691 1.28759
R4282 wind_comp_0.sg13g2_and2_2$1_0.VSS.t116 wind_comp_0.sg13g2_and2_2$1_0.VSS.n1066 1.28759
R4283 wind_comp_0.sg13g2_and2_2$1_0.VSS.n2054 wind_comp_0.sg13g2_and2_2$1_0.VSS.n159 1.28621
R4284 wind_comp_0.sg13g2_and2_2$1_0.VSS.n2056 wind_comp_0.sg13g2_and2_2$1_0.VSS.n2055 1.28621
R4285 wind_comp_0.sg13g2_and2_2$1_0.VSS.n2058 wind_comp_0.sg13g2_and2_2$1_0.VSS.n2057 1.28621
R4286 wind_comp_0.sg13g2_and2_2$1_0.VSS.n2059 wind_comp_0.sg13g2_and2_2$1_0.VSS.n218 1.28621
R4287 wind_comp_0.sg13g2_and2_2$1_0.VSS.n2060 wind_comp_0.sg13g2_and2_2$1_0.VSS.n240 1.28621
R4288 wind_comp_0.sg13g2_and2_2$1_0.VSS.n2061 wind_comp_0.sg13g2_and2_2$1_0.VSS.n242 1.28621
R4289 wind_comp_0.sg13g2_and2_2$1_0.VSS.n2064 wind_comp_0.sg13g2_and2_2$1_0.VSS.n2063 1.28621
R4290 wind_comp_0.sg13g2_and2_2$1_0.VSS.n2067 wind_comp_0.sg13g2_and2_2$1_0.VSS.n2066 1.28621
R4291 wind_comp_0.sg13g2_and2_2$1_0.VSS.n2070 wind_comp_0.sg13g2_and2_2$1_0.VSS.n2069 1.28621
R4292 wind_comp_0.sg13g2_and2_2$1_0.VSS.n2071 wind_comp_0.sg13g2_and2_2$1_0.VSS.n674 1.28621
R4293 wind_comp_0.sg13g2_and2_2$1_0.VSS.n2073 wind_comp_0.sg13g2_and2_2$1_0.VSS.n2072 1.28621
R4294 wind_comp_0.sg13g2_and2_2$1_0.VSS.n2076 wind_comp_0.sg13g2_and2_2$1_0.VSS.n2075 1.28621
R4295 wind_comp_0.sg13g2_and2_2$1_0.VSS.n2077 wind_comp_0.sg13g2_and2_2$1_0.VSS.n89 0.00889112
R4296 wind_comp_0.sg13g2_and2_2$1_0.VSS.n89 wind_comp_0.sg13g2_and2_2$1_0.VSS.n87 0.639912
R4297 wind_comp_0.sg13g2_and2_2$1_0.VSS.n2079 wind_comp_0.sg13g2_and2_2$1_0.VSS.n152 1.28621
R4298 wind_comp_0.sg13g2_and2_2$1_0.VSS.n2080 wind_comp_0.sg13g2_and2_2$1_0.VSS.n165 1.28621
R4299 wind_comp_0.sg13g2_and2_2$1_0.VSS.n2081 wind_comp_0.sg13g2_and2_2$1_0.VSS.n251 1.28621
R4300 wind_comp_0.sg13g2_and2_2$1_0.VSS.n2082 wind_comp_0.sg13g2_and2_2$1_0.VSS.n253 1.28621
R4301 wind_comp_0.sg13g2_and2_2$1_0.VSS.n2083 wind_comp_0.sg13g2_and2_2$1_0.VSS.n134 1.28621
R4302 wind_comp_0.sg13g2_and2_2$1_0.VSS.n2084 wind_comp_0.sg13g2_and2_2$1_0.VSS.n157 1.28621
R4303 wind_comp_0.sg13g2_and2_2$1_0.VSS.n2085 wind_comp_0.sg13g2_and2_2$1_0.VSS.n231 1.28621
R4304 wind_comp_0.sg13g2_and2_2$1_0.VSS.n2086 wind_comp_0.sg13g2_and2_2$1_0.VSS.n675 1.28621
R4305 wind_comp_0.sg13g2_and2_2$1_0.VSS.n170 wind_comp_0.sg13g2_and2_2$1_0.VSS.n2087 1.28621
R4306 wind_comp_0.sg13g2_and2_2$1_0.VSS.n2036 wind_comp_0.sg13g2_and2_2$1_0.VSS.n2035 1.28621
R4307 wind_comp_0.sg13g2_and2_2$1_0.VSS.n2050 wind_comp_0.sg13g2_and2_2$1_0.VSS.n2049 1.28621
R4308 wind_comp_0.sg13g2_and2_2$1_0.VSS.n2047 wind_comp_0.sg13g2_and2_2$1_0.VSS.n2040 1.28621
R4309 wind_comp_0.sg13g2_and2_2$1_0.VSS.n2045 wind_comp_0.sg13g2_and2_2$1_0.VSS.n2044 1.28621
R4310 wind_comp_0.sg13g2_and2_2$1_0.VSS.n1966 wind_comp_0.sg13g2_and2_2$1_0.VSS.n1965 1.28621
R4311 wind_comp_0.sg13g2_and2_2$1_0.VSS.n2131 wind_comp_0.sg13g2_and2_2$1_0.VSS.n2130 1.28621
R4312 wind_comp_0.sg13g2_and2_2$1_0.VSS.n2133 wind_comp_0.sg13g2_and2_2$1_0.VSS.n2132 1.28621
R4313 wind_comp_0.sg13g2_and2_2$1_0.VSS.n2135 wind_comp_0.sg13g2_and2_2$1_0.VSS.n1963 1.28621
R4314 wind_comp_0.sg13g2_and2_2$1_0.VSS.n2138 wind_comp_0.sg13g2_and2_2$1_0.VSS.n2137 1.28621
R4315 wind_comp_0.sg13g2_and2_2$1_0.VSS.n2139 wind_comp_0.sg13g2_and2_2$1_0.VSS.n360 1.28621
R4316 wind_comp_0.sg13g2_and2_2$1_0.VSS.n2142 wind_comp_0.sg13g2_and2_2$1_0.VSS.n2141 1.28621
R4317 wind_comp_0.sg13g2_and2_2$1_0.VSS.n2143 wind_comp_0.sg13g2_and2_2$1_0.VSS.n629 1.28621
R4318 wind_comp_0.sg13g2_and2_2$1_0.VSS.n2146 wind_comp_0.sg13g2_and2_2$1_0.VSS.n2145 1.28621
R4319 wind_comp_0.sg13g2_and2_2$1_0.VSS.n2149 wind_comp_0.sg13g2_and2_2$1_0.VSS.n2148 1.28621
R4320 wind_comp_0.sg13g2_and2_2$1_0.VSS.n2150 wind_comp_0.sg13g2_and2_2$1_0.VSS.n284 1.28621
R4321 wind_comp_0.sg13g2_and2_2$1_0.VSS.n2153 wind_comp_0.sg13g2_and2_2$1_0.VSS.n2152 1.28621
R4322 wind_comp_0.sg13g2_and2_2$1_0.VSS.n398 wind_comp_0.sg13g2_and2_2$1_0.VSS.n2154 1.28621
R4323 wind_comp_0.sg13g2_and2_2$1_0.VSS.n127 wind_comp_0.sg13g2_and2_2$1_0.VSS.n2378 1.28621
R4324 wind_comp_0.sg13g2_and2_2$1_0.VSS.n656 wind_comp_0.sg13g2_and2_2$1_0.VSS.n2452 1.28621
R4325 wind_comp_0.sg13g2_and2_2$1_0.VSS.n2340 wind_comp_0.sg13g2_and2_2$1_0.VSS.n119 1.28621
R4326 wind_comp_0.sg13g2_and2_2$1_0.VSS.n2449 wind_comp_0.sg13g2_and2_2$1_0.VSS.n137 1.28621
R4327 wind_comp_0.sg13g2_and2_2$1_0.VSS.n2448 wind_comp_0.sg13g2_and2_2$1_0.VSS.n144 1.28621
R4328 wind_comp_0.sg13g2_and2_2$1_0.VSS.n2447 wind_comp_0.sg13g2_and2_2$1_0.VSS.n239 1.28621
R4329 wind_comp_0.sg13g2_and2_2$1_0.VSS.n2343 wind_comp_0.sg13g2_and2_2$1_0.VSS.n657 1.28621
R4330 wind_comp_0.sg13g2_and2_2$1_0.VSS.n2444 wind_comp_0.sg13g2_and2_2$1_0.VSS.n229 1.28621
R4331 wind_comp_0.sg13g2_and2_2$1_0.VSS.n2443 wind_comp_0.sg13g2_and2_2$1_0.VSS.n2442 1.28621
R4332 wind_comp_0.sg13g2_and2_2$1_0.VSS.n2441 wind_comp_0.sg13g2_and2_2$1_0.VSS.n2440 1.28621
R4333 wind_comp_0.sg13g2_and2_2$1_0.VSS.n2347 wind_comp_0.sg13g2_and2_2$1_0.VSS.n2346 1.28621
R4334 wind_comp_0.sg13g2_and2_2$1_0.VSS.n2437 wind_comp_0.sg13g2_and2_2$1_0.VSS.n2436 1.28621
R4335 wind_comp_0.sg13g2_and2_2$1_0.VSS.n2435 wind_comp_0.sg13g2_and2_2$1_0.VSS.n2434 1.28621
R4336 wind_comp_0.sg13g2_and2_2$1_0.VSS.n2433 wind_comp_0.sg13g2_and2_2$1_0.VSS.n2432 1.28621
R4337 wind_comp_0.sg13g2_and2_2$1_0.VSS.n2351 wind_comp_0.sg13g2_and2_2$1_0.VSS.n2350 1.28621
R4338 wind_comp_0.sg13g2_and2_2$1_0.VSS.n2428 wind_comp_0.sg13g2_and2_2$1_0.VSS.n2427 1.28621
R4339 wind_comp_0.sg13g2_and2_2$1_0.VSS.n2426 wind_comp_0.sg13g2_and2_2$1_0.VSS.n2425 1.28621
R4340 wind_comp_0.sg13g2_and2_2$1_0.VSS.n2424 wind_comp_0.sg13g2_and2_2$1_0.VSS.n660 1.28621
R4341 wind_comp_0.sg13g2_and2_2$1_0.VSS.n2355 wind_comp_0.sg13g2_and2_2$1_0.VSS.n2354 1.28621
R4342 wind_comp_0.sg13g2_and2_2$1_0.VSS.n2421 wind_comp_0.sg13g2_and2_2$1_0.VSS.n613 1.28621
R4343 wind_comp_0.sg13g2_and2_2$1_0.VSS.n2420 wind_comp_0.sg13g2_and2_2$1_0.VSS.n2419 1.28621
R4344 wind_comp_0.sg13g2_and2_2$1_0.VSS.n2418 wind_comp_0.sg13g2_and2_2$1_0.VSS.n2417 1.28621
R4345 wind_comp_0.sg13g2_and2_2$1_0.VSS.n2358 wind_comp_0.sg13g2_and2_2$1_0.VSS.n286 1.28621
R4346 wind_comp_0.sg13g2_and2_2$1_0.VSS.n2414 wind_comp_0.sg13g2_and2_2$1_0.VSS.n2413 1.28621
R4347 wind_comp_0.sg13g2_and2_2$1_0.VSS.n2412 wind_comp_0.sg13g2_and2_2$1_0.VSS.n96 0.00889112
R4348 wind_comp_0.sg13g2_and2_2$1_0.VSS.n96 wind_comp_0.sg13g2_and2_2$1_0.VSS.n90 0.639912
R4349 wind_comp_0.sg13g2_and2_2$1_0.VSS.n2361 wind_comp_0.sg13g2_and2_2$1_0.VSS.n355 1.28621
R4350 wind_comp_0.sg13g2_and2_2$1_0.VSS.n2408 wind_comp_0.sg13g2_and2_2$1_0.VSS.n2407 1.28621
R4351 wind_comp_0.sg13g2_and2_2$1_0.VSS.n2406 wind_comp_0.sg13g2_and2_2$1_0.VSS.n2405 1.28621
R4352 wind_comp_0.sg13g2_and2_2$1_0.VSS.n2404 wind_comp_0.sg13g2_and2_2$1_0.VSS.n664 1.28621
R4353 wind_comp_0.sg13g2_and2_2$1_0.VSS.n2365 wind_comp_0.sg13g2_and2_2$1_0.VSS.n2364 1.28621
R4354 wind_comp_0.sg13g2_and2_2$1_0.VSS.n2401 wind_comp_0.sg13g2_and2_2$1_0.VSS.n615 1.28621
R4355 wind_comp_0.sg13g2_and2_2$1_0.VSS.n2400 wind_comp_0.sg13g2_and2_2$1_0.VSS.n2399 1.28621
R4356 wind_comp_0.sg13g2_and2_2$1_0.VSS.n2398 wind_comp_0.sg13g2_and2_2$1_0.VSS.n2397 1.28621
R4357 wind_comp_0.sg13g2_and2_2$1_0.VSS.n2368 wind_comp_0.sg13g2_and2_2$1_0.VSS.n666 1.28621
R4358 wind_comp_0.sg13g2_and2_2$1_0.VSS.n2394 wind_comp_0.sg13g2_and2_2$1_0.VSS.n150 0.00889112
R4359 wind_comp_0.sg13g2_and2_2$1_0.VSS.n150 wind_comp_0.sg13g2_and2_2$1_0.VSS.n46 0.639912
R4360 wind_comp_0.sg13g2_and2_2$1_0.VSS.n47 wind_comp_0.sg13g2_and2_2$1_0.VSS.n46 0.639912
R4361 wind_comp_0.sg13g2_and2_2$1_0.VSS.n2371 wind_comp_0.sg13g2_and2_2$1_0.VSS.n47 0.00889112
R4362 wind_comp_0.sg13g2_and2_2$1_0.VSS.n42 wind_comp_0.sg13g2_and2_2$1_0.VSS.n41 0.639912
R4363 wind_comp_0.sg13g2_and2_2$1_0.VSS.n2388 wind_comp_0.sg13g2_and2_2$1_0.VSS.n42 0.00889112
R4364 wind_comp_0.sg13g2_and2_2$1_0.VSS.n2387 wind_comp_0.sg13g2_and2_2$1_0.VSS.n289 1.28621
R4365 wind_comp_0.sg13g2_and2_2$1_0.VSS.n2375 wind_comp_0.sg13g2_and2_2$1_0.VSS.n2374 1.28621
R4366 wind_comp_0.sg13g2_and2_2$1_0.VSS.n2384 wind_comp_0.sg13g2_and2_2$1_0.VSS.n2383 1.28621
R4367 wind_comp_0.sg13g2_and2_2$1_0.VSS.n2382 wind_comp_0.sg13g2_and2_2$1_0.VSS.n2381 1.28621
R4368 wind_comp_0.sg13g2_and2_2$1_0.VSS.n2382 wind_comp_0.sg13g2_and2_2$1_0.VSS.n2377 1.28621
R4369 wind_comp_0.sg13g2_and2_2$1_0.VSS.n2385 wind_comp_0.sg13g2_and2_2$1_0.VSS.n2384 1.28621
R4370 wind_comp_0.sg13g2_and2_2$1_0.VSS.n2376 wind_comp_0.sg13g2_and2_2$1_0.VSS.n2375 1.28621
R4371 wind_comp_0.sg13g2_and2_2$1_0.VSS.n2387 wind_comp_0.sg13g2_and2_2$1_0.VSS.n2386 1.28621
R4372 wind_comp_0.sg13g2_and2_2$1_0.VSS.n2388 wind_comp_0.sg13g2_and2_2$1_0.VSS.n2373 1.28621
R4373 wind_comp_0.sg13g2_and2_2$1_0.VSS.n2390 wind_comp_0.sg13g2_and2_2$1_0.VSS.n2389 1.28621
R4374 wind_comp_0.sg13g2_and2_2$1_0.VSS.n2372 wind_comp_0.sg13g2_and2_2$1_0.VSS.n2371 1.28621
R4375 wind_comp_0.sg13g2_and2_2$1_0.VSS.n2392 wind_comp_0.sg13g2_and2_2$1_0.VSS.n2391 1.28621
R4376 wind_comp_0.sg13g2_and2_2$1_0.VSS.n2393 wind_comp_0.sg13g2_and2_2$1_0.VSS.n2370 1.28621
R4377 wind_comp_0.sg13g2_and2_2$1_0.VSS.n2395 wind_comp_0.sg13g2_and2_2$1_0.VSS.n2394 1.28621
R4378 wind_comp_0.sg13g2_and2_2$1_0.VSS.n2369 wind_comp_0.sg13g2_and2_2$1_0.VSS.n2368 1.28621
R4379 wind_comp_0.sg13g2_and2_2$1_0.VSS.n2398 wind_comp_0.sg13g2_and2_2$1_0.VSS.n2396 1.28621
R4380 wind_comp_0.sg13g2_and2_2$1_0.VSS.n2400 wind_comp_0.sg13g2_and2_2$1_0.VSS.n2367 1.28621
R4381 wind_comp_0.sg13g2_and2_2$1_0.VSS.n2402 wind_comp_0.sg13g2_and2_2$1_0.VSS.n2401 1.28621
R4382 wind_comp_0.sg13g2_and2_2$1_0.VSS.n2366 wind_comp_0.sg13g2_and2_2$1_0.VSS.n2365 1.28621
R4383 wind_comp_0.sg13g2_and2_2$1_0.VSS.n2404 wind_comp_0.sg13g2_and2_2$1_0.VSS.n2403 1.28621
R4384 wind_comp_0.sg13g2_and2_2$1_0.VSS.n2406 wind_comp_0.sg13g2_and2_2$1_0.VSS.n2363 1.28621
R4385 wind_comp_0.sg13g2_and2_2$1_0.VSS.n2409 wind_comp_0.sg13g2_and2_2$1_0.VSS.n2408 1.28621
R4386 wind_comp_0.sg13g2_and2_2$1_0.VSS.n2362 wind_comp_0.sg13g2_and2_2$1_0.VSS.n2361 1.28621
R4387 wind_comp_0.sg13g2_and2_2$1_0.VSS.n2411 wind_comp_0.sg13g2_and2_2$1_0.VSS.n2410 1.28621
R4388 wind_comp_0.sg13g2_and2_2$1_0.VSS.n2412 wind_comp_0.sg13g2_and2_2$1_0.VSS.n2360 1.28621
R4389 wind_comp_0.sg13g2_and2_2$1_0.VSS.n2415 wind_comp_0.sg13g2_and2_2$1_0.VSS.n2414 1.28621
R4390 wind_comp_0.sg13g2_and2_2$1_0.VSS.n2359 wind_comp_0.sg13g2_and2_2$1_0.VSS.n2358 1.28621
R4391 wind_comp_0.sg13g2_and2_2$1_0.VSS.n2418 wind_comp_0.sg13g2_and2_2$1_0.VSS.n2416 1.28621
R4392 wind_comp_0.sg13g2_and2_2$1_0.VSS.n2420 wind_comp_0.sg13g2_and2_2$1_0.VSS.n2357 1.28621
R4393 wind_comp_0.sg13g2_and2_2$1_0.VSS.n2422 wind_comp_0.sg13g2_and2_2$1_0.VSS.n2421 1.28621
R4394 wind_comp_0.sg13g2_and2_2$1_0.VSS.n2356 wind_comp_0.sg13g2_and2_2$1_0.VSS.n2355 1.28621
R4395 wind_comp_0.sg13g2_and2_2$1_0.VSS.n2424 wind_comp_0.sg13g2_and2_2$1_0.VSS.n2423 1.28621
R4396 wind_comp_0.sg13g2_and2_2$1_0.VSS.n2426 wind_comp_0.sg13g2_and2_2$1_0.VSS.n2353 1.28621
R4397 wind_comp_0.sg13g2_and2_2$1_0.VSS.n2429 wind_comp_0.sg13g2_and2_2$1_0.VSS.n2428 1.28621
R4398 wind_comp_0.sg13g2_and2_2$1_0.VSS.n2352 wind_comp_0.sg13g2_and2_2$1_0.VSS.n2351 1.28621
R4399 wind_comp_0.sg13g2_and2_2$1_0.VSS.n2433 wind_comp_0.sg13g2_and2_2$1_0.VSS.n2430 1.28621
R4400 wind_comp_0.sg13g2_and2_2$1_0.VSS.n2435 wind_comp_0.sg13g2_and2_2$1_0.VSS.n2349 1.28621
R4401 wind_comp_0.sg13g2_and2_2$1_0.VSS.n2438 wind_comp_0.sg13g2_and2_2$1_0.VSS.n2437 1.28621
R4402 wind_comp_0.sg13g2_and2_2$1_0.VSS.n2348 wind_comp_0.sg13g2_and2_2$1_0.VSS.n2347 1.28621
R4403 wind_comp_0.sg13g2_and2_2$1_0.VSS.n2441 wind_comp_0.sg13g2_and2_2$1_0.VSS.n2439 1.28621
R4404 wind_comp_0.sg13g2_and2_2$1_0.VSS.n2443 wind_comp_0.sg13g2_and2_2$1_0.VSS.n2345 1.28621
R4405 wind_comp_0.sg13g2_and2_2$1_0.VSS.n2445 wind_comp_0.sg13g2_and2_2$1_0.VSS.n2444 1.28621
R4406 wind_comp_0.sg13g2_and2_2$1_0.VSS.n2344 wind_comp_0.sg13g2_and2_2$1_0.VSS.n2343 1.28621
R4407 wind_comp_0.sg13g2_and2_2$1_0.VSS.n2447 wind_comp_0.sg13g2_and2_2$1_0.VSS.n2446 1.28621
R4408 wind_comp_0.sg13g2_and2_2$1_0.VSS.n2448 wind_comp_0.sg13g2_and2_2$1_0.VSS.n2342 1.28621
R4409 wind_comp_0.sg13g2_and2_2$1_0.VSS.n2450 wind_comp_0.sg13g2_and2_2$1_0.VSS.n2449 1.28621
R4410 wind_comp_0.sg13g2_and2_2$1_0.VSS.n2341 wind_comp_0.sg13g2_and2_2$1_0.VSS.n2340 1.28621
R4411 wind_comp_0.sg13g2_and2_2$1_0.VSS.n145 wind_comp_0.sg13g2_and2_2$1_0.VSS.n320 0.639912
R4412 wind_comp_0.sg13g2_and2_2$1_0.VSS.n320 wind_comp_0.sg13g2_and2_2$1_0.VSS.n2376 0.00889112
R4413 wind_comp_0.sg13g2_and2_2$1_0.VSS.n319 wind_comp_0.sg13g2_and2_2$1_0.VSS.n145 0.639912
R4414 wind_comp_0.sg13g2_and2_2$1_0.VSS.n2373 wind_comp_0.sg13g2_and2_2$1_0.VSS.n319 0.00889112
R4415 wind_comp_0.sg13g2_and2_2$1_0.VSS.n145 wind_comp_0.sg13g2_and2_2$1_0.VSS.n318 0.639912
R4416 wind_comp_0.sg13g2_and2_2$1_0.VSS.n318 wind_comp_0.sg13g2_and2_2$1_0.VSS.n2372 0.00889112
R4417 wind_comp_0.sg13g2_and2_2$1_0.VSS.n317 wind_comp_0.sg13g2_and2_2$1_0.VSS.n145 0.639912
R4418 wind_comp_0.sg13g2_and2_2$1_0.VSS.n2370 wind_comp_0.sg13g2_and2_2$1_0.VSS.n317 0.00889112
R4419 wind_comp_0.sg13g2_and2_2$1_0.VSS.n145 wind_comp_0.sg13g2_and2_2$1_0.VSS.n316 0.639912
R4420 wind_comp_0.sg13g2_and2_2$1_0.VSS.n316 wind_comp_0.sg13g2_and2_2$1_0.VSS.n2369 0.00889112
R4421 wind_comp_0.sg13g2_and2_2$1_0.VSS.n315 wind_comp_0.sg13g2_and2_2$1_0.VSS.n145 0.639912
R4422 wind_comp_0.sg13g2_and2_2$1_0.VSS.n2367 wind_comp_0.sg13g2_and2_2$1_0.VSS.n315 0.00889112
R4423 wind_comp_0.sg13g2_and2_2$1_0.VSS.n145 wind_comp_0.sg13g2_and2_2$1_0.VSS.n314 0.639912
R4424 wind_comp_0.sg13g2_and2_2$1_0.VSS.n314 wind_comp_0.sg13g2_and2_2$1_0.VSS.n2366 0.00889112
R4425 wind_comp_0.sg13g2_and2_2$1_0.VSS.n313 wind_comp_0.sg13g2_and2_2$1_0.VSS.n146 0.639912
R4426 wind_comp_0.sg13g2_and2_2$1_0.VSS.n2363 wind_comp_0.sg13g2_and2_2$1_0.VSS.n313 0.00889112
R4427 wind_comp_0.sg13g2_and2_2$1_0.VSS.n146 wind_comp_0.sg13g2_and2_2$1_0.VSS.n312 0.639912
R4428 wind_comp_0.sg13g2_and2_2$1_0.VSS.n312 wind_comp_0.sg13g2_and2_2$1_0.VSS.n2362 0.00889112
R4429 wind_comp_0.sg13g2_and2_2$1_0.VSS.n311 wind_comp_0.sg13g2_and2_2$1_0.VSS.n146 0.639912
R4430 wind_comp_0.sg13g2_and2_2$1_0.VSS.n2360 wind_comp_0.sg13g2_and2_2$1_0.VSS.n311 0.00889112
R4431 wind_comp_0.sg13g2_and2_2$1_0.VSS.n146 wind_comp_0.sg13g2_and2_2$1_0.VSS.n310 0.639912
R4432 wind_comp_0.sg13g2_and2_2$1_0.VSS.n310 wind_comp_0.sg13g2_and2_2$1_0.VSS.n2359 0.00889112
R4433 wind_comp_0.sg13g2_and2_2$1_0.VSS.n309 wind_comp_0.sg13g2_and2_2$1_0.VSS.n146 0.639912
R4434 wind_comp_0.sg13g2_and2_2$1_0.VSS.n2357 wind_comp_0.sg13g2_and2_2$1_0.VSS.n309 0.00889112
R4435 wind_comp_0.sg13g2_and2_2$1_0.VSS.n146 wind_comp_0.sg13g2_and2_2$1_0.VSS.n308 0.639912
R4436 wind_comp_0.sg13g2_and2_2$1_0.VSS.n308 wind_comp_0.sg13g2_and2_2$1_0.VSS.n2356 0.00889112
R4437 wind_comp_0.sg13g2_and2_2$1_0.VSS.n307 wind_comp_0.sg13g2_and2_2$1_0.VSS.n146 0.639912
R4438 wind_comp_0.sg13g2_and2_2$1_0.VSS.n2353 wind_comp_0.sg13g2_and2_2$1_0.VSS.n307 0.00889112
R4439 wind_comp_0.sg13g2_and2_2$1_0.VSS.n146 wind_comp_0.sg13g2_and2_2$1_0.VSS.n306 0.639912
R4440 wind_comp_0.sg13g2_and2_2$1_0.VSS.n306 wind_comp_0.sg13g2_and2_2$1_0.VSS.n2352 0.00889112
R4441 wind_comp_0.sg13g2_and2_2$1_0.VSS.n305 wind_comp_0.sg13g2_and2_2$1_0.VSS.n146 0.639912
R4442 wind_comp_0.sg13g2_and2_2$1_0.VSS.n2349 wind_comp_0.sg13g2_and2_2$1_0.VSS.n305 0.00889112
R4443 wind_comp_0.sg13g2_and2_2$1_0.VSS.n146 wind_comp_0.sg13g2_and2_2$1_0.VSS.n304 0.639912
R4444 wind_comp_0.sg13g2_and2_2$1_0.VSS.n304 wind_comp_0.sg13g2_and2_2$1_0.VSS.n2348 0.00889112
R4445 wind_comp_0.sg13g2_and2_2$1_0.VSS.n303 wind_comp_0.sg13g2_and2_2$1_0.VSS.n146 0.639912
R4446 wind_comp_0.sg13g2_and2_2$1_0.VSS.n2345 wind_comp_0.sg13g2_and2_2$1_0.VSS.n303 0.00889112
R4447 wind_comp_0.sg13g2_and2_2$1_0.VSS.n146 wind_comp_0.sg13g2_and2_2$1_0.VSS.n302 0.639912
R4448 wind_comp_0.sg13g2_and2_2$1_0.VSS.n302 wind_comp_0.sg13g2_and2_2$1_0.VSS.n2344 0.00889112
R4449 wind_comp_0.sg13g2_and2_2$1_0.VSS.n301 wind_comp_0.sg13g2_and2_2$1_0.VSS.n146 0.639912
R4450 wind_comp_0.sg13g2_and2_2$1_0.VSS.n2342 wind_comp_0.sg13g2_and2_2$1_0.VSS.n301 0.00889112
R4451 wind_comp_0.sg13g2_and2_2$1_0.VSS.n146 wind_comp_0.sg13g2_and2_2$1_0.VSS.n2450 1.28621
R4452 wind_comp_0.sg13g2_and2_2$1_0.VSS.n2056 wind_comp_0.sg13g2_and2_2$1_0.VSS.n2039 1.28621
R4453 wind_comp_0.sg13g2_and2_2$1_0.VSS.n2058 wind_comp_0.sg13g2_and2_2$1_0.VSS.n2038 1.28621
R4454 wind_comp_0.sg13g2_and2_2$1_0.VSS.n2059 wind_comp_0.sg13g2_and2_2$1_0.VSS.n321 1.28621
R4455 wind_comp_0.sg13g2_and2_2$1_0.VSS.n2060 wind_comp_0.sg13g2_and2_2$1_0.VSS.n323 1.28621
R4456 wind_comp_0.sg13g2_and2_2$1_0.VSS.n2061 wind_comp_0.sg13g2_and2_2$1_0.VSS.n322 1.28621
R4457 wind_comp_0.sg13g2_and2_2$1_0.VSS.n2064 wind_comp_0.sg13g2_and2_2$1_0.VSS.n325 1.28621
R4458 wind_comp_0.sg13g2_and2_2$1_0.VSS.n2067 wind_comp_0.sg13g2_and2_2$1_0.VSS.n324 1.28621
R4459 wind_comp_0.sg13g2_and2_2$1_0.VSS.n2070 wind_comp_0.sg13g2_and2_2$1_0.VSS.n327 1.28621
R4460 wind_comp_0.sg13g2_and2_2$1_0.VSS.n2071 wind_comp_0.sg13g2_and2_2$1_0.VSS.n326 1.28621
R4461 wind_comp_0.sg13g2_and2_2$1_0.VSS.n2073 wind_comp_0.sg13g2_and2_2$1_0.VSS.n329 1.28621
R4462 wind_comp_0.sg13g2_and2_2$1_0.VSS.n2076 wind_comp_0.sg13g2_and2_2$1_0.VSS.n328 1.28621
R4463 wind_comp_0.sg13g2_and2_2$1_0.VSS.n2077 wind_comp_0.sg13g2_and2_2$1_0.VSS.n331 1.28621
R4464 wind_comp_0.sg13g2_and2_2$1_0.VSS.n2078 wind_comp_0.sg13g2_and2_2$1_0.VSS.n330 1.28621
R4465 wind_comp_0.sg13g2_and2_2$1_0.VSS.n2079 wind_comp_0.sg13g2_and2_2$1_0.VSS.n333 1.28621
R4466 wind_comp_0.sg13g2_and2_2$1_0.VSS.n2080 wind_comp_0.sg13g2_and2_2$1_0.VSS.n332 1.28621
R4467 wind_comp_0.sg13g2_and2_2$1_0.VSS.n2081 wind_comp_0.sg13g2_and2_2$1_0.VSS.n335 1.28621
R4468 wind_comp_0.sg13g2_and2_2$1_0.VSS.n2082 wind_comp_0.sg13g2_and2_2$1_0.VSS.n334 1.28621
R4469 wind_comp_0.sg13g2_and2_2$1_0.VSS.n2083 wind_comp_0.sg13g2_and2_2$1_0.VSS.n337 1.28621
R4470 wind_comp_0.sg13g2_and2_2$1_0.VSS.n2084 wind_comp_0.sg13g2_and2_2$1_0.VSS.n336 1.28621
R4471 wind_comp_0.sg13g2_and2_2$1_0.VSS.n2085 wind_comp_0.sg13g2_and2_2$1_0.VSS.n339 1.28621
R4472 wind_comp_0.sg13g2_and2_2$1_0.VSS.n2086 wind_comp_0.sg13g2_and2_2$1_0.VSS.n338 1.28621
R4473 wind_comp_0.sg13g2_and2_2$1_0.VSS.n2087 wind_comp_0.sg13g2_and2_2$1_0.VSS.n2037 1.28621
R4474 wind_comp_0.sg13g2_and2_2$1_0.VSS.n2052 wind_comp_0.sg13g2_and2_2$1_0.VSS.n2036 1.28621
R4475 wind_comp_0.sg13g2_and2_2$1_0.VSS.n2051 wind_comp_0.sg13g2_and2_2$1_0.VSS.n2050 1.28621
R4476 wind_comp_0.sg13g2_and2_2$1_0.VSS.n2040 wind_comp_0.sg13g2_and2_2$1_0.VSS.n341 1.28621
R4477 wind_comp_0.sg13g2_and2_2$1_0.VSS.n2044 wind_comp_0.sg13g2_and2_2$1_0.VSS.n2043 1.28621
R4478 wind_comp_0.sg13g2_and2_2$1_0.VSS.n342 wind_comp_0.sg13g2_and2_2$1_0.VSS.n1965 1.28621
R4479 wind_comp_0.sg13g2_and2_2$1_0.VSS.n2131 wind_comp_0.sg13g2_and2_2$1_0.VSS.n344 1.28621
R4480 wind_comp_0.sg13g2_and2_2$1_0.VSS.n2132 wind_comp_0.sg13g2_and2_2$1_0.VSS.n343 1.28621
R4481 wind_comp_0.sg13g2_and2_2$1_0.VSS.n2042 wind_comp_0.sg13g2_and2_2$1_0.VSS.n1963 1.28621
R4482 wind_comp_0.sg13g2_and2_2$1_0.VSS.n2138 wind_comp_0.sg13g2_and2_2$1_0.VSS.n345 1.28621
R4483 wind_comp_0.sg13g2_and2_2$1_0.VSS.n2139 wind_comp_0.sg13g2_and2_2$1_0.VSS.n347 1.28621
R4484 wind_comp_0.sg13g2_and2_2$1_0.VSS.n2142 wind_comp_0.sg13g2_and2_2$1_0.VSS.n346 1.28621
R4485 wind_comp_0.sg13g2_and2_2$1_0.VSS.n2143 wind_comp_0.sg13g2_and2_2$1_0.VSS.n349 1.28621
R4486 wind_comp_0.sg13g2_and2_2$1_0.VSS.n2146 wind_comp_0.sg13g2_and2_2$1_0.VSS.n348 1.28621
R4487 wind_comp_0.sg13g2_and2_2$1_0.VSS.n2149 wind_comp_0.sg13g2_and2_2$1_0.VSS.n351 1.28621
R4488 wind_comp_0.sg13g2_and2_2$1_0.VSS.n2150 wind_comp_0.sg13g2_and2_2$1_0.VSS.n350 1.28621
R4489 wind_comp_0.sg13g2_and2_2$1_0.VSS.n2153 wind_comp_0.sg13g2_and2_2$1_0.VSS.n1962 1.28621
R4490 wind_comp_0.sg13g2_and2_2$1_0.VSS.n65 wind_comp_0.sg13g2_and2_2$1_0.VSS.n56 0.639912
R4491 wind_comp_0.sg13g2_and2_2$1_0.VSS.n56 wind_comp_0.sg13g2_and2_2$1_0.VSS.n321 0.00889112
R4492 wind_comp_0.sg13g2_and2_2$1_0.VSS.n55 wind_comp_0.sg13g2_and2_2$1_0.VSS.n323 0.00889112
R4493 wind_comp_0.sg13g2_and2_2$1_0.VSS.n65 wind_comp_0.sg13g2_and2_2$1_0.VSS.n55 0.639912
R4494 wind_comp_0.sg13g2_and2_2$1_0.VSS.n54 wind_comp_0.sg13g2_and2_2$1_0.VSS.n325 0.00889112
R4495 wind_comp_0.sg13g2_and2_2$1_0.VSS.n65 wind_comp_0.sg13g2_and2_2$1_0.VSS.n54 0.639912
R4496 wind_comp_0.sg13g2_and2_2$1_0.VSS.n58 wind_comp_0.sg13g2_and2_2$1_0.VSS.n327 0.00889112
R4497 wind_comp_0.sg13g2_and2_2$1_0.VSS.n65 wind_comp_0.sg13g2_and2_2$1_0.VSS.n58 0.639912
R4498 wind_comp_0.sg13g2_and2_2$1_0.VSS.n57 wind_comp_0.sg13g2_and2_2$1_0.VSS.n329 0.00889112
R4499 wind_comp_0.sg13g2_and2_2$1_0.VSS.n65 wind_comp_0.sg13g2_and2_2$1_0.VSS.n57 0.639912
R4500 wind_comp_0.sg13g2_and2_2$1_0.VSS.n59 wind_comp_0.sg13g2_and2_2$1_0.VSS.n331 0.00889112
R4501 wind_comp_0.sg13g2_and2_2$1_0.VSS.n65 wind_comp_0.sg13g2_and2_2$1_0.VSS.n59 0.639912
R4502 wind_comp_0.sg13g2_and2_2$1_0.VSS.n60 wind_comp_0.sg13g2_and2_2$1_0.VSS.n333 0.00889112
R4503 wind_comp_0.sg13g2_and2_2$1_0.VSS.n65 wind_comp_0.sg13g2_and2_2$1_0.VSS.n60 0.639912
R4504 wind_comp_0.sg13g2_and2_2$1_0.VSS.n63 wind_comp_0.sg13g2_and2_2$1_0.VSS.n335 0.00889112
R4505 wind_comp_0.sg13g2_and2_2$1_0.VSS.n65 wind_comp_0.sg13g2_and2_2$1_0.VSS.n63 0.639912
R4506 wind_comp_0.sg13g2_and2_2$1_0.VSS.n64 wind_comp_0.sg13g2_and2_2$1_0.VSS.n337 0.00889112
R4507 wind_comp_0.sg13g2_and2_2$1_0.VSS.n65 wind_comp_0.sg13g2_and2_2$1_0.VSS.n64 0.639912
R4508 wind_comp_0.sg13g2_and2_2$1_0.VSS.n62 wind_comp_0.sg13g2_and2_2$1_0.VSS.n339 0.00889112
R4509 wind_comp_0.sg13g2_and2_2$1_0.VSS.n65 wind_comp_0.sg13g2_and2_2$1_0.VSS.n62 0.639912
R4510 wind_comp_0.sg13g2_and2_2$1_0.VSS.n340 wind_comp_0.sg13g2_and2_2$1_0.VSS.n2037 0.00889112
R4511 wind_comp_0.sg13g2_and2_2$1_0.VSS.n65 wind_comp_0.sg13g2_and2_2$1_0.VSS.n340 0.639912
R4512 wind_comp_0.sg13g2_and2_2$1_0.VSS.n2051 wind_comp_0.sg13g2_and2_2$1_0.VSS.n179 0.00889112
R4513 wind_comp_0.sg13g2_and2_2$1_0.VSS.n61 wind_comp_0.sg13g2_and2_2$1_0.VSS.n179 0.639912
R4514 wind_comp_0.sg13g2_and2_2$1_0.VSS.n2043 wind_comp_0.sg13g2_and2_2$1_0.VSS.n180 0.00889112
R4515 wind_comp_0.sg13g2_and2_2$1_0.VSS.n61 wind_comp_0.sg13g2_and2_2$1_0.VSS.n180 0.639912
R4516 wind_comp_0.sg13g2_and2_2$1_0.VSS.n178 wind_comp_0.sg13g2_and2_2$1_0.VSS.n344 0.00889112
R4517 wind_comp_0.sg13g2_and2_2$1_0.VSS.n61 wind_comp_0.sg13g2_and2_2$1_0.VSS.n178 0.639912
R4518 wind_comp_0.sg13g2_and2_2$1_0.VSS.n177 wind_comp_0.sg13g2_and2_2$1_0.VSS.n2042 0.00889112
R4519 wind_comp_0.sg13g2_and2_2$1_0.VSS.n61 wind_comp_0.sg13g2_and2_2$1_0.VSS.n177 0.639912
R4520 wind_comp_0.sg13g2_and2_2$1_0.VSS.n174 wind_comp_0.sg13g2_and2_2$1_0.VSS.n347 0.00889112
R4521 wind_comp_0.sg13g2_and2_2$1_0.VSS.n61 wind_comp_0.sg13g2_and2_2$1_0.VSS.n174 0.639912
R4522 wind_comp_0.sg13g2_and2_2$1_0.VSS.n173 wind_comp_0.sg13g2_and2_2$1_0.VSS.n349 0.00889112
R4523 wind_comp_0.sg13g2_and2_2$1_0.VSS.n61 wind_comp_0.sg13g2_and2_2$1_0.VSS.n173 0.639912
R4524 wind_comp_0.sg13g2_and2_2$1_0.VSS.n175 wind_comp_0.sg13g2_and2_2$1_0.VSS.n351 0.00889112
R4525 wind_comp_0.sg13g2_and2_2$1_0.VSS.n61 wind_comp_0.sg13g2_and2_2$1_0.VSS.n175 0.639912
R4526 wind_comp_0.sg13g2_and2_2$1_0.VSS.n67 wind_comp_0.sg13g2_and2_2$1_0.VSS.n1881 1.2769
R4527 wind_comp_0.sg13g2_and2_2$1_0.VSS.n453 wind_comp_0.sg13g2_and2_2$1_0.VSS.n122 1.27349
R4528 wind_comp_0.sg13g2_and2_2$1_0.VSS.n14 wind_comp_0.sg13g2_and2_2$1_0.VSS.n8 0.764639
R4529 wind_comp_0.sg13g2_and2_2$1_0.VSS.n118 wind_comp_0.comparator_1.dynamic_pcell$1_0.VSS 1.41279
R4530 wind_comp_0.sg13g2_and2_2$1_0.VSS.n155 wind_comp_0.sg13g2_and2_2$1_0.VSS.n185 1.26565
R4531 wind_comp_0.sg13g2_and2_2$1_0.VSS.n148 wind_comp_0.sg13g2_and2_2$1_0.VSS.n151 1.17173
R4532 wind_comp_0.sg13g2_and2_2$1_0.VSS.n747 wind_comp_0.sg13g2_and2_2$1_0.VSS.n8 1.30982
R4533 wind_comp_0.sg13g2_and2_2$1_0.VSS.n2114 wind_comp_0.sg13g2_and2_2$1_0.VSS.n8 1.3099
R4534 wind_comp_0.sg13g2_and2_2$1_0.VSS.n200 wind_comp_0.sg13g2_and2_2$1_0.VSS.n1886 1.25378
R4535 wind_comp_0.sg13g2_and2_2$1_0.VSS.n122 wind_comp_0.sg13g2_and2_2$1_0.VSS.n1375 1.22192
R4536 wind_comp_0.sg13g2_and2_2$1_0.VSS.n907 wind_comp_0.sg13g2_and2_2$1_0.VSS.n75 1.21515
R4537 wind_comp_0.sg13g2_and2_2$1_0.VSS.n905 wind_comp_0.sg13g2_and2_2$1_0.VSS.n76 1.21506
R4538 wind_comp_0.sg13g2_and2_2$1_0.VSS.n193 wind_comp_0.sg13g2_and2_2$1_0.VSS.n300 1.2105
R4539 wind_comp_0.sg13g2_and2_2$1_0.VSS.t410 wind_comp_0.sg13g2_and2_2$1_0.VSS.n1180 1.18034
R4540 wind_comp_0.sg13g2_and2_2$1_0.VSS.n2577 wind_comp_0.sg13g2_and2_2$1_0.VSS.t41 1.16631
R4541 wind_comp_0.sg13g2_and2_2$1_0.VSS.n2589 wind_comp_0.sg13g2_and2_2$1_0.VSS.t59 1.16626
R4542 wind_comp_0.sg13g2_and2_2$1_0.VSS.n894 wind_comp_0.sg13g2_and2_2$1_0.VSS.t13 1.1662
R4543 wind_comp_0.sg13g2_and2_2$1_0.VSS.n994 wind_comp_0.sg13g2_and2_2$1_0.VSS.t235 1.1662
R4544 wind_comp_0.sg13g2_and2_2$1_0.VSS.n1015 wind_comp_0.sg13g2_and2_2$1_0.VSS.t245 1.16618
R4545 wind_comp_0.sg13g2_and2_2$1_0.VSS.n1998 wind_comp_0.sg13g2_and2_2$1_0.VSS.t145 1.16614
R4546 wind_comp_0.sg13g2_and2_2$1_0.VSS.n1983 wind_comp_0.sg13g2_and2_2$1_0.VSS.t48 1.16614
R4547 wind_comp_0.sg13g2_and2_2$1_0.VSS.n2026 wind_comp_0.sg13g2_and2_2$1_0.VSS.t39 1.16614
R4548 wind_comp_0.sg13g2_and2_2$1_0.VSS.n2582 wind_comp_0.sg13g2_and2_2$1_0.VSS.t45 1.16614
R4549 wind_comp_0.sg13g2_and2_2$1_0.VSS.n1048 wind_comp_0.sg13g2_and2_2$1_0.VSS.t142 1.16614
R4550 wind_comp_0.sg13g2_and2_2$1_0.VSS.n890 wind_comp_0.sg13g2_and2_2$1_0.VSS.t133 1.16614
R4551 wind_comp_0.sg13g2_and2_2$1_0.VSS.n2095 wind_comp_0.sg13g2_and2_2$1_0.VSS.t152 1.16614
R4552 wind_comp_0.sg13g2_and2_2$1_0.VSS.n2309 wind_comp_0.sg13g2_and2_2$1_0.VSS.t237 1.16614
R4553 wind_comp_0.sg13g2_and2_2$1_0.VSS.n896 wind_comp_0.sg13g2_and2_2$1_0.VSS.t14 1.16608
R4554 wind_comp_0.sg13g2_and2_2$1_0.VSS.n1985 wind_comp_0.sg13g2_and2_2$1_0.VSS.t47 1.16608
R4555 wind_comp_0.sg13g2_and2_2$1_0.VSS.n785 wind_comp_0.sg13g2_and2_2$1_0.VSS.t9 1.16608
R4556 wind_comp_0.sg13g2_and2_2$1_0.VSS.n972 wind_comp_0.sg13g2_and2_2$1_0.VSS.t33 1.16608
R4557 wind_comp_0.sg13g2_and2_2$1_0.VSS.n1021 wind_comp_0.sg13g2_and2_2$1_0.VSS.t240 1.16608
R4558 wind_comp_0.sg13g2_and2_2$1_0.VSS.n2229 wind_comp_0.sg13g2_and2_2$1_0.VSS.t213 1.16608
R4559 wind_comp_0.sg13g2_and2_2$1_0.VSS.n2231 wind_comp_0.sg13g2_and2_2$1_0.VSS.t214 1.16604
R4560 wind_comp_0.sg13g2_and2_2$1_0.VSS.n884 wind_comp_0.sg13g2_and2_2$1_0.VSS.t132 1.16604
R4561 wind_comp_0.sg13g2_and2_2$1_0.VSS.n2584 wind_comp_0.sg13g2_and2_2$1_0.VSS.t53 1.16603
R4562 wind_comp_0.sg13g2_and2_2$1_0.VSS.n2311 wind_comp_0.sg13g2_and2_2$1_0.VSS.t238 1.16599
R4563 wind_comp_0.sg13g2_and2_2$1_0.VSS.n989 wind_comp_0.sg13g2_and2_2$1_0.VSS.t231 1.16599
R4564 wind_comp_0.sg13g2_and2_2$1_0.VSS.n1991 wind_comp_0.sg13g2_and2_2$1_0.VSS.t144 1.16595
R4565 wind_comp_0.sg13g2_and2_2$1_0.VSS.n2020 wind_comp_0.sg13g2_and2_2$1_0.VSS.t28 1.16595
R4566 wind_comp_0.sg13g2_and2_2$1_0.VSS.n774 wind_comp_0.sg13g2_and2_2$1_0.VSS.t25 1.16595
R4567 wind_comp_0.sg13g2_and2_2$1_0.VSS.n977 wind_comp_0.sg13g2_and2_2$1_0.VSS.t34 1.16595
R4568 wind_comp_0.sg13g2_and2_2$1_0.VSS.n1054 wind_comp_0.sg13g2_and2_2$1_0.VSS.t138 1.16595
R4569 wind_comp_0.sg13g2_and2_2$1_0.VSS.n2108 wind_comp_0.sg13g2_and2_2$1_0.VSS.t149 1.16595
R4570 wind_comp_0.sg13g2_and2_2$1_0.VSS.n777 wind_comp_0.sg13g2_and2_2$1_0.VSS.t22 1.16591
R4571 wind_comp_0.sg13g2_and2_2$1_0.VSS.n783 wind_comp_0.sg13g2_and2_2$1_0.VSS.t10 1.16589
R4572 wind_comp_0.sg13g2_and2_2$1_0.VSS.n8 wind_comp_0.sg13g2_and2_2$1_0.VSS.n697 1.1352
R4573 wind_comp_0.comparator_1.dynamic_pcell$2_0.VSS wind_comp_0.sg13g2_and2_2$1_0.VSS.n77 1.13455
R4574 wind_comp_0.sg13g2_and2_2$1_0.VSS.n2595 wind_comp_0.sg13g2_and2_2$1_0.VSS.n2594 1.1291
R4575 wind_comp_0.sg13g2_and2_2$1_0.VSS.n2291 wind_comp_0.sg13g2_and2_2$1_0.VSS.n2257 1.1291
R4576 wind_comp_0.sg13g2_and2_2$1_0.VSS.n2581 wind_comp_0.sg13g2_and2_2$1_0.VSS.n2576 1.09683
R4577 wind_comp_0.sg13g2_and2_2$1_0.VSS.n249 wind_comp_0.sg13g2_and2_2$1_0.VSS.n2583 1.09683
R4578 wind_comp_0.sg13g2_and2_2$1_0.VSS.n2588 wind_comp_0.sg13g2_and2_2$1_0.VSS.n249 1.09683
R4579 wind_comp_0.sg13g2_and2_2$1_0.VSS.n1313 wind_comp_0.sg13g2_and2_2$1_0.VSS.n455 1.07308
R4580 wind_comp_0.sg13g2_and2_2$1_0.VSS.n1451 wind_comp_0.sg13g2_and2_2$1_0.VSS.n457 1.07308
R4581 wind_comp_0.sg13g2_and2_2$1_0.VSS.t251 wind_comp_0.sg13g2_and2_2$1_0.VSS.t61 1.07308
R4582 wind_comp_0.sg13g2_and2_2$1_0.VSS.n1356 wind_comp_0.sg13g2_and2_2$1_0.VSS.n458 1.07308
R4583 wind_comp_0.sg13g2_and2_2$1_0.VSS.n1358 wind_comp_0.sg13g2_and2_2$1_0.VSS.n459 1.07308
R4584 wind_comp_0.sg13g2_and2_2$1_0.VSS.n1447 wind_comp_0.sg13g2_and2_2$1_0.VSS.n460 1.07308
R4585 wind_comp_0.sg13g2_and2_2$1_0.VSS.n1360 wind_comp_0.sg13g2_and2_2$1_0.VSS.n461 1.07308
R4586 wind_comp_0.sg13g2_and2_2$1_0.VSS.n1362 wind_comp_0.sg13g2_and2_2$1_0.VSS.n462 1.07308
R4587 wind_comp_0.sg13g2_and2_2$1_0.VSS.n1444 wind_comp_0.sg13g2_and2_2$1_0.VSS.n463 1.07308
R4588 wind_comp_0.sg13g2_and2_2$1_0.VSS.n1462 wind_comp_0.sg13g2_and2_2$1_0.VSS.n464 1.07308
R4589 wind_comp_0.sg13g2_and2_2$1_0.VSS.n1463 wind_comp_0.sg13g2_and2_2$1_0.VSS.n1364 1.07308
R4590 wind_comp_0.sg13g2_and2_2$1_0.VSS.n1365 wind_comp_0.sg13g2_and2_2$1_0.VSS.n465 1.07308
R4591 wind_comp_0.sg13g2_and2_2$1_0.VSS.n1367 wind_comp_0.sg13g2_and2_2$1_0.VSS.n466 1.07308
R4592 wind_comp_0.sg13g2_and2_2$1_0.VSS.n1369 wind_comp_0.sg13g2_and2_2$1_0.VSS.n468 1.07308
R4593 wind_comp_0.sg13g2_and2_2$1_0.VSS.n1371 wind_comp_0.sg13g2_and2_2$1_0.VSS.n469 1.07308
R4594 wind_comp_0.sg13g2_and2_2$1_0.VSS.n1469 wind_comp_0.sg13g2_and2_2$1_0.VSS.n470 1.07308
R4595 wind_comp_0.sg13g2_and2_2$1_0.VSS.n1441 wind_comp_0.sg13g2_and2_2$1_0.VSS.n471 1.07308
R4596 wind_comp_0.sg13g2_and2_2$1_0.VSS.n1373 wind_comp_0.sg13g2_and2_2$1_0.VSS.n472 1.07308
R4597 wind_comp_0.sg13g2_and2_2$1_0.VSS.n1439 wind_comp_0.sg13g2_and2_2$1_0.VSS.n474 1.07308
R4598 wind_comp_0.sg13g2_and2_2$1_0.VSS.n1378 wind_comp_0.sg13g2_and2_2$1_0.VSS.n475 1.07308
R4599 wind_comp_0.sg13g2_and2_2$1_0.VSS.n1477 wind_comp_0.sg13g2_and2_2$1_0.VSS.t269 1.07308
R4600 wind_comp_0.sg13g2_and2_2$1_0.VSS.n1380 wind_comp_0.sg13g2_and2_2$1_0.VSS.n476 1.07308
R4601 wind_comp_0.sg13g2_and2_2$1_0.VSS.t2 wind_comp_0.sg13g2_and2_2$1_0.VSS.n477 1.07308
R4602 wind_comp_0.sg13g2_and2_2$1_0.VSS.n1383 wind_comp_0.sg13g2_and2_2$1_0.VSS.n478 1.07308
R4603 wind_comp_0.sg13g2_and2_2$1_0.VSS.n1483 wind_comp_0.sg13g2_and2_2$1_0.VSS.n1384 1.07308
R4604 wind_comp_0.sg13g2_and2_2$1_0.VSS.n1385 wind_comp_0.sg13g2_and2_2$1_0.VSS.n479 1.07308
R4605 wind_comp_0.sg13g2_and2_2$1_0.VSS.n1484 wind_comp_0.sg13g2_and2_2$1_0.VSS.n481 1.07308
R4606 wind_comp_0.sg13g2_and2_2$1_0.VSS.n1389 wind_comp_0.sg13g2_and2_2$1_0.VSS.n482 1.07308
R4607 wind_comp_0.sg13g2_and2_2$1_0.VSS.n1488 wind_comp_0.sg13g2_and2_2$1_0.VSS.n483 1.07308
R4608 wind_comp_0.sg13g2_and2_2$1_0.VSS.n1393 wind_comp_0.sg13g2_and2_2$1_0.VSS.n484 1.07308
R4609 wind_comp_0.sg13g2_and2_2$1_0.VSS.n1396 wind_comp_0.sg13g2_and2_2$1_0.VSS.t64 1.07308
R4610 wind_comp_0.sg13g2_and2_2$1_0.VSS.n1492 wind_comp_0.sg13g2_and2_2$1_0.VSS.n485 1.07308
R4611 wind_comp_0.sg13g2_and2_2$1_0.VSS.n1397 wind_comp_0.sg13g2_and2_2$1_0.VSS.n486 1.07308
R4612 wind_comp_0.sg13g2_and2_2$1_0.VSS.n1523 wind_comp_0.sg13g2_and2_2$1_0.VSS.n1399 1.07308
R4613 wind_comp_0.sg13g2_and2_2$1_0.VSS.t351 wind_comp_0.sg13g2_and2_2$1_0.VSS.n1418 1.07308
R4614 wind_comp_0.sg13g2_and2_2$1_0.VSS.n1262 wind_comp_0.sg13g2_and2_2$1_0.VSS.t79 1.07308
R4615 wind_comp_0.sg13g2_and2_2$1_0.VSS.t354 wind_comp_0.sg13g2_and2_2$1_0.VSS.n1413 1.07308
R4616 wind_comp_0.sg13g2_and2_2$1_0.VSS.n1414 wind_comp_0.sg13g2_and2_2$1_0.VSS.t354 1.07308
R4617 wind_comp_0.sg13g2_and2_2$1_0.VSS.t82 wind_comp_0.sg13g2_and2_2$1_0.VSS.n500 1.07308
R4618 wind_comp_0.sg13g2_and2_2$1_0.VSS.n1401 wind_comp_0.sg13g2_and2_2$1_0.VSS.n1400 1.07308
R4619 wind_comp_0.sg13g2_and2_2$1_0.VSS.n1521 wind_comp_0.sg13g2_and2_2$1_0.VSS.n1520 1.07308
R4620 wind_comp_0.sg13g2_and2_2$1_0.VSS.n395 wind_comp_0.sg13g2_and2_2$1_0.VSS.t16 1.07308
R4621 wind_comp_0.sg13g2_and2_2$1_0.VSS.t100 wind_comp_0.sg13g2_and2_2$1_0.VSS.n1195 1.07308
R4622 wind_comp_0.sg13g2_and2_2$1_0.VSS.n581 wind_comp_0.sg13g2_and2_2$1_0.VSS.t102 1.07308
R4623 wind_comp_0.sg13g2_and2_2$1_0.VSS.n1657 wind_comp_0.sg13g2_and2_2$1_0.VSS.t371 1.07308
R4624 wind_comp_0.sg13g2_and2_2$1_0.VSS.n1629 wind_comp_0.sg13g2_and2_2$1_0.VSS.n421 1.07308
R4625 wind_comp_0.sg13g2_and2_2$1_0.VSS.n1628 wind_comp_0.sg13g2_and2_2$1_0.VSS.t306 1.07308
R4626 wind_comp_0.sg13g2_and2_2$1_0.VSS.n1622 wind_comp_0.sg13g2_and2_2$1_0.VSS.n409 1.07308
R4627 wind_comp_0.sg13g2_and2_2$1_0.VSS.t121 wind_comp_0.sg13g2_and2_2$1_0.VSS.t323 1.07308
R4628 wind_comp_0.sg13g2_and2_2$1_0.VSS.n1524 wind_comp_0.sg13g2_and2_2$1_0.VSS.t341 1.07308
R4629 wind_comp_0.sg13g2_and2_2$1_0.VSS.t0 wind_comp_0.sg13g2_and2_2$1_0.VSS.n467 1.07308
R4630 wind_comp_0.sg13g2_and2_2$1_0.VSS.n1438 wind_comp_0.sg13g2_and2_2$1_0.VSS.t2 1.07308
R4631 wind_comp_0.sg13g2_and2_2$1_0.VSS.n1395 wind_comp_0.sg13g2_and2_2$1_0.VSS.t338 1.07308
R4632 wind_comp_0.sg13g2_and2_2$1_0.VSS.n1391 wind_comp_0.sg13g2_and2_2$1_0.VSS.t334 1.07308
R4633 wind_comp_0.sg13g2_and2_2$1_0.VSS.n2530 wind_comp_0.sg13g2_and2_2$1_0.VSS.n83 0.623068
R4634 wind_comp_0.sg13g2_and2_2$1_0.VSS.n782 wind_comp_0.sg13g2_and2_2$1_0.VSS.n202 0.934204
R4635 wind_comp_0.sg13g2_and2_2$1_0.VSS.n2 wind_comp_0.comparator_0.dynamic_pcell$2_0.VSS 1.03324
R4636 wind_comp_0.sg13g2_and2_2$1_0.VSS.n2612 wind_comp_0.comparator_0.dynamic_pcell$2_0.SRC_NET_MNO 1.02084
R4637 wind_comp_0.sg13g2_and2_2$1_0.VSS.n2253 wind_comp_0.comparator_1.dynamic_pcell$2_0.SRC_NET_MNO 1.02084
R4638 wind_comp_0.sg13g2_and2_2$1_0.VSS.n2274 wind_comp_0.comparator_1.dynamic_pcell$2_0.SRC_NET_MNO 1.02084
R4639 wind_comp_0.sg13g2_and2_2$1_0.VSS.n2621 wind_comp_0.comparator_0.dynamic_pcell$2_0.SRC_NET_MNO 1.02084
R4640 wind_comp_0.comparator_1.dynamic_pcell_0.VSS wind_comp_0.sg13g2_and2_2$1_0.VSS.n100 1.02061
R4641 wind_comp_0.sg13g2_and2_2$1_0.VSS.n2563 wind_comp_0.sg13g2_and2_2$1_0.VSS.n300 0.9905
R4642 wind_comp_0.sg13g2_and2_2$1_0.VSS.n1540 wind_comp_0.sg13g2_and2_2$1_0.VSS.n1539 0.979551
R4643 wind_comp_0.comparator_0.dynamic_pcell$2_0.VSS wind_comp_0.sg13g2_and2_2$1_0.VSS.n6 1.2297
R4644 wind_comp_0.sg13g2_and2_2$1_0.VSS.n53 wind_comp_0.comparator_1.dynamic_pcell$2_0.VSS 1.02206
R4645 wind_comp_0.sg13g2_and2_2$1_0.VSS.n0 wind_comp_0.comparator_0.dynamic_pcell$2_0.VSS 0.942846
R4646 wind_comp_0.sg13g2_and2_2$1_0.VSS.n1558 wind_comp_0.sg13g2_and2_2$1_0.VSS.n1546 0.941738
R4647 wind_comp_0.sg13g2_and2_2$1_0.VSS.n1535 wind_comp_0.sg13g2_and2_2$1_0.VSS.n1525 0.933833
R4648 wind_comp_0.sg13g2_and2_2$1_0.VSS.n1562 wind_comp_0.sg13g2_and2_2$1_0.VSS.n1561 0.933833
R4649 wind_comp_0.sg13g2_and2_2$1_0.VSS.n77 wind_comp_0.sg13g2_and2_2$1_0.VSS.n903 0.932078
R4650 wind_comp_0.sg13g2_and2_2$1_0.VSS.n124 wind_comp_0.sg13g2_and2_2$1_0.VSS.n123 0.655201
R4651 wind_comp_0.sg13g2_and2_2$1_0.VSS.n102 wind_comp_0.sg13g2_and2_2$1_0.VSS.n97 0.835133
R4652 wind_comp_0.sg13g2_and2_2$1_0.VSS.n102 wind_comp_0.comparator_1.dynamic_pcell_0.VSS 0.943883
R4653 wind_comp_0.sg13g2_and2_2$1_0.VSS.n124 wind_comp_0.sg13g2_and2_2$1_0.VSS.t154 0.895237
R4654 wind_comp_0.sg13g2_and2_2$1_0.VSS.n2126 wind_comp_0.comparator_0.dynamic_pcell$2_0.SRC_NET_MNO 0.8937
R4655 wind_comp_0.sg13g2_and2_2$1_0.VSS.n2575 wind_comp_0.comparator_0.dynamic_pcell$2_0.SRC_NET_MNO 0.8937
R4656 wind_comp_0.sg13g2_and2_2$1_0.VSS.n2283 wind_comp_0.comparator_1.dynamic_pcell$2_0.SRC_NET_MNO 0.8937
R4657 wind_comp_0.sg13g2_and2_2$1_0.VSS.n2289 wind_comp_0.comparator_1.dynamic_pcell$2_0.SRC_NET_MNO 0.8937
R4658 wind_comp_0.sg13g2_and2_2$1_0.VSS.n206 wind_comp_0.sg13g2_and2_2$1_0.VSS.n1272 0.904382
R4659 wind_comp_0.sg13g2_and2_2$1_0.VSS.n249 wind_comp_0.sg13g2_and2_2$1_0.VSS.n246 0.860333
R4660 wind_comp_0.sg13g2_and2_2$1_0.VSS.n1459 wind_comp_0.sg13g2_and2_2$1_0.VSS.n456 0.858562
R4661 wind_comp_0.sg13g2_and2_2$1_0.VSS.t61 wind_comp_0.sg13g2_and2_2$1_0.VSS.n458 0.858562
R4662 wind_comp_0.sg13g2_and2_2$1_0.VSS.n1477 wind_comp_0.sg13g2_and2_2$1_0.VSS.n476 0.858562
R4663 wind_comp_0.sg13g2_and2_2$1_0.VSS.n1437 wind_comp_0.sg13g2_and2_2$1_0.VSS.n480 0.858562
R4664 wind_comp_0.sg13g2_and2_2$1_0.VSS.n1506 wind_comp_0.sg13g2_and2_2$1_0.VSS.n498 0.858562
R4665 wind_comp_0.sg13g2_and2_2$1_0.VSS.n1506 wind_comp_0.sg13g2_and2_2$1_0.VSS.n1505 0.858562
R4666 wind_comp_0.sg13g2_and2_2$1_0.VSS.n1408 wind_comp_0.sg13g2_and2_2$1_0.VSS.n1407 0.858562
R4667 wind_comp_0.sg13g2_and2_2$1_0.VSS.t6 wind_comp_0.sg13g2_and2_2$1_0.VSS.n130 3.87251
R4668 wind_comp_0.sg13g2_and2_2$1_0.VSS.n1639 wind_comp_0.sg13g2_and2_2$1_0.VSS.n389 0.858562
R4669 wind_comp_0.sg13g2_and2_2$1_0.VSS.n579 wind_comp_0.sg13g2_and2_2$1_0.VSS.n1639 0.858562
R4670 wind_comp_0.sg13g2_and2_2$1_0.VSS.n579 wind_comp_0.sg13g2_and2_2$1_0.VSS.t372 0.858562
R4671 wind_comp_0.sg13g2_and2_2$1_0.VSS.n576 wind_comp_0.sg13g2_and2_2$1_0.VSS.t375 0.858562
R4672 wind_comp_0.sg13g2_and2_2$1_0.VSS.n575 wind_comp_0.sg13g2_and2_2$1_0.VSS.n1659 0.858562
R4673 wind_comp_0.sg13g2_and2_2$1_0.VSS.n573 wind_comp_0.sg13g2_and2_2$1_0.VSS.t378 0.858562
R4674 wind_comp_0.sg13g2_and2_2$1_0.VSS.n570 wind_comp_0.sg13g2_and2_2$1_0.VSS.t381 0.858562
R4675 wind_comp_0.sg13g2_and2_2$1_0.VSS.n1631 wind_comp_0.sg13g2_and2_2$1_0.VSS.n1111 0.858562
R4676 wind_comp_0.sg13g2_and2_2$1_0.VSS.n558 wind_comp_0.sg13g2_and2_2$1_0.VSS.n1678 0.858562
R4677 wind_comp_0.sg13g2_and2_2$1_0.VSS.n554 wind_comp_0.sg13g2_and2_2$1_0.VSS.n1628 0.858562
R4678 wind_comp_0.sg13g2_and2_2$1_0.VSS.n1622 wind_comp_0.sg13g2_and2_2$1_0.VSS.n1071 0.858562
R4679 wind_comp_0.sg13g2_and2_2$1_0.VSS.n1692 wind_comp_0.sg13g2_and2_2$1_0.VSS.n1066 0.858562
R4680 wind_comp_0.sg13g2_and2_2$1_0.VSS.n536 wind_comp_0.sg13g2_and2_2$1_0.VSS.t121 0.858562
R4681 wind_comp_0.sg13g2_and2_2$1_0.VSS.n1614 wind_comp_0.sg13g2_and2_2$1_0.VSS.t324 0.858562
R4682 wind_comp_0.sg13g2_and2_2$1_0.VSS.n534 wind_comp_0.sg13g2_and2_2$1_0.VSS.n1614 0.858562
R4683 wind_comp_0.sg13g2_and2_2$1_0.VSS.n1565 wind_comp_0.sg13g2_and2_2$1_0.VSS.n124 0.851793
R4684 wind_comp_0.sg13g2_and2_2$1_0.VSS.n101 wind_comp_0.sg13g2_and2_2$1_0.VSS.n99 0.850987
R4685 wind_comp_0.sg13g2_and2_2$1_0.VSS.n34 wind_comp_0.sg13g2_and2_2$1_0.VSS.n13 0.622979
R4686 wind_comp_0.sg13g2_and2_2$1_0.VSS.n0 wind_comp_0.sg13g2_and2_2$1_0.VSS.n1981 0.841999
R4687 wind_comp_0.sg13g2_and2_2$1_0.VSS.n53 wind_comp_0.sg13g2_and2_2$1_0.VSS.n52 0.664936
R4688 wind_comp_0.sg13g2_and2_2$1_0.VSS.n193 wind_comp_0.sg13g2_and2_2$1_0.VSS.n73 1.41811
R4689 wind_comp_0.sg13g2_and2_2$1_0.VSS.n95 wind_comp_0.sg13g2_and2_2$1_0.VSS.n83 0.396003
R4690 wind_comp_0.sg13g2_and2_2$1_0.VSS.n1528 wind_comp_0.sg13g2_and2_2$1_0.VSS.n606 0.819389
R4691 wind_comp_0.sg13g2_and2_2$1_0.VSS.n1544 wind_comp_0.sg13g2_and2_2$1_0.VSS.n1525 0.819389
R4692 wind_comp_0.sg13g2_and2_2$1_0.VSS.n1554 wind_comp_0.sg13g2_and2_2$1_0.VSS.n214 0.819389
R4693 wind_comp_0.sg13g2_and2_2$1_0.VSS.n1563 wind_comp_0.sg13g2_and2_2$1_0.VSS.n1562 0.819389
R4694 wind_comp_0.sg13g2_and2_2$1_0.VSS.n1571 wind_comp_0.sg13g2_and2_2$1_0.VSS.n124 0.81462
R4695 wind_comp_0.sg13g2_and2_2$1_0.VSS.n903 wind_comp_0.sg13g2_and2_2$1_0.VSS.n78 0.813715
R4696 wind_comp_0.sg13g2_and2_2$1_0.VSS.n2524 wind_comp_0.sg13g2_and2_2$1_0.VSS.n100 0.807541
R4697 wind_comp_0.sg13g2_and2_2$1_0.VSS.n1555 wind_comp_0.sg13g2_and2_2$1_0.VSS.n1545 0.8045
R4698 wind_comp_0.sg13g2_and2_2$1_0.VSS.n79 wind_comp_0.sg13g2_and2_2$1_0.VSS.n78 0.802712
R4699 wind_comp_0.sg13g2_and2_2$1_0.VSS.n690 wind_comp_0.sg13g2_and2_2$1_0.VSS.n2 0.801076
R4700 wind_comp_0.sg13g2_and2_2$1_0.VSS.n1539 wind_comp_0.sg13g2_and2_2$1_0.VSS.n1525 0.758278
R4701 wind_comp_0.sg13g2_and2_2$1_0.VSS.n1562 wind_comp_0.sg13g2_and2_2$1_0.VSS.n1546 0.758278
R4702 wind_comp_0.sg13g2_and2_2$1_0.VSS.n970 wind_comp_0.sg13g2_and2_2$1_0.VSS.t32 0.728252
R4703 wind_comp_0.sg13g2_and2_2$1_0.VSS.n101 wind_comp_0.sg13g2_and2_2$1_0.VSS.n100 0.723821
R4704 wind_comp_0.sg13g2_and2_2$1_0.VSS.n4 wind_comp_0.sg13g2_and2_2$1_0.VSS.n2 0.722091
R4705 wind_comp_0.sg13g2_and2_2$1_0.VSS.n202 wind_comp_0.comparator_0.dynamic_pcell$2_0.VSS 1.13315
R4706 wind_comp_0.sg13g2_and2_2$1_0.VSS.n4 wind_comp_0.sg13g2_and2_2$1_0.VSS.n1 0.515113
R4707 wind_comp_0.comparator_0.dynamic_pcell$1_0.SRC_NET_PQRS wind_comp_0.sg13g2_and2_2$1_0.VSS.n700 0.70359
R4708 wind_comp_0.sg13g2_and2_2$1_0.VSS.n700 wind_comp_0.comparator_0.dynamic_pcell$1_0.SRC_NET_PQRS 0.70359
R4709 wind_comp_0.comparator_0.dynamic_pcell$1_0.SRC_NET_PQRS wind_comp_0.sg13g2_and2_2$1_0.VSS.n699 0.70359
R4710 wind_comp_0.sg13g2_and2_2$1_0.VSS.n699 wind_comp_0.comparator_0.dynamic_pcell$1_0.SRC_NET_PQRS 0.70359
R4711 wind_comp_0.comparator_0.dynamic_pcell$1_0.SRC_NET_PQRS wind_comp_0.sg13g2_and2_2$1_0.VSS.n698 0.70359
R4712 wind_comp_0.sg13g2_and2_2$1_0.VSS.n1956 wind_comp_0.comparator_1.dynamic_pcell$1_0.SRC_NET_PQRS 0.70359
R4713 wind_comp_0.comparator_1.dynamic_pcell$1_0.SRC_NET_PQRS wind_comp_0.sg13g2_and2_2$1_0.VSS.n1956 0.70359
R4714 wind_comp_0.sg13g2_and2_2$1_0.VSS.n1957 wind_comp_0.comparator_1.dynamic_pcell$1_0.SRC_NET_PQRS 0.70359
R4715 wind_comp_0.comparator_1.dynamic_pcell$1_0.SRC_NET_PQRS wind_comp_0.sg13g2_and2_2$1_0.VSS.n1957 0.70359
R4716 wind_comp_0.comparator_1.dynamic_pcell$1_0.SRC_NET_PQRS wind_comp_0.sg13g2_and2_2$1_0.VSS.n1958 0.70359
R4717 wind_comp_0.sg13g2_and2_2$1_0.VSS.n8 wind_comp_0.sg13g2_and2_2$1_0.VSS.n7 0.696579
R4718 wind_comp_0.sg13g2_and2_2$1_0.VSS.n2522 wind_comp_0.sg13g2_and2_2$1_0.VSS.n2521 0.68159
R4719 wind_comp_0.sg13g2_and2_2$1_0.VSS.n1568 wind_comp_0.sg13g2_and2_2$1_0.VSS.n1567 0.68159
R4720 wind_comp_0.sg13g2_and2_2$1_0.VSS.n13 wind_comp_0.comparator_0.dynamic_pcell$2_0.VSS 1.03954
R4721 wind_comp_0.sg13g2_and2_2$1_0.VSS.n4 wind_comp_0.sg13g2_and2_2$1_0.VSS.n0 0.656813
R4722 wind_comp_0.sg13g2_and2_2$1_0.VSS.n1458 wind_comp_0.sg13g2_and2_2$1_0.VSS.t249 0.644047
R4723 wind_comp_0.sg13g2_and2_2$1_0.VSS.t253 wind_comp_0.sg13g2_and2_2$1_0.VSS.n1358 0.644047
R4724 wind_comp_0.sg13g2_and2_2$1_0.VSS.t55 wind_comp_0.sg13g2_and2_2$1_0.VSS.t254 0.644047
R4725 wind_comp_0.sg13g2_and2_2$1_0.VSS.t256 wind_comp_0.sg13g2_and2_2$1_0.VSS.n1362 0.644047
R4726 wind_comp_0.sg13g2_and2_2$1_0.VSS.t259 wind_comp_0.sg13g2_and2_2$1_0.VSS.n1365 0.644047
R4727 wind_comp_0.sg13g2_and2_2$1_0.VSS.t262 wind_comp_0.sg13g2_and2_2$1_0.VSS.n1369 0.644047
R4728 wind_comp_0.sg13g2_and2_2$1_0.VSS.n1443 wind_comp_0.sg13g2_and2_2$1_0.VSS.n1370 0.644047
R4729 wind_comp_0.sg13g2_and2_2$1_0.VSS.n1470 wind_comp_0.sg13g2_and2_2$1_0.VSS.n1469 0.644047
R4730 wind_comp_0.sg13g2_and2_2$1_0.VSS.t265 wind_comp_0.sg13g2_and2_2$1_0.VSS.n1441 0.644047
R4731 wind_comp_0.sg13g2_and2_2$1_0.VSS.n1474 wind_comp_0.sg13g2_and2_2$1_0.VSS.n1473 0.644047
R4732 wind_comp_0.sg13g2_and2_2$1_0.VSS.t268 wind_comp_0.sg13g2_and2_2$1_0.VSS.n1439 0.644047
R4733 wind_comp_0.sg13g2_and2_2$1_0.VSS.n1440 wind_comp_0.sg13g2_and2_2$1_0.VSS.n1377 0.644047
R4734 wind_comp_0.sg13g2_and2_2$1_0.VSS.n1392 wind_comp_0.sg13g2_and2_2$1_0.VSS.t67 0.644047
R4735 wind_comp_0.sg13g2_and2_2$1_0.VSS.t344 wind_comp_0.sg13g2_and2_2$1_0.VSS.n1430 0.644047
R4736 wind_comp_0.sg13g2_and2_2$1_0.VSS.t347 wind_comp_0.sg13g2_and2_2$1_0.VSS.n1426 0.644047
R4737 wind_comp_0.sg13g2_and2_2$1_0.VSS.n1423 wind_comp_0.sg13g2_and2_2$1_0.VSS.n1422 0.644047
R4738 wind_comp_0.sg13g2_and2_2$1_0.VSS.t350 wind_comp_0.sg13g2_and2_2$1_0.VSS.n1259 0.644047
R4739 wind_comp_0.sg13g2_and2_2$1_0.VSS.t353 wind_comp_0.sg13g2_and2_2$1_0.VSS.n1261 0.644047
R4740 wind_comp_0.sg13g2_and2_2$1_0.VSS.n1508 wind_comp_0.sg13g2_and2_2$1_0.VSS.t82 0.644047
R4741 wind_comp_0.sg13g2_and2_2$1_0.VSS.t84 wind_comp_0.sg13g2_and2_2$1_0.VSS.n1301 0.644047
R4742 wind_comp_0.sg13g2_and2_2$1_0.VSS.n1899 wind_comp_0.sg13g2_and2_2$1_0.VSS.n1304 0.644047
R4743 wind_comp_0.sg13g2_and2_2$1_0.VSS.n1305 wind_comp_0.sg13g2_and2_2$1_0.VSS.n1228 0.644047
R4744 wind_comp_0.sg13g2_and2_2$1_0.VSS.n2568 wind_comp_0.sg13g2_and2_2$1_0.VSS.n1227 0.644047
R4745 wind_comp_0.sg13g2_and2_2$1_0.VSS.n2569 wind_comp_0.sg13g2_and2_2$1_0.VSS.n131 3.05209
R4746 wind_comp_0.sg13g2_and2_2$1_0.VSS.n1584 wind_comp_0.sg13g2_and2_2$1_0.VSS.t326 0.644047
R4747 wind_comp_0.sg13g2_and2_2$1_0.VSS.n365 wind_comp_0.sg13g2_and2_2$1_0.VSS.t100 0.644047
R4748 wind_comp_0.sg13g2_and2_2$1_0.VSS.n1606 wind_comp_0.sg13g2_and2_2$1_0.VSS.n1176 0.644047
R4749 wind_comp_0.sg13g2_and2_2$1_0.VSS.n1600 wind_comp_0.sg13g2_and2_2$1_0.VSS.n1175 0.644047
R4750 wind_comp_0.sg13g2_and2_2$1_0.VSS.n1603 wind_comp_0.sg13g2_and2_2$1_0.VSS.n1172 0.644047
R4751 wind_comp_0.sg13g2_and2_2$1_0.VSS.n1601 wind_comp_0.sg13g2_and2_2$1_0.VSS.n1171 0.644047
R4752 wind_comp_0.sg13g2_and2_2$1_0.VSS.n1602 wind_comp_0.sg13g2_and2_2$1_0.VSS.n1168 0.644047
R4753 wind_comp_0.sg13g2_and2_2$1_0.VSS.n1649 wind_comp_0.sg13g2_and2_2$1_0.VSS.n1167 0.644047
R4754 wind_comp_0.sg13g2_and2_2$1_0.VSS.t102 wind_comp_0.sg13g2_and2_2$1_0.VSS.n387 0.644047
R4755 wind_comp_0.sg13g2_and2_2$1_0.VSS.t371 wind_comp_0.sg13g2_and2_2$1_0.VSS.n1147 0.644047
R4756 wind_comp_0.sg13g2_and2_2$1_0.VSS.t97 wind_comp_0.sg13g2_and2_2$1_0.VSS.n1143 0.644047
R4757 wind_comp_0.sg13g2_and2_2$1_0.VSS.t374 wind_comp_0.sg13g2_and2_2$1_0.VSS.n1140 0.644047
R4758 wind_comp_0.sg13g2_and2_2$1_0.VSS.t377 wind_comp_0.sg13g2_and2_2$1_0.VSS.n1135 0.644047
R4759 wind_comp_0.sg13g2_and2_2$1_0.VSS.t380 wind_comp_0.sg13g2_and2_2$1_0.VSS.n1128 0.644047
R4760 wind_comp_0.sg13g2_and2_2$1_0.VSS.t383 wind_comp_0.sg13g2_and2_2$1_0.VSS.n1123 0.644047
R4761 wind_comp_0.sg13g2_and2_2$1_0.VSS.n2529 wind_comp_0.sg13g2_and2_2$1_0.VSS.n1120 0.644047
R4762 wind_comp_0.sg13g2_and2_2$1_0.VSS.n1666 wind_comp_0.sg13g2_and2_2$1_0.VSS.n1119 0.644047
R4763 wind_comp_0.sg13g2_and2_2$1_0.VSS.t386 wind_comp_0.sg13g2_and2_2$1_0.VSS.n1116 0.644047
R4764 wind_comp_0.sg13g2_and2_2$1_0.VSS.n424 wind_comp_0.sg13g2_and2_2$1_0.VSS.n1115 0.644047
R4765 wind_comp_0.sg13g2_and2_2$1_0.VSS.n400 wind_comp_0.sg13g2_and2_2$1_0.VSS.n1112 0.644047
R4766 wind_comp_0.sg13g2_and2_2$1_0.VSS.t389 wind_comp_0.sg13g2_and2_2$1_0.VSS.n1111 0.644047
R4767 wind_comp_0.sg13g2_and2_2$1_0.VSS.t119 wind_comp_0.sg13g2_and2_2$1_0.VSS.n401 0.644047
R4768 wind_comp_0.sg13g2_and2_2$1_0.VSS.n401 wind_comp_0.sg13g2_and2_2$1_0.VSS.n1108 0.644047
R4769 wind_comp_0.sg13g2_and2_2$1_0.VSS.n423 wind_comp_0.sg13g2_and2_2$1_0.VSS.n1107 0.644047
R4770 wind_comp_0.sg13g2_and2_2$1_0.VSS.n422 wind_comp_0.sg13g2_and2_2$1_0.VSS.n1103 0.644047
R4771 wind_comp_0.sg13g2_and2_2$1_0.VSS.n403 wind_comp_0.sg13g2_and2_2$1_0.VSS.n1100 0.644047
R4772 wind_comp_0.sg13g2_and2_2$1_0.VSS.n421 wind_comp_0.sg13g2_and2_2$1_0.VSS.n1099 0.644047
R4773 wind_comp_0.sg13g2_and2_2$1_0.VSS.n404 wind_comp_0.sg13g2_and2_2$1_0.VSS.n1096 0.644047
R4774 wind_comp_0.sg13g2_and2_2$1_0.VSS.n420 wind_comp_0.sg13g2_and2_2$1_0.VSS.n1095 0.644047
R4775 wind_comp_0.sg13g2_and2_2$1_0.VSS.n405 wind_comp_0.sg13g2_and2_2$1_0.VSS.n1092 0.644047
R4776 wind_comp_0.sg13g2_and2_2$1_0.VSS.n419 wind_comp_0.sg13g2_and2_2$1_0.VSS.n1090 0.644047
R4777 wind_comp_0.sg13g2_and2_2$1_0.VSS.n406 wind_comp_0.sg13g2_and2_2$1_0.VSS.n1088 0.644047
R4778 wind_comp_0.sg13g2_and2_2$1_0.VSS.n418 wind_comp_0.sg13g2_and2_2$1_0.VSS.n1087 0.644047
R4779 wind_comp_0.sg13g2_and2_2$1_0.VSS.n1690 wind_comp_0.sg13g2_and2_2$1_0.VSS.n408 0.644047
R4780 wind_comp_0.sg13g2_and2_2$1_0.VSS.n545 wind_comp_0.sg13g2_and2_2$1_0.VSS.t291 0.644047
R4781 wind_comp_0.sg13g2_and2_2$1_0.VSS.t320 wind_comp_0.sg13g2_and2_2$1_0.VSS.t116 0.644047
R4782 wind_comp_0.sg13g2_and2_2$1_0.VSS.t293 wind_comp_0.sg13g2_and2_2$1_0.VSS.n1681 0.644047
R4783 wind_comp_0.sg13g2_and2_2$1_0.VSS.n2451 wind_comp_0.sg13g2_and2_2$1_0.VSS.n146 0.641126
R4784 wind_comp_0.sg13g2_and2_2$1_0.VSS.n145 wind_comp_0.sg13g2_and2_2$1_0.VSS.n181 0.641126
R4785 wind_comp_0.sg13g2_and2_2$1_0.VSS.n2053 wind_comp_0.sg13g2_and2_2$1_0.VSS.n65 0.641126
R4786 wind_comp_0.sg13g2_and2_2$1_0.VSS.n61 wind_comp_0.sg13g2_and2_2$1_0.VSS.n176 0.641126
R4787 wind_comp_0.sg13g2_and2_2$1_0.VSS.n125 wind_comp_0.sg13g2_and2_2$1_0.VSS.n124 0.564935
R4788 wind_comp_0.sg13g2_and2_2$1_0.VSS.n1542 wind_comp_0.sg13g2_and2_2$1_0.VSS.n1536 0.629071
R4789 wind_comp_0.sg13g2_and2_2$1_0.VSS.n1529 wind_comp_0.sg13g2_and2_2$1_0.VSS.n1528 0.6205
R4790 wind_comp_0.sg13g2_and2_2$1_0.VSS.n1554 wind_comp_0.sg13g2_and2_2$1_0.VSS.n1553 0.6205
R4791 wind_comp_0.sg13g2_and2_2$1_0.VSS.n898 wind_comp_0.sg13g2_and2_2$1_0.VSS.n78 0.589723
R4792 wind_comp_0.sg13g2_and2_2$1_0.VSS.n2548 wind_comp_0.sg13g2_and2_2$1_0.VSS.n83 0.564932
R4793 wind_comp_0.sg13g2_and2_2$1_0.VSS.n1573 wind_comp_0.sg13g2_and2_2$1_0.VSS.n74 0.564638
R4794 wind_comp_0.sg13g2_and2_2$1_0.VSS.n2547 wind_comp_0.sg13g2_and2_2$1_0.VSS.n83 0.56446
R4795 wind_comp_0.sg13g2_and2_2$1_0.VSS.n1551 wind_comp_0.sg13g2_and2_2$1_0.VSS.n1545 0.5605
R4796 wind_comp_0.sg13g2_and2_2$1_0.VSS.n1955 wind_comp_0.comparator_1.dynamic_pcell$1_0.VSS 0.559722
R4797 wind_comp_0.comparator_0.dynamic_pcell$1_0.VSS wind_comp_0.sg13g2_and2_2$1_0.VSS.n701 0.554167
R4798 wind_comp_0.sg13g2_and2_2$1_0.VSS.n79 wind_comp_0.sg13g2_and2_2$1_0.VSS.n77 0.54801
R4799 wind_comp_0.sg13g2_and2_2$1_0.VSS.n2566 wind_comp_0.sg13g2_and2_2$1_0.VSS.n203 0.537763
R4800 wind_comp_0.sg13g2_and2_2$1_0.VSS.n209 wind_comp_0.sg13g2_and2_2$1_0.VSS.t408 1.25752
R4801 wind_comp_0.sg13g2_and2_2$1_0.VSS.t409 wind_comp_0.sg13g2_and2_2$1_0.VSS.n1284 0.536789
R4802 wind_comp_0.sg13g2_and2_2$1_0.VSS.n372 wind_comp_0.sg13g2_and2_2$1_0.VSS.t410 0.536789
R4803 wind_comp_0.sg13g2_and2_2$1_0.VSS.t411 wind_comp_0.sg13g2_and2_2$1_0.VSS.n1606 0.536789
R4804 wind_comp_0.sg13g2_and2_2$1_0.VSS.n2520 wind_comp_0.comparator_1.dynamic_pcell_0.VSS 0.534
R4805 wind_comp_0.sg13g2_and2_2$1_0.VSS.n1566 wind_comp_0.comparator_0.dynamic_pcell_0.VSS 0.534
R4806 wind_comp_0.sg13g2_and2_2$1_0.VSS.n1486 wind_comp_0.comparator_0.sg13cmos5l_inv_16_1.VSS 0.530933
R4807 wind_comp_0.sg13g2_and2_2$1_0.VSS.n1675 wind_comp_0.sg13g2_and2_2$1_0.VSS.n1674 0.530933
R4808 wind_comp_0.comparator_1.dynamic_pcell_0.VSS wind_comp_0.sg13g2_and2_2$1_0.VSS.n99 0.524463
R4809 wind_comp_0.comparator_0.dynamic_pcell_0.VSS wind_comp_0.sg13g2_and2_2$1_0.VSS.n1565 0.523147
R4810 wind_comp_0.sg13g2_and2_2$1_0.VSS.n1675 wind_comp_0.sg13g2_and2_2$1_0.VSS.n83 3.35716
R4811 wind_comp_0.sg13g2_and2_2$1_0.VSS.n213 wind_comp_0.sg13g2_and2_2$1_0.VSS.n1275 0.687853
R4812 wind_comp_0.sg13g2_and2_2$1_0.VSS.n1209 wind_comp_0.sg13g2_and2_2$1_0.VSS.t283 0.520323
R4813 wind_comp_0.sg13g2_and2_2$1_0.VSS.n1598 wind_comp_0.sg13g2_and2_2$1_0.VSS.n82 0.516378
R4814 wind_comp_0.sg13g2_and2_2$1_0.VSS.n1572 wind_comp_0.sg13g2_and2_2$1_0.VSS.n74 0.501011
R4815 wind_comp_0.sg13g2_and2_2$1_0.VSS.n1542 wind_comp_0.sg13g2_and2_2$1_0.VSS.n1537 0.451724
R4816 wind_comp_0.sg13g2_and2_2$1_0.VSS.n1544 wind_comp_0.sg13g2_and2_2$1_0.VSS.n1543 0.451724
R4817 wind_comp_0.sg13g2_and2_2$1_0.VSS.n1565 wind_comp_0.sg13g2_and2_2$1_0.VSS.n1312 0.45035
R4818 wind_comp_0.sg13g2_and2_2$1_0.VSS.n99 wind_comp_0.sg13g2_and2_2$1_0.VSS.n1611 0.449026
R4819 wind_comp_0.sg13g2_and2_2$1_0.VSS.n1460 wind_comp_0.sg13g2_and2_2$1_0.VSS.n459 0.429531
R4820 wind_comp_0.sg13g2_and2_2$1_0.VSS.n1474 wind_comp_0.sg13g2_and2_2$1_0.VSS.n473 0.429531
R4821 wind_comp_0.sg13g2_and2_2$1_0.VSS.n1434 wind_comp_0.sg13g2_and2_2$1_0.VSS.t334 0.429531
R4822 wind_comp_0.sg13g2_and2_2$1_0.VSS.n1427 wind_comp_0.sg13g2_and2_2$1_0.VSS.n491 0.429531
R4823 wind_comp_0.sg13g2_and2_2$1_0.VSS.n1503 wind_comp_0.sg13g2_and2_2$1_0.VSS.n1502 0.429531
R4824 wind_comp_0.sg13g2_and2_2$1_0.VSS.n1509 wind_comp_0.sg13g2_and2_2$1_0.VSS.t356 0.429531
R4825 wind_comp_0.sg13g2_and2_2$1_0.VSS.n1405 wind_comp_0.sg13g2_and2_2$1_0.VSS.n1404 0.429531
R4826 wind_comp_0.sg13g2_and2_2$1_0.VSS.n1401 wind_comp_0.sg13g2_and2_2$1_0.VSS.t399 0.429531
R4827 wind_comp_0.sg13g2_and2_2$1_0.VSS.n1278 wind_comp_0.sg13g2_and2_2$1_0.VSS.n513 0.429531
R4828 wind_comp_0.sg13g2_and2_2$1_0.VSS.n1280 wind_comp_0.sg13g2_and2_2$1_0.VSS.n514 0.429531
R4829 wind_comp_0.sg13g2_and2_2$1_0.VSS.n1282 wind_comp_0.sg13g2_and2_2$1_0.VSS.n515 0.429531
R4830 wind_comp_0.sg13g2_and2_2$1_0.VSS.n1284 wind_comp_0.sg13g2_and2_2$1_0.VSS.n516 0.429531
R4831 wind_comp_0.sg13g2_and2_2$1_0.VSS.n1287 wind_comp_0.sg13g2_and2_2$1_0.VSS.n517 0.429531
R4832 wind_comp_0.sg13g2_and2_2$1_0.VSS.n1289 wind_comp_0.sg13g2_and2_2$1_0.VSS.n518 0.429531
R4833 wind_comp_0.sg13g2_and2_2$1_0.VSS.n1292 wind_comp_0.sg13g2_and2_2$1_0.VSS.n519 0.429531
R4834 wind_comp_0.sg13g2_and2_2$1_0.VSS.n1295 wind_comp_0.sg13g2_and2_2$1_0.VSS.n520 0.429531
R4835 wind_comp_0.sg13g2_and2_2$1_0.VSS.n1297 wind_comp_0.sg13g2_and2_2$1_0.VSS.n521 0.429531
R4836 wind_comp_0.sg13g2_and2_2$1_0.VSS.n1300 wind_comp_0.sg13g2_and2_2$1_0.VSS.n522 0.429531
R4837 wind_comp_0.sg13g2_and2_2$1_0.VSS.n1301 wind_comp_0.sg13g2_and2_2$1_0.VSS.n523 0.429531
R4838 wind_comp_0.sg13g2_and2_2$1_0.VSS.n1303 wind_comp_0.sg13g2_and2_2$1_0.VSS.n524 0.429531
R4839 wind_comp_0.sg13g2_and2_2$1_0.VSS.n1928 wind_comp_0.sg13g2_and2_2$1_0.VSS.n1900 0.429531
R4840 wind_comp_0.sg13g2_and2_2$1_0.VSS.t87 wind_comp_0.sg13g2_and2_2$1_0.VSS.n1899 0.429531
R4841 wind_comp_0.sg13g2_and2_2$1_0.VSS.n2517 wind_comp_0.sg13g2_and2_2$1_0.VSS.n363 0.429531
R4842 wind_comp_0.sg13g2_and2_2$1_0.VSS.n605 wind_comp_0.sg13g2_and2_2$1_0.VSS.n364 0.429531
R4843 wind_comp_0.sg13g2_and2_2$1_0.VSS.n604 wind_comp_0.sg13g2_and2_2$1_0.VSS.n365 0.429531
R4844 wind_comp_0.sg13g2_and2_2$1_0.VSS.n603 wind_comp_0.sg13g2_and2_2$1_0.VSS.n366 0.429531
R4845 wind_comp_0.sg13g2_and2_2$1_0.VSS.n602 wind_comp_0.sg13g2_and2_2$1_0.VSS.n367 0.429531
R4846 wind_comp_0.sg13g2_and2_2$1_0.VSS.n601 wind_comp_0.sg13g2_and2_2$1_0.VSS.n368 0.429531
R4847 wind_comp_0.sg13g2_and2_2$1_0.VSS.n600 wind_comp_0.sg13g2_and2_2$1_0.VSS.n369 0.429531
R4848 wind_comp_0.sg13g2_and2_2$1_0.VSS.n599 wind_comp_0.sg13g2_and2_2$1_0.VSS.n370 0.429531
R4849 wind_comp_0.sg13g2_and2_2$1_0.VSS.n598 wind_comp_0.sg13g2_and2_2$1_0.VSS.n371 0.429531
R4850 wind_comp_0.sg13g2_and2_2$1_0.VSS.n597 wind_comp_0.sg13g2_and2_2$1_0.VSS.n372 0.429531
R4851 wind_comp_0.sg13g2_and2_2$1_0.VSS.n596 wind_comp_0.sg13g2_and2_2$1_0.VSS.n373 0.429531
R4852 wind_comp_0.sg13g2_and2_2$1_0.VSS.n595 wind_comp_0.sg13g2_and2_2$1_0.VSS.n374 0.429531
R4853 wind_comp_0.sg13g2_and2_2$1_0.VSS.n594 wind_comp_0.sg13g2_and2_2$1_0.VSS.n375 0.429531
R4854 wind_comp_0.sg13g2_and2_2$1_0.VSS.n1651 wind_comp_0.sg13g2_and2_2$1_0.VSS.n1172 0.429531
R4855 wind_comp_0.sg13g2_and2_2$1_0.VSS.n376 wind_comp_0.sg13g2_and2_2$1_0.VSS.n1171 0.429531
R4856 wind_comp_0.sg13g2_and2_2$1_0.VSS.n1654 wind_comp_0.sg13g2_and2_2$1_0.VSS.t401 0.429531
R4857 wind_comp_0.sg13g2_and2_2$1_0.VSS.n377 wind_comp_0.sg13g2_and2_2$1_0.VSS.n1168 0.429531
R4858 wind_comp_0.sg13g2_and2_2$1_0.VSS.n378 wind_comp_0.sg13g2_and2_2$1_0.VSS.n1167 0.429531
R4859 wind_comp_0.sg13g2_and2_2$1_0.VSS.n379 wind_comp_0.sg13g2_and2_2$1_0.VSS.n1164 0.429531
R4860 wind_comp_0.sg13g2_and2_2$1_0.VSS.n380 wind_comp_0.sg13g2_and2_2$1_0.VSS.n1163 0.429531
R4861 wind_comp_0.sg13g2_and2_2$1_0.VSS.n381 wind_comp_0.sg13g2_and2_2$1_0.VSS.n1160 0.429531
R4862 wind_comp_0.sg13g2_and2_2$1_0.VSS.n382 wind_comp_0.sg13g2_and2_2$1_0.VSS.n1159 0.429531
R4863 wind_comp_0.sg13g2_and2_2$1_0.VSS.n1655 wind_comp_0.sg13g2_and2_2$1_0.VSS.n382 0.429531
R4864 wind_comp_0.sg13g2_and2_2$1_0.VSS.n383 wind_comp_0.sg13g2_and2_2$1_0.VSS.n1156 0.429531
R4865 wind_comp_0.sg13g2_and2_2$1_0.VSS.n384 wind_comp_0.sg13g2_and2_2$1_0.VSS.n1155 0.429531
R4866 wind_comp_0.sg13g2_and2_2$1_0.VSS.n1656 wind_comp_0.sg13g2_and2_2$1_0.VSS.n1152 0.429531
R4867 wind_comp_0.sg13g2_and2_2$1_0.VSS.n385 wind_comp_0.sg13g2_and2_2$1_0.VSS.n1152 0.429531
R4868 wind_comp_0.sg13g2_and2_2$1_0.VSS.n386 wind_comp_0.sg13g2_and2_2$1_0.VSS.n1151 0.429531
R4869 wind_comp_0.sg13g2_and2_2$1_0.VSS.n582 wind_comp_0.sg13g2_and2_2$1_0.VSS.n1642 0.429531
R4870 wind_comp_0.sg13g2_and2_2$1_0.VSS.n1642 wind_comp_0.sg13g2_and2_2$1_0.VSS.t369 0.429531
R4871 wind_comp_0.sg13g2_and2_2$1_0.VSS.n387 wind_comp_0.sg13g2_and2_2$1_0.VSS.n1148 0.429531
R4872 wind_comp_0.sg13g2_and2_2$1_0.VSS.n388 wind_comp_0.sg13g2_and2_2$1_0.VSS.n1147 0.429531
R4873 wind_comp_0.sg13g2_and2_2$1_0.VSS.n389 wind_comp_0.sg13g2_and2_2$1_0.VSS.n1144 0.429531
R4874 wind_comp_0.sg13g2_and2_2$1_0.VSS.n390 wind_comp_0.sg13g2_and2_2$1_0.VSS.n1143 0.429531
R4875 wind_comp_0.sg13g2_and2_2$1_0.VSS.n391 wind_comp_0.sg13g2_and2_2$1_0.VSS.n1140 0.429531
R4876 wind_comp_0.sg13g2_and2_2$1_0.VSS.n392 wind_comp_0.sg13g2_and2_2$1_0.VSS.n1138 0.429531
R4877 wind_comp_0.sg13g2_and2_2$1_0.VSS.n1880 wind_comp_0.sg13g2_and2_2$1_0.VSS.n1136 0.429531
R4878 wind_comp_0.sg13g2_and2_2$1_0.VSS.n572 wind_comp_0.sg13g2_and2_2$1_0.VSS.n1660 0.429531
R4879 wind_comp_0.sg13g2_and2_2$1_0.VSS.n1663 wind_comp_0.sg13g2_and2_2$1_0.VSS.n1124 0.429531
R4880 wind_comp_0.sg13g2_and2_2$1_0.VSS.n567 wind_comp_0.sg13g2_and2_2$1_0.VSS.t384 0.429531
R4881 wind_comp_0.sg13g2_and2_2$1_0.VSS.t112 wind_comp_0.sg13g2_and2_2$1_0.VSS.n1115 0.429531
R4882 wind_comp_0.sg13g2_and2_2$1_0.VSS.n564 wind_comp_0.sg13g2_and2_2$1_0.VSS.t387 0.429531
R4883 wind_comp_0.sg13g2_and2_2$1_0.VSS.n561 wind_comp_0.sg13g2_and2_2$1_0.VSS.t390 0.429531
R4884 wind_comp_0.sg13g2_and2_2$1_0.VSS.n561 wind_comp_0.sg13g2_and2_2$1_0.VSS.n1677 0.429531
R4885 wind_comp_0.sg13g2_and2_2$1_0.VSS.n1630 wind_comp_0.sg13g2_and2_2$1_0.VSS.n1104 0.429531
R4886 wind_comp_0.sg13g2_and2_2$1_0.VSS.n551 wind_comp_0.sg13g2_and2_2$1_0.VSS.n1627 0.429531
R4887 wind_comp_0.sg13g2_and2_2$1_0.VSS.n1625 wind_comp_0.sg13g2_and2_2$1_0.VSS.n1076 0.429531
R4888 wind_comp_0.sg13g2_and2_2$1_0.VSS.n537 wind_comp_0.sg13g2_and2_2$1_0.VSS.n1616 0.429531
R4889 wind_comp_0.sg13g2_and2_2$1_0.VSS.t198 wind_comp_0.sg13g2_and2_2$1_0.VSS.n1063 0.429531
R4890 wind_comp_0.sg13g2_and2_2$1_0.VSS.n1569 wind_comp_0.comparator_0.dynamic_pcell_0.VSS 0.42792
R4891 wind_comp_0.sg13g2_and2_2$1_0.VSS.n1543 wind_comp_0.sg13g2_and2_2$1_0.VSS.n1534 0.418051
R4892 wind_comp_0.sg13g2_and2_2$1_0.VSS.n1570 wind_comp_0.sg13g2_and2_2$1_0.VSS.n1569 0.41792
R4893 wind_comp_0.sg13g2_and2_2$1_0.VSS.n2123 wind_comp_0.sg13g2_and2_2$1_0.VSS.n2122 0.381877
R4894 wind_comp_0.sg13g2_and2_2$1_0.VSS.n2572 wind_comp_0.sg13g2_and2_2$1_0.VSS.n2571 0.381877
R4895 wind_comp_0.sg13g2_and2_2$1_0.VSS.n2286 wind_comp_0.sg13g2_and2_2$1_0.VSS.n2285 0.381877
R4896 wind_comp_0.sg13g2_and2_2$1_0.VSS.n2280 wind_comp_0.sg13g2_and2_2$1_0.VSS.n2279 0.381877
R4897 wind_comp_0.sg13g2_and2_2$1_0.VSS.n1375 wind_comp_0.sg13g2_and2_2$1_0.VSS.n7 0.375385
R4898 wind_comp_0.sg13g2_and2_2$1_0.VSS.n1556 wind_comp_0.sg13g2_and2_2$1_0.VSS.n1555 0.3725
R4899 wind_comp_0.sg13g2_and2_2$1_0.VSS.n453 wind_comp_0.sg13g2_and2_2$1_0.VSS.n7 0.371635
R4900 wind_comp_0.sg13g2_and2_2$1_0.VSS.n2563 wind_comp_0.sg13g2_and2_2$1_0.VSS.n353 0.652605
R4901 wind_comp_0.sg13g2_and2_2$1_0.VSS.n1675 wind_comp_0.sg13g2_and2_2$1_0.VSS.n1612 0.344342
R4902 wind_comp_0.sg13g2_and2_2$1_0.VSS.n1486 wind_comp_0.sg13g2_and2_2$1_0.VSS.n608 0.344252
R4903 wind_comp_0.sg13g2_and2_2$1_0.VSS.n107 wind_comp_0.sg13g2_and2_2$1_0.VSS.n1929 0.338669
R4904 wind_comp_0.sg13g2_and2_2$1_0.VSS.n1932 wind_comp_0.sg13g2_and2_2$1_0.VSS.n112 0.338669
R4905 wind_comp_0.sg13g2_and2_2$1_0.VSS.n1954 wind_comp_0.sg13g2_and2_2$1_0.VSS.n1953 0.333833
R4906 wind_comp_0.sg13g2_and2_2$1_0.VSS.n1952 wind_comp_0.sg13g2_and2_2$1_0.VSS.n1930 0.333833
R4907 wind_comp_0.sg13g2_and2_2$1_0.VSS.n1935 wind_comp_0.sg13g2_and2_2$1_0.VSS.n1931 0.333833
R4908 wind_comp_0.sg13g2_and2_2$1_0.VSS.n1937 wind_comp_0.sg13g2_and2_2$1_0.VSS.n1936 0.333833
R4909 wind_comp_0.sg13g2_and2_2$1_0.VSS.n1939 wind_comp_0.sg13g2_and2_2$1_0.VSS.n1938 0.333833
R4910 wind_comp_0.sg13g2_and2_2$1_0.VSS.n1941 wind_comp_0.sg13g2_and2_2$1_0.VSS.n1940 0.333833
R4911 wind_comp_0.sg13g2_and2_2$1_0.VSS.n1943 wind_comp_0.sg13g2_and2_2$1_0.VSS.n1942 0.333833
R4912 wind_comp_0.sg13g2_and2_2$1_0.VSS.n1945 wind_comp_0.sg13g2_and2_2$1_0.VSS.n1944 0.333833
R4913 wind_comp_0.sg13g2_and2_2$1_0.VSS.n1949 wind_comp_0.sg13g2_and2_2$1_0.VSS.n1948 0.333833
R4914 wind_comp_0.sg13g2_and2_2$1_0.VSS.n1947 wind_comp_0.sg13g2_and2_2$1_0.VSS.n1946 0.333833
R4915 wind_comp_0.sg13g2_and2_2$1_0.VSS.n1952 wind_comp_0.sg13g2_and2_2$1_0.VSS.n1951 0.333833
R4916 wind_comp_0.sg13g2_and2_2$1_0.VSS.n1951 wind_comp_0.sg13g2_and2_2$1_0.VSS.n1942 0.333833
R4917 wind_comp_0.sg13g2_and2_2$1_0.VSS.n1532 wind_comp_0.sg13g2_and2_2$1_0.VSS.n1531 0.313833
R4918 wind_comp_0.sg13g2_and2_2$1_0.VSS.n1532 wind_comp_0.sg13g2_and2_2$1_0.VSS.n1529 0.313833
R4919 wind_comp_0.sg13g2_and2_2$1_0.VSS.n1553 wind_comp_0.sg13g2_and2_2$1_0.VSS.n1552 0.313833
R4920 wind_comp_0.sg13g2_and2_2$1_0.VSS.n1552 wind_comp_0.sg13g2_and2_2$1_0.VSS.n1550 0.313833
R4921 wind_comp_0.comparator_0.dynamic_pcell_0.VSS wind_comp_0.sg13g2_and2_2$1_0.VSS.n608 0.313345
R4922 wind_comp_0.comparator_1.dynamic_pcell_0.VSS wind_comp_0.sg13g2_and2_2$1_0.VSS.n1612 0.313209
R4923 wind_comp_0.sg13g2_and2_2$1_0.VSS.n938 wind_comp_0.sg13g2_and2_2$1_0.VSS.t30 0.312394
R4924 wind_comp_0.sg13g2_and2_2$1_0.VSS.n903 wind_comp_0.sg13g2_and2_2$1_0.VSS.n902 0.293833
R4925 wind_comp_0.sg13g2_and2_2$1_0.VSS.n782 wind_comp_0.sg13g2_and2_2$1_0.VSS.n781 0.293833
R4926 wind_comp_0.sg13g2_and2_2$1_0.VSS.n70 wind_comp_0.sg13g2_and2_2$1_0.VSS.n203 0.290478
R4927 wind_comp_0.sg13g2_and2_2$1_0.VSS.n1786 wind_comp_0.sg13g2_and2_2$1_0.VSS.n1718 0.278594
R4928 wind_comp_0.sg13g2_and2_2$1_0.VSS.n83 wind_comp_0.sg13g2_and2_2$1_0.VSS.n82 0.276831
R4929 wind_comp_0.comparator_0.dynamic_pcell$1_0.VSS wind_comp_0.sg13g2_and2_2$1_0.VSS.n697 0.250971
R4930 wind_comp_0.sg13g2_and2_2$1_0.VSS.n899 wind_comp_0.sg13g2_and2_2$1_0.VSS.n898 0.238833
R4931 wind_comp_0.sg13g2_and2_2$1_0.VSS.n1997 wind_comp_0.sg13g2_and2_2$1_0.VSS.n1996 0.238833
R4932 wind_comp_0.sg13g2_and2_2$1_0.VSS.n40 wind_comp_0.sg13g2_and2_2$1_0.VSS.n39 0.238833
R4933 wind_comp_0.sg13g2_and2_2$1_0.VSS.n34 wind_comp_0.sg13g2_and2_2$1_0.VSS.n33 0.238833
R4934 wind_comp_0.sg13g2_and2_2$1_0.VSS.n1987 wind_comp_0.sg13g2_and2_2$1_0.VSS.n168 0.238833
R4935 wind_comp_0.sg13g2_and2_2$1_0.VSS.n2025 wind_comp_0.sg13g2_and2_2$1_0.VSS.n216 0.238833
R4936 wind_comp_0.sg13g2_and2_2$1_0.VSS.n5 wind_comp_0.sg13g2_and2_2$1_0.VSS.n2027 0.239371
R4937 wind_comp_0.sg13g2_and2_2$1_0.VSS.n4 wind_comp_0.sg13g2_and2_2$1_0.VSS.n3 0.238833
R4938 wind_comp_0.sg13g2_and2_2$1_0.VSS.n787 wind_comp_0.sg13g2_and2_2$1_0.VSS.n4 0.238833
R4939 wind_comp_0.sg13g2_and2_2$1_0.VSS.n1350 wind_comp_0.sg13g2_and2_2$1_0.VSS.n1349 0.238833
R4940 wind_comp_0.sg13g2_and2_2$1_0.VSS.n1346 wind_comp_0.sg13g2_and2_2$1_0.VSS.n1345 0.238833
R4941 wind_comp_0.sg13g2_and2_2$1_0.VSS.n237 wind_comp_0.sg13g2_and2_2$1_0.VSS.n236 0.238833
R4942 wind_comp_0.sg13g2_and2_2$1_0.VSS.n1332 wind_comp_0.sg13g2_and2_2$1_0.VSS.n1330 0.238833
R4943 wind_comp_0.sg13g2_and2_2$1_0.VSS.n1327 wind_comp_0.sg13g2_and2_2$1_0.VSS.n1326 0.238833
R4944 wind_comp_0.sg13g2_and2_2$1_0.VSS.n776 wind_comp_0.sg13g2_and2_2$1_0.VSS.n20 0.238833
R4945 wind_comp_0.sg13g2_and2_2$1_0.VSS.n976 wind_comp_0.sg13g2_and2_2$1_0.VSS.n135 0.238833
R4946 wind_comp_0.sg13g2_and2_2$1_0.VSS.n31 wind_comp_0.sg13g2_and2_2$1_0.VSS.n30 0.238833
R4947 wind_comp_0.sg13g2_and2_2$1_0.VSS.n24 wind_comp_0.sg13g2_and2_2$1_0.VSS.n23 0.238833
R4948 wind_comp_0.sg13g2_and2_2$1_0.VSS.n1053 wind_comp_0.sg13g2_and2_2$1_0.VSS.n1052 0.238833
R4949 wind_comp_0.sg13g2_and2_2$1_0.VSS.n993 wind_comp_0.sg13g2_and2_2$1_0.VSS.n163 0.238833
R4950 wind_comp_0.sg13g2_and2_2$1_0.VSS.n996 wind_comp_0.sg13g2_and2_2$1_0.VSS.n995 0.238833
R4951 wind_comp_0.sg13g2_and2_2$1_0.VSS.n1026 wind_comp_0.sg13g2_and2_2$1_0.VSS.n1025 0.238833
R4952 wind_comp_0.sg13g2_and2_2$1_0.VSS.n1020 wind_comp_0.sg13g2_and2_2$1_0.VSS.n1019 0.238833
R4953 wind_comp_0.sg13g2_and2_2$1_0.VSS.n2234 wind_comp_0.sg13g2_and2_2$1_0.VSS.n2233 0.238833
R4954 wind_comp_0.sg13g2_and2_2$1_0.VSS.n142 wind_comp_0.sg13g2_and2_2$1_0.VSS.n141 0.238833
R4955 wind_comp_0.sg13g2_and2_2$1_0.VSS.n889 wind_comp_0.sg13g2_and2_2$1_0.VSS.n888 0.238833
R4956 wind_comp_0.sg13g2_and2_2$1_0.VSS.n892 wind_comp_0.sg13g2_and2_2$1_0.VSS.n891 0.238833
R4957 wind_comp_0.sg13g2_and2_2$1_0.VSS.n2314 wind_comp_0.sg13g2_and2_2$1_0.VSS.n2313 0.238833
R4958 wind_comp_0.sg13g2_and2_2$1_0.VSS.n16 wind_comp_0.sg13g2_and2_2$1_0.VSS.n2317 0.238833
R4959 wind_comp_0.sg13g2_and2_2$1_0.VSS.n2336 wind_comp_0.sg13g2_and2_2$1_0.VSS.n2334 0.238833
R4960 wind_comp_0.sg13g2_and2_2$1_0.VSS.n2329 wind_comp_0.sg13g2_and2_2$1_0.VSS.n222 0.238833
R4961 wind_comp_0.sg13g2_and2_2$1_0.VSS.n2292 wind_comp_0.sg13g2_and2_2$1_0.VSS.n234 0.238833
R4962 wind_comp_0.sg13g2_and2_2$1_0.VSS.n2299 wind_comp_0.sg13g2_and2_2$1_0.VSS.n2298 0.238833
R4963 wind_comp_0.sg13g2_and2_2$1_0.VSS.n17 wind_comp_0.sg13g2_and2_2$1_0.VSS.n15 0.238833
R4964 wind_comp_0.sg13g2_and2_2$1_0.VSS.n2320 wind_comp_0.sg13g2_and2_2$1_0.VSS.n17 0.238833
R4965 wind_comp_0.sg13g2_and2_2$1_0.VSS.n2302 wind_comp_0.sg13g2_and2_2$1_0.VSS.n17 0.238833
R4966 wind_comp_0.sg13g2_and2_2$1_0.VSS.n16 wind_comp_0.sg13g2_and2_2$1_0.VSS.n2308 0.238833
R4967 wind_comp_0.sg13g2_and2_2$1_0.VSS.n294 wind_comp_0.sg13g2_and2_2$1_0.VSS.n292 0.238833
R4968 wind_comp_0.sg13g2_and2_2$1_0.VSS.n294 wind_comp_0.sg13g2_and2_2$1_0.VSS.n293 0.238833
R4969 wind_comp_0.sg13g2_and2_2$1_0.VSS.n148 wind_comp_0.sg13g2_and2_2$1_0.VSS.n147 0.238833
R4970 wind_comp_0.sg13g2_and2_2$1_0.VSS.n1911 wind_comp_0.sg13g2_and2_2$1_0.VSS.n148 0.238833
R4971 wind_comp_0.sg13g2_and2_2$1_0.VSS.n296 wind_comp_0.sg13g2_and2_2$1_0.VSS.n298 0.238833
R4972 wind_comp_0.sg13g2_and2_2$1_0.VSS.n1921 wind_comp_0.sg13g2_and2_2$1_0.VSS.n296 0.238833
R4973 wind_comp_0.sg13g2_and2_2$1_0.VSS.n155 wind_comp_0.sg13g2_and2_2$1_0.VSS.n153 0.238833
R4974 wind_comp_0.sg13g2_and2_2$1_0.VSS.n155 wind_comp_0.sg13g2_and2_2$1_0.VSS.n154 0.238833
R4975 wind_comp_0.sg13g2_and2_2$1_0.VSS.n117 wind_comp_0.sg13g2_and2_2$1_0.VSS.n115 0.238833
R4976 wind_comp_0.sg13g2_and2_2$1_0.VSS.n117 wind_comp_0.sg13g2_and2_2$1_0.VSS.n116 0.238833
R4977 wind_comp_0.sg13g2_and2_2$1_0.VSS.n117 wind_comp_0.sg13g2_and2_2$1_0.VSS.n114 0.238833
R4978 wind_comp_0.sg13g2_and2_2$1_0.VSS.n117 wind_comp_0.sg13g2_and2_2$1_0.VSS.n113 0.238833
R4979 wind_comp_0.sg13g2_and2_2$1_0.VSS.n198 wind_comp_0.sg13g2_and2_2$1_0.VSS.n195 0.238833
R4980 wind_comp_0.sg13g2_and2_2$1_0.VSS.n2217 wind_comp_0.sg13g2_and2_2$1_0.VSS.n198 0.238833
R4981 wind_comp_0.sg13g2_and2_2$1_0.VSS.n198 wind_comp_0.sg13g2_and2_2$1_0.VSS.n197 0.238833
R4982 wind_comp_0.sg13g2_and2_2$1_0.VSS.n198 wind_comp_0.sg13g2_and2_2$1_0.VSS.n196 0.238833
R4983 wind_comp_0.sg13g2_and2_2$1_0.VSS.n2101 wind_comp_0.sg13g2_and2_2$1_0.VSS.n36 0.238833
R4984 wind_comp_0.sg13g2_and2_2$1_0.VSS.n2106 wind_comp_0.sg13g2_and2_2$1_0.VSS.n2104 0.238833
R4985 wind_comp_0.sg13g2_and2_2$1_0.VSS.n38 wind_comp_0.sg13g2_and2_2$1_0.VSS.n37 0.238833
R4986 wind_comp_0.sg13g2_and2_2$1_0.VSS.n2118 wind_comp_0.sg13g2_and2_2$1_0.VSS.n2117 0.238833
R4987 wind_comp_0.sg13g2_and2_2$1_0.VSS.n689 wind_comp_0.sg13g2_and2_2$1_0.VSS.n688 0.238833
R4988 wind_comp_0.sg13g2_and2_2$1_0.VSS.n685 wind_comp_0.sg13g2_and2_2$1_0.VSS.n139 0.238833
R4989 wind_comp_0.sg13g2_and2_2$1_0.VSS.n225 wind_comp_0.sg13g2_and2_2$1_0.VSS.n224 0.238833
R4990 wind_comp_0.sg13g2_and2_2$1_0.VSS.n740 wind_comp_0.sg13g2_and2_2$1_0.VSS.n739 0.238833
R4991 wind_comp_0.sg13g2_and2_2$1_0.VSS.n2113 wind_comp_0.sg13g2_and2_2$1_0.VSS.n2112 0.238833
R4992 wind_comp_0.sg13g2_and2_2$1_0.VSS.n2107 wind_comp_0.sg13g2_and2_2$1_0.VSS.n2106 0.238833
R4993 wind_comp_0.sg13g2_and2_2$1_0.VSS.n453 wind_comp_0.sg13g2_and2_2$1_0.VSS.n697 0.232625
R4994 wind_comp_0.sg13g2_and2_2$1_0.VSS.n1579 wind_comp_0.sg13g2_and2_2$1_0.VSS.n1306 0.223925
R4995 wind_comp_0.sg13g2_and2_2$1_0.VSS.n1589 wind_comp_0.sg13g2_and2_2$1_0.VSS.n1588 0.223083
R4996 wind_comp_0.sg13g2_and2_2$1_0.VSS.n1455 wind_comp_0.sg13g2_and2_2$1_0.VSS.t154 0.215016
R4997 wind_comp_0.sg13g2_and2_2$1_0.VSS.n1459 wind_comp_0.sg13g2_and2_2$1_0.VSS.n1458 0.215016
R4998 wind_comp_0.sg13g2_and2_2$1_0.VSS.n1452 wind_comp_0.sg13g2_and2_2$1_0.VSS.t158 0.215016
R4999 wind_comp_0.sg13g2_and2_2$1_0.VSS.n1461 wind_comp_0.sg13g2_and2_2$1_0.VSS.n1361 0.215016
R5000 wind_comp_0.sg13g2_and2_2$1_0.VSS.n1445 wind_comp_0.sg13g2_and2_2$1_0.VSS.n1444 0.215016
R5001 wind_comp_0.sg13g2_and2_2$1_0.VSS.n1483 wind_comp_0.sg13g2_and2_2$1_0.VSS.t272 0.215016
R5002 wind_comp_0.sg13g2_and2_2$1_0.VSS.n1437 wind_comp_0.sg13g2_and2_2$1_0.VSS.n1436 0.215016
R5003 wind_comp_0.sg13g2_and2_2$1_0.VSS.n1485 wind_comp_0.sg13g2_and2_2$1_0.VSS.n1388 0.215016
R5004 wind_comp_0.sg13g2_and2_2$1_0.VSS.n1493 wind_comp_0.sg13g2_and2_2$1_0.VSS.n1492 0.215016
R5005 wind_comp_0.sg13g2_and2_2$1_0.VSS.n1432 wind_comp_0.sg13g2_and2_2$1_0.VSS.n1398 0.215016
R5006 wind_comp_0.sg13g2_and2_2$1_0.VSS.n1399 wind_comp_0.sg13g2_and2_2$1_0.VSS.n487 0.215016
R5007 wind_comp_0.sg13g2_and2_2$1_0.VSS.n1226 wind_comp_0.sg13g2_and2_2$1_0.VSS.n488 0.215016
R5008 wind_comp_0.sg13g2_and2_2$1_0.VSS.n1430 wind_comp_0.sg13g2_and2_2$1_0.VSS.n489 0.215016
R5009 wind_comp_0.sg13g2_and2_2$1_0.VSS.n1497 wind_comp_0.sg13g2_and2_2$1_0.VSS.n490 0.215016
R5010 wind_comp_0.sg13g2_and2_2$1_0.VSS.n1199 wind_comp_0.sg13g2_and2_2$1_0.VSS.n491 0.215016
R5011 wind_comp_0.sg13g2_and2_2$1_0.VSS.n1426 wind_comp_0.sg13g2_and2_2$1_0.VSS.n492 0.215016
R5012 wind_comp_0.sg13g2_and2_2$1_0.VSS.n1499 wind_comp_0.sg13g2_and2_2$1_0.VSS.n493 0.215016
R5013 wind_comp_0.sg13g2_and2_2$1_0.VSS.n1422 wind_comp_0.sg13g2_and2_2$1_0.VSS.n494 0.215016
R5014 wind_comp_0.sg13g2_and2_2$1_0.VSS.n1259 wind_comp_0.sg13g2_and2_2$1_0.VSS.n495 0.215016
R5015 wind_comp_0.sg13g2_and2_2$1_0.VSS.n1501 wind_comp_0.sg13g2_and2_2$1_0.VSS.n496 0.215016
R5016 wind_comp_0.sg13g2_and2_2$1_0.VSS.n1417 wind_comp_0.sg13g2_and2_2$1_0.VSS.n497 0.215016
R5017 wind_comp_0.sg13g2_and2_2$1_0.VSS.n1261 wind_comp_0.sg13g2_and2_2$1_0.VSS.n498 0.215016
R5018 wind_comp_0.sg13g2_and2_2$1_0.VSS.n1504 wind_comp_0.sg13g2_and2_2$1_0.VSS.n499 0.215016
R5019 wind_comp_0.sg13g2_and2_2$1_0.VSS.n1412 wind_comp_0.sg13g2_and2_2$1_0.VSS.n500 0.215016
R5020 wind_comp_0.sg13g2_and2_2$1_0.VSS.n1509 wind_comp_0.sg13g2_and2_2$1_0.VSS.n1507 0.215016
R5021 wind_comp_0.sg13g2_and2_2$1_0.VSS.n1507 wind_comp_0.sg13g2_and2_2$1_0.VSS.n501 0.215016
R5022 wind_comp_0.sg13g2_and2_2$1_0.VSS.n1263 wind_comp_0.sg13g2_and2_2$1_0.VSS.n502 0.215016
R5023 wind_comp_0.sg13g2_and2_2$1_0.VSS.n1408 wind_comp_0.sg13g2_and2_2$1_0.VSS.t357 0.215016
R5024 wind_comp_0.sg13g2_and2_2$1_0.VSS.n1406 wind_comp_0.sg13g2_and2_2$1_0.VSS.n503 0.215016
R5025 wind_comp_0.sg13g2_and2_2$1_0.VSS.n1510 wind_comp_0.sg13g2_and2_2$1_0.VSS.n504 0.215016
R5026 wind_comp_0.sg13g2_and2_2$1_0.VSS.n1265 wind_comp_0.sg13g2_and2_2$1_0.VSS.n505 0.215016
R5027 wind_comp_0.sg13g2_and2_2$1_0.VSS.n1403 wind_comp_0.sg13g2_and2_2$1_0.VSS.n506 0.215016
R5028 wind_comp_0.sg13g2_and2_2$1_0.VSS.n1514 wind_comp_0.sg13g2_and2_2$1_0.VSS.n507 0.215016
R5029 wind_comp_0.sg13g2_and2_2$1_0.VSS.n1267 wind_comp_0.sg13g2_and2_2$1_0.VSS.n508 0.215016
R5030 wind_comp_0.sg13g2_and2_2$1_0.VSS.n1269 wind_comp_0.sg13g2_and2_2$1_0.VSS.n509 0.215016
R5031 wind_comp_0.sg13g2_and2_2$1_0.VSS.n1517 wind_comp_0.sg13g2_and2_2$1_0.VSS.n206 0.32874
R5032 wind_comp_0.sg13g2_and2_2$1_0.VSS.n1516 wind_comp_0.sg13g2_and2_2$1_0.VSS.n510 0.215016
R5033 wind_comp_0.sg13g2_and2_2$1_0.VSS.n1400 wind_comp_0.sg13g2_and2_2$1_0.VSS.n511 0.215016
R5034 wind_comp_0.sg13g2_and2_2$1_0.VSS.n1274 wind_comp_0.sg13g2_and2_2$1_0.VSS.n512 0.215016
R5035 wind_comp_0.sg13g2_and2_2$1_0.VSS.n1519 wind_comp_0.sg13g2_and2_2$1_0.VSS.n513 0.215016
R5036 wind_comp_0.sg13g2_and2_2$1_0.VSS.n1277 wind_comp_0.sg13g2_and2_2$1_0.VSS.n514 0.215016
R5037 wind_comp_0.sg13g2_and2_2$1_0.VSS.n1279 wind_comp_0.sg13g2_and2_2$1_0.VSS.n515 0.215016
R5038 wind_comp_0.sg13g2_and2_2$1_0.VSS.n1281 wind_comp_0.sg13g2_and2_2$1_0.VSS.n516 0.215016
R5039 wind_comp_0.sg13g2_and2_2$1_0.VSS.n1283 wind_comp_0.sg13g2_and2_2$1_0.VSS.n517 0.215016
R5040 wind_comp_0.sg13g2_and2_2$1_0.VSS.n1286 wind_comp_0.sg13g2_and2_2$1_0.VSS.n518 0.215016
R5041 wind_comp_0.sg13g2_and2_2$1_0.VSS.n1290 wind_comp_0.sg13g2_and2_2$1_0.VSS.t160 0.215016
R5042 wind_comp_0.sg13g2_and2_2$1_0.VSS.n1288 wind_comp_0.sg13g2_and2_2$1_0.VSS.n519 0.215016
R5043 wind_comp_0.sg13g2_and2_2$1_0.VSS.n1291 wind_comp_0.sg13g2_and2_2$1_0.VSS.n520 0.215016
R5044 wind_comp_0.sg13g2_and2_2$1_0.VSS.n1294 wind_comp_0.sg13g2_and2_2$1_0.VSS.n521 0.215016
R5045 wind_comp_0.sg13g2_and2_2$1_0.VSS.n1296 wind_comp_0.sg13g2_and2_2$1_0.VSS.n522 0.215016
R5046 wind_comp_0.sg13g2_and2_2$1_0.VSS.n1299 wind_comp_0.sg13g2_and2_2$1_0.VSS.n523 0.215016
R5047 wind_comp_0.sg13g2_and2_2$1_0.VSS.n1928 wind_comp_0.sg13g2_and2_2$1_0.VSS.n1927 0.215016
R5048 wind_comp_0.sg13g2_and2_2$1_0.VSS.n130 wind_comp_0.sg13g2_and2_2$1_0.VSS.n1587 18.878
R5049 wind_comp_0.sg13g2_and2_2$1_0.VSS.t177 wind_comp_0.sg13g2_and2_2$1_0.VSS.n1191 0.215016
R5050 wind_comp_0.sg13g2_and2_2$1_0.VSS.n1597 wind_comp_0.sg13g2_and2_2$1_0.VSS.t196 0.215016
R5051 wind_comp_0.sg13g2_and2_2$1_0.VSS.n1650 wind_comp_0.sg13g2_and2_2$1_0.VSS.n1649 0.215016
R5052 wind_comp_0.sg13g2_and2_2$1_0.VSS.t367 wind_comp_0.sg13g2_and2_2$1_0.VSS.n1656 0.215016
R5053 wind_comp_0.sg13g2_and2_2$1_0.VSS.n1667 wind_comp_0.sg13g2_and2_2$1_0.VSS.n1666 0.215016
R5054 wind_comp_0.sg13g2_and2_2$1_0.VSS.n1630 wind_comp_0.sg13g2_and2_2$1_0.VSS.n402 0.215016
R5055 wind_comp_0.sg13g2_and2_2$1_0.VSS.t303 wind_comp_0.sg13g2_and2_2$1_0.VSS.n1629 0.215016
R5056 wind_comp_0.sg13g2_and2_2$1_0.VSS.n1619 wind_comp_0.sg13g2_and2_2$1_0.VSS.n415 0.215016
R5057 wind_comp_0.sg13g2_and2_2$1_0.VSS.n2526 wind_comp_0.sg13g2_and2_2$1_0.VSS.t201 0.215016
R5058 wind_comp_0.sg13g2_and2_2$1_0.VSS.t248 wind_comp_0.sg13g2_and2_2$1_0.VSS.n524 0.215016
R5059 wind_comp_0.sg13g2_and2_2$1_0.VSS.n2536 wind_comp_0.sg13g2_and2_2$1_0.VSS.n2535 0.213625
R5060 wind_comp_0.sg13g2_and2_2$1_0.VSS.n2535 wind_comp_0.sg13g2_and2_2$1_0.VSS.n2534 0.213625
R5061 wind_comp_0.sg13g2_and2_2$1_0.VSS.n2543 wind_comp_0.sg13g2_and2_2$1_0.VSS.n2542 0.213625
R5062 wind_comp_0.sg13g2_and2_2$1_0.VSS.n2542 wind_comp_0.sg13g2_and2_2$1_0.VSS.n2541 0.213625
R5063 wind_comp_0.sg13g2_and2_2$1_0.VSS.n2540 wind_comp_0.sg13g2_and2_2$1_0.VSS.n2531 0.213625
R5064 wind_comp_0.sg13g2_and2_2$1_0.VSS.n2546 wind_comp_0.sg13g2_and2_2$1_0.VSS.n2540 0.213625
R5065 wind_comp_0.sg13g2_and2_2$1_0.VSS.n2533 wind_comp_0.sg13g2_and2_2$1_0.VSS.n2532 0.213625
R5066 wind_comp_0.sg13g2_and2_2$1_0.VSS.n2539 wind_comp_0.sg13g2_and2_2$1_0.VSS.n2533 0.213625
R5067 wind_comp_0.sg13g2_and2_2$1_0.VSS.n1541 wind_comp_0.sg13g2_and2_2$1_0.VSS.n1538 0.213625
R5068 wind_comp_0.sg13g2_and2_2$1_0.VSS.n1539 wind_comp_0.sg13g2_and2_2$1_0.VSS.n1538 0.213625
R5069 wind_comp_0.sg13g2_and2_2$1_0.VSS.n1550 wind_comp_0.sg13g2_and2_2$1_0.VSS.n1549 0.213625
R5070 wind_comp_0.sg13g2_and2_2$1_0.VSS.n2551 wind_comp_0.sg13g2_and2_2$1_0.VSS.n2550 0.213625
R5071 wind_comp_0.sg13g2_and2_2$1_0.VSS.n2552 wind_comp_0.sg13g2_and2_2$1_0.VSS.n2551 0.213625
R5072 wind_comp_0.sg13g2_and2_2$1_0.VSS.n2558 wind_comp_0.sg13g2_and2_2$1_0.VSS.n2557 0.213625
R5073 wind_comp_0.sg13g2_and2_2$1_0.VSS.n2559 wind_comp_0.sg13g2_and2_2$1_0.VSS.n2558 0.213625
R5074 wind_comp_0.sg13g2_and2_2$1_0.VSS.n2562 wind_comp_0.sg13g2_and2_2$1_0.VSS.n2556 0.213625
R5075 wind_comp_0.sg13g2_and2_2$1_0.VSS.n2556 wind_comp_0.sg13g2_and2_2$1_0.VSS.n1309 0.213625
R5076 wind_comp_0.sg13g2_and2_2$1_0.VSS.n2555 wind_comp_0.sg13g2_and2_2$1_0.VSS.n2549 0.213625
R5077 wind_comp_0.sg13g2_and2_2$1_0.VSS.n2549 wind_comp_0.sg13g2_and2_2$1_0.VSS.n1310 0.213625
R5078 wind_comp_0.sg13g2_and2_2$1_0.VSS.n1553 wind_comp_0.sg13g2_and2_2$1_0.VSS.n1547 0.213625
R5079 wind_comp_0.sg13g2_and2_2$1_0.VSS.n1548 wind_comp_0.sg13g2_and2_2$1_0.VSS.n1547 0.213625
R5080 wind_comp_0.sg13g2_and2_2$1_0.VSS.n189 wind_comp_0.sg13g2_and2_2$1_0.VSS.n1879 0.213625
R5081 wind_comp_0.sg13g2_and2_2$1_0.VSS.n1879 wind_comp_0.sg13g2_and2_2$1_0.VSS.n1874 0.213625
R5082 wind_comp_0.sg13g2_and2_2$1_0.VSS.n1878 wind_comp_0.sg13g2_and2_2$1_0.VSS.n1877 0.213625
R5083 wind_comp_0.sg13g2_and2_2$1_0.VSS.n1878 wind_comp_0.sg13g2_and2_2$1_0.VSS.n1876 0.213625
R5084 wind_comp_0.sg13g2_and2_2$1_0.VSS.n92 wind_comp_0.sg13g2_and2_2$1_0.VSS.n1864 0.213625
R5085 wind_comp_0.sg13g2_and2_2$1_0.VSS.n1864 wind_comp_0.sg13g2_and2_2$1_0.VSS.n1859 0.213625
R5086 wind_comp_0.sg13g2_and2_2$1_0.VSS.n1863 wind_comp_0.sg13g2_and2_2$1_0.VSS.n1862 0.213625
R5087 wind_comp_0.sg13g2_and2_2$1_0.VSS.n1863 wind_comp_0.sg13g2_and2_2$1_0.VSS.n1861 0.213625
R5088 wind_comp_0.sg13g2_and2_2$1_0.VSS.n2329 wind_comp_0.sg13g2_and2_2$1_0.VSS.n2327 0.213625
R5089 wind_comp_0.sg13g2_and2_2$1_0.VSS.n2334 wind_comp_0.sg13g2_and2_2$1_0.VSS.n2327 0.213625
R5090 wind_comp_0.sg13g2_and2_2$1_0.VSS.n2331 wind_comp_0.sg13g2_and2_2$1_0.VSS.n2330 0.213625
R5091 wind_comp_0.sg13g2_and2_2$1_0.VSS.n2330 wind_comp_0.sg13g2_and2_2$1_0.VSS.n2328 0.213625
R5092 wind_comp_0.sg13g2_and2_2$1_0.VSS.n2298 wind_comp_0.sg13g2_and2_2$1_0.VSS.n2297 0.213625
R5093 wind_comp_0.sg13g2_and2_2$1_0.VSS.n2297 wind_comp_0.sg13g2_and2_2$1_0.VSS.n2292 0.213625
R5094 wind_comp_0.sg13g2_and2_2$1_0.VSS.n2296 wind_comp_0.sg13g2_and2_2$1_0.VSS.n2295 0.213625
R5095 wind_comp_0.sg13g2_and2_2$1_0.VSS.n2296 wind_comp_0.sg13g2_and2_2$1_0.VSS.n2294 0.213625
R5096 wind_comp_0.sg13g2_and2_2$1_0.VSS.n2320 wind_comp_0.sg13g2_and2_2$1_0.VSS.n2318 0.213625
R5097 wind_comp_0.sg13g2_and2_2$1_0.VSS.n15 wind_comp_0.sg13g2_and2_2$1_0.VSS.n2318 0.213625
R5098 wind_comp_0.sg13g2_and2_2$1_0.VSS.n2322 wind_comp_0.sg13g2_and2_2$1_0.VSS.n2321 0.213625
R5099 wind_comp_0.sg13g2_and2_2$1_0.VSS.n2321 wind_comp_0.sg13g2_and2_2$1_0.VSS.n2319 0.213625
R5100 wind_comp_0.sg13g2_and2_2$1_0.VSS.n2308 wind_comp_0.sg13g2_and2_2$1_0.VSS.n2307 0.213625
R5101 wind_comp_0.sg13g2_and2_2$1_0.VSS.n2307 wind_comp_0.sg13g2_and2_2$1_0.VSS.n2302 0.213625
R5102 wind_comp_0.sg13g2_and2_2$1_0.VSS.n2306 wind_comp_0.sg13g2_and2_2$1_0.VSS.n2305 0.213625
R5103 wind_comp_0.sg13g2_and2_2$1_0.VSS.n2306 wind_comp_0.sg13g2_and2_2$1_0.VSS.n2304 0.213625
R5104 wind_comp_0.sg13g2_and2_2$1_0.VSS.n147 wind_comp_0.sg13g2_and2_2$1_0.VSS.n1910 0.213625
R5105 wind_comp_0.sg13g2_and2_2$1_0.VSS.n1910 wind_comp_0.sg13g2_and2_2$1_0.VSS.n293 0.213625
R5106 wind_comp_0.sg13g2_and2_2$1_0.VSS.n1909 wind_comp_0.sg13g2_and2_2$1_0.VSS.n1908 0.213625
R5107 wind_comp_0.sg13g2_and2_2$1_0.VSS.n1909 wind_comp_0.sg13g2_and2_2$1_0.VSS.n1907 0.213625
R5108 wind_comp_0.sg13g2_and2_2$1_0.VSS.n1904 wind_comp_0.sg13g2_and2_2$1_0.VSS.n1903 0.213625
R5109 wind_comp_0.sg13g2_and2_2$1_0.VSS.n1903 wind_comp_0.sg13g2_and2_2$1_0.VSS.n1902 0.213625
R5110 wind_comp_0.sg13g2_and2_2$1_0.VSS.n1911 wind_comp_0.sg13g2_and2_2$1_0.VSS.n1901 0.213625
R5111 wind_comp_0.sg13g2_and2_2$1_0.VSS.n292 wind_comp_0.sg13g2_and2_2$1_0.VSS.n1901 0.213625
R5112 wind_comp_0.sg13g2_and2_2$1_0.VSS.n153 wind_comp_0.sg13g2_and2_2$1_0.VSS.n1926 0.213625
R5113 wind_comp_0.sg13g2_and2_2$1_0.VSS.n1926 wind_comp_0.sg13g2_and2_2$1_0.VSS.n1921 0.213625
R5114 wind_comp_0.sg13g2_and2_2$1_0.VSS.n1925 wind_comp_0.sg13g2_and2_2$1_0.VSS.n1924 0.213625
R5115 wind_comp_0.sg13g2_and2_2$1_0.VSS.n1925 wind_comp_0.sg13g2_and2_2$1_0.VSS.n1923 0.213625
R5116 wind_comp_0.sg13g2_and2_2$1_0.VSS.n1918 wind_comp_0.sg13g2_and2_2$1_0.VSS.n1917 0.213625
R5117 wind_comp_0.sg13g2_and2_2$1_0.VSS.n1917 wind_comp_0.sg13g2_and2_2$1_0.VSS.n1916 0.213625
R5118 wind_comp_0.sg13g2_and2_2$1_0.VSS.n1915 wind_comp_0.sg13g2_and2_2$1_0.VSS.n154 0.213625
R5119 wind_comp_0.sg13g2_and2_2$1_0.VSS.n298 wind_comp_0.sg13g2_and2_2$1_0.VSS.n1915 0.213625
R5120 wind_comp_0.sg13g2_and2_2$1_0.VSS.n1887 wind_comp_0.sg13g2_and2_2$1_0.VSS.n114 0.213625
R5121 wind_comp_0.sg13g2_and2_2$1_0.VSS.n116 wind_comp_0.sg13g2_and2_2$1_0.VSS.n1887 0.213625
R5122 wind_comp_0.sg13g2_and2_2$1_0.VSS.n1890 wind_comp_0.sg13g2_and2_2$1_0.VSS.n1889 0.213625
R5123 wind_comp_0.sg13g2_and2_2$1_0.VSS.n1889 wind_comp_0.sg13g2_and2_2$1_0.VSS.n1888 0.213625
R5124 wind_comp_0.sg13g2_and2_2$1_0.VSS.n1896 wind_comp_0.sg13g2_and2_2$1_0.VSS.n1895 0.213625
R5125 wind_comp_0.sg13g2_and2_2$1_0.VSS.n1895 wind_comp_0.sg13g2_and2_2$1_0.VSS.n1894 0.213625
R5126 wind_comp_0.sg13g2_and2_2$1_0.VSS.n1893 wind_comp_0.sg13g2_and2_2$1_0.VSS.n113 0.213625
R5127 wind_comp_0.sg13g2_and2_2$1_0.VSS.n115 wind_comp_0.sg13g2_and2_2$1_0.VSS.n1893 0.213625
R5128 wind_comp_0.sg13g2_and2_2$1_0.VSS.n197 wind_comp_0.sg13g2_and2_2$1_0.VSS.n2222 0.213625
R5129 wind_comp_0.sg13g2_and2_2$1_0.VSS.n2222 wind_comp_0.sg13g2_and2_2$1_0.VSS.n2217 0.213625
R5130 wind_comp_0.sg13g2_and2_2$1_0.VSS.n2221 wind_comp_0.sg13g2_and2_2$1_0.VSS.n2220 0.213625
R5131 wind_comp_0.sg13g2_and2_2$1_0.VSS.n2221 wind_comp_0.sg13g2_and2_2$1_0.VSS.n2219 0.213625
R5132 wind_comp_0.sg13g2_and2_2$1_0.VSS.n2214 wind_comp_0.sg13g2_and2_2$1_0.VSS.n2213 0.213625
R5133 wind_comp_0.sg13g2_and2_2$1_0.VSS.n2213 wind_comp_0.sg13g2_and2_2$1_0.VSS.n2212 0.213625
R5134 wind_comp_0.sg13g2_and2_2$1_0.VSS.n2211 wind_comp_0.sg13g2_and2_2$1_0.VSS.n196 0.213625
R5135 wind_comp_0.sg13g2_and2_2$1_0.VSS.n195 wind_comp_0.sg13g2_and2_2$1_0.VSS.n2211 0.213625
R5136 wind_comp_0.sg13g2_and2_2$1_0.VSS.n2099 wind_comp_0.sg13g2_and2_2$1_0.VSS.n2098 0.213625
R5137 wind_comp_0.sg13g2_and2_2$1_0.VSS.n2100 wind_comp_0.sg13g2_and2_2$1_0.VSS.n2099 0.213625
R5138 wind_comp_0.sg13g2_and2_2$1_0.VSS.n2104 wind_comp_0.sg13g2_and2_2$1_0.VSS.n2097 0.213625
R5139 wind_comp_0.sg13g2_and2_2$1_0.VSS.n2101 wind_comp_0.sg13g2_and2_2$1_0.VSS.n2097 0.213625
R5140 wind_comp_0.sg13g2_and2_2$1_0.VSS.n37 wind_comp_0.sg13g2_and2_2$1_0.VSS.n2088 0.213625
R5141 wind_comp_0.sg13g2_and2_2$1_0.VSS.n2118 wind_comp_0.sg13g2_and2_2$1_0.VSS.n2088 0.213625
R5142 wind_comp_0.sg13g2_and2_2$1_0.VSS.n2090 wind_comp_0.sg13g2_and2_2$1_0.VSS.n2089 0.213625
R5143 wind_comp_0.sg13g2_and2_2$1_0.VSS.n2091 wind_comp_0.sg13g2_and2_2$1_0.VSS.n2090 0.213625
R5144 wind_comp_0.sg13g2_and2_2$1_0.VSS.n688 wind_comp_0.sg13g2_and2_2$1_0.VSS.n681 0.213625
R5145 wind_comp_0.sg13g2_and2_2$1_0.VSS.n685 wind_comp_0.sg13g2_and2_2$1_0.VSS.n681 0.213625
R5146 wind_comp_0.sg13g2_and2_2$1_0.VSS.n683 wind_comp_0.sg13g2_and2_2$1_0.VSS.n682 0.213625
R5147 wind_comp_0.sg13g2_and2_2$1_0.VSS.n684 wind_comp_0.sg13g2_and2_2$1_0.VSS.n683 0.213625
R5148 wind_comp_0.sg13g2_and2_2$1_0.VSS.n224 wind_comp_0.sg13g2_and2_2$1_0.VSS.n734 0.213625
R5149 wind_comp_0.sg13g2_and2_2$1_0.VSS.n740 wind_comp_0.sg13g2_and2_2$1_0.VSS.n734 0.213625
R5150 wind_comp_0.sg13g2_and2_2$1_0.VSS.n736 wind_comp_0.sg13g2_and2_2$1_0.VSS.n735 0.213625
R5151 wind_comp_0.sg13g2_and2_2$1_0.VSS.n737 wind_comp_0.sg13g2_and2_2$1_0.VSS.n736 0.213625
R5152 wind_comp_0.sg13g2_and2_2$1_0.VSS.n1533 wind_comp_0.sg13g2_and2_2$1_0.VSS.n1527 0.21152
R5153 wind_comp_0.sg13g2_and2_2$1_0.VSS.n1534 wind_comp_0.sg13g2_and2_2$1_0.VSS.n1533 0.21152
R5154 wind_comp_0.sg13g2_and2_2$1_0.VSS.n698 wind_comp_0.comparator_0.dynamic_pcell$1_0.SRC_NET_PQRS 0.193645
R5155 wind_comp_0.sg13g2_and2_2$1_0.VSS.n1958 wind_comp_0.comparator_1.dynamic_pcell$1_0.SRC_NET_PQRS 0.193645
R5156 wind_comp_0.sg13g2_and2_2$1_0.VSS.n1718 wind_comp_0.sg13g2_and2_2$1_0.VSS.n1717 0.190335
R5157 wind_comp_0.sg13g2_and2_2$1_0.VSS.n1560 wind_comp_0.sg13g2_and2_2$1_0.VSS.n1559 0.1885
R5158 wind_comp_0.sg13g2_and2_2$1_0.VSS.n1560 wind_comp_0.sg13g2_and2_2$1_0.VSS.n1556 0.1885
R5159 wind_comp_0.sg13g2_and2_2$1_0.VSS.n2525 wind_comp_0.sg13g2_and2_2$1_0.VSS.n2524 0.187817
R5160 wind_comp_0.sg13g2_and2_2$1_0.VSS.n1675 wind_comp_0.sg13g2_and2_2$1_0.VSS.n1613 0.180795
R5161 wind_comp_0.sg13g2_and2_2$1_0.VSS.n2521 wind_comp_0.comparator_1.dynamic_pcell_0.SRC_NET_GH 0.180445
R5162 wind_comp_0.sg13g2_and2_2$1_0.VSS.n1567 wind_comp_0.comparator_0.dynamic_pcell_0.SRC_NET_GH 0.180445
R5163 wind_comp_0.sg13g2_and2_2$1_0.VSS.n1486 wind_comp_0.sg13g2_and2_2$1_0.VSS.n1271 0.180425
R5164 wind_comp_0.sg13g2_and2_2$1_0.VSS.n2567 wind_comp_0.sg13g2_and2_2$1_0.VSS.n208 0.187506
R5165 wind_comp_0.sg13g2_and2_2$1_0.VSS.n1349 wind_comp_0.sg13g2_and2_2$1_0.VSS.n1341 0.175813
R5166 wind_comp_0.sg13g2_and2_2$1_0.VSS.n1346 wind_comp_0.sg13g2_and2_2$1_0.VSS.n1341 0.175813
R5167 wind_comp_0.sg13g2_and2_2$1_0.VSS.n1343 wind_comp_0.sg13g2_and2_2$1_0.VSS.n1342 0.175813
R5168 wind_comp_0.sg13g2_and2_2$1_0.VSS.n1344 wind_comp_0.sg13g2_and2_2$1_0.VSS.n1343 0.175813
R5169 wind_comp_0.sg13g2_and2_2$1_0.VSS.n1530 wind_comp_0.sg13g2_and2_2$1_0.VSS.n1527 0.175813
R5170 wind_comp_0.sg13g2_and2_2$1_0.VSS.n1531 wind_comp_0.sg13g2_and2_2$1_0.VSS.n1530 0.175813
R5171 wind_comp_0.sg13g2_and2_2$1_0.VSS.n1534 wind_comp_0.sg13g2_and2_2$1_0.VSS.n1526 0.175813
R5172 wind_comp_0.sg13g2_and2_2$1_0.VSS.n1529 wind_comp_0.sg13g2_and2_2$1_0.VSS.n1526 0.175813
R5173 wind_comp_0.sg13g2_and2_2$1_0.VSS.n1330 wind_comp_0.sg13g2_and2_2$1_0.VSS.n1321 0.175813
R5174 wind_comp_0.sg13g2_and2_2$1_0.VSS.n1327 wind_comp_0.sg13g2_and2_2$1_0.VSS.n1321 0.175813
R5175 wind_comp_0.sg13g2_and2_2$1_0.VSS.n1323 wind_comp_0.sg13g2_and2_2$1_0.VSS.n1322 0.175813
R5176 wind_comp_0.sg13g2_and2_2$1_0.VSS.n1324 wind_comp_0.sg13g2_and2_2$1_0.VSS.n1323 0.175813
R5177 wind_comp_0.sg13g2_and2_2$1_0.VSS.n1695 wind_comp_0.sg13g2_and2_2$1_0.VSS.n1694 0.175813
R5178 wind_comp_0.sg13g2_and2_2$1_0.VSS.n1701 wind_comp_0.sg13g2_and2_2$1_0.VSS.n1695 0.175813
R5179 wind_comp_0.sg13g2_and2_2$1_0.VSS.n1698 wind_comp_0.sg13g2_and2_2$1_0.VSS.n1697 0.175813
R5180 wind_comp_0.sg13g2_and2_2$1_0.VSS.n1697 wind_comp_0.sg13g2_and2_2$1_0.VSS.n1696 0.175813
R5181 wind_comp_0.sg13g2_and2_2$1_0.VSS.n1716 wind_comp_0.sg13g2_and2_2$1_0.VSS.n1715 0.175813
R5182 wind_comp_0.sg13g2_and2_2$1_0.VSS.n1715 wind_comp_0.sg13g2_and2_2$1_0.VSS.n1710 0.175813
R5183 wind_comp_0.sg13g2_and2_2$1_0.VSS.n1714 wind_comp_0.sg13g2_and2_2$1_0.VSS.n1713 0.175813
R5184 wind_comp_0.sg13g2_and2_2$1_0.VSS.n1714 wind_comp_0.sg13g2_and2_2$1_0.VSS.n1712 0.175813
R5185 wind_comp_0.sg13g2_and2_2$1_0.VSS.n1559 wind_comp_0.sg13g2_and2_2$1_0.VSS.n1558 0.175813
R5186 wind_comp_0.sg13g2_and2_2$1_0.VSS.n1557 wind_comp_0.sg13g2_and2_2$1_0.VSS.n1546 0.175813
R5187 wind_comp_0.sg13g2_and2_2$1_0.VSS.n1557 wind_comp_0.sg13g2_and2_2$1_0.VSS.n1556 0.175813
R5188 wind_comp_0.sg13g2_and2_2$1_0.VSS.n1858 wind_comp_0.sg13g2_and2_2$1_0.VSS.n1857 0.175813
R5189 wind_comp_0.sg13g2_and2_2$1_0.VSS.n186 wind_comp_0.sg13g2_and2_2$1_0.VSS.n1858 0.175813
R5190 wind_comp_0.sg13g2_and2_2$1_0.VSS.n1855 wind_comp_0.sg13g2_and2_2$1_0.VSS.n1853 0.175813
R5191 wind_comp_0.sg13g2_and2_2$1_0.VSS.n1854 wind_comp_0.sg13g2_and2_2$1_0.VSS.n1853 0.175813
R5192 wind_comp_0.sg13g2_and2_2$1_0.VSS.n1873 wind_comp_0.sg13g2_and2_2$1_0.VSS.n190 0.175813
R5193 wind_comp_0.sg13g2_and2_2$1_0.VSS.n182 wind_comp_0.sg13g2_and2_2$1_0.VSS.n1873 0.175813
R5194 wind_comp_0.sg13g2_and2_2$1_0.VSS.n1870 wind_comp_0.sg13g2_and2_2$1_0.VSS.n1869 0.175813
R5195 wind_comp_0.sg13g2_and2_2$1_0.VSS.n1869 wind_comp_0.sg13g2_and2_2$1_0.VSS.n1868 0.175813
R5196 wind_comp_0.sg13g2_and2_2$1_0.VSS.n2545 wind_comp_0.sg13g2_and2_2$1_0.VSS.n2541 0.172833
R5197 wind_comp_0.sg13g2_and2_2$1_0.VSS.n2546 wind_comp_0.sg13g2_and2_2$1_0.VSS.n2545 0.172833
R5198 wind_comp_0.sg13g2_and2_2$1_0.VSS.n2539 wind_comp_0.sg13g2_and2_2$1_0.VSS.n2538 0.172833
R5199 wind_comp_0.sg13g2_and2_2$1_0.VSS.n2538 wind_comp_0.sg13g2_and2_2$1_0.VSS.n2534 0.172833
R5200 wind_comp_0.sg13g2_and2_2$1_0.VSS.n2544 wind_comp_0.sg13g2_and2_2$1_0.VSS.n2543 0.172833
R5201 wind_comp_0.sg13g2_and2_2$1_0.VSS.n2544 wind_comp_0.sg13g2_and2_2$1_0.VSS.n2531 0.172833
R5202 wind_comp_0.sg13g2_and2_2$1_0.VSS.n2537 wind_comp_0.sg13g2_and2_2$1_0.VSS.n2532 0.172833
R5203 wind_comp_0.sg13g2_and2_2$1_0.VSS.n2537 wind_comp_0.sg13g2_and2_2$1_0.VSS.n2536 0.172833
R5204 wind_comp_0.sg13g2_and2_2$1_0.VSS.n1349 wind_comp_0.sg13g2_and2_2$1_0.VSS.n1348 0.172833
R5205 wind_comp_0.sg13g2_and2_2$1_0.VSS.n1348 wind_comp_0.sg13g2_and2_2$1_0.VSS.n1342 0.172833
R5206 wind_comp_0.sg13g2_and2_2$1_0.VSS.n1347 wind_comp_0.sg13g2_and2_2$1_0.VSS.n1346 0.172833
R5207 wind_comp_0.sg13g2_and2_2$1_0.VSS.n1347 wind_comp_0.sg13g2_and2_2$1_0.VSS.n1344 0.172833
R5208 wind_comp_0.sg13g2_and2_2$1_0.VSS.n1330 wind_comp_0.sg13g2_and2_2$1_0.VSS.n1329 0.172833
R5209 wind_comp_0.sg13g2_and2_2$1_0.VSS.n1329 wind_comp_0.sg13g2_and2_2$1_0.VSS.n1322 0.172833
R5210 wind_comp_0.sg13g2_and2_2$1_0.VSS.n1328 wind_comp_0.sg13g2_and2_2$1_0.VSS.n1327 0.172833
R5211 wind_comp_0.sg13g2_and2_2$1_0.VSS.n1328 wind_comp_0.sg13g2_and2_2$1_0.VSS.n1324 0.172833
R5212 wind_comp_0.sg13g2_and2_2$1_0.VSS.n1700 wind_comp_0.sg13g2_and2_2$1_0.VSS.n1696 0.172833
R5213 wind_comp_0.sg13g2_and2_2$1_0.VSS.n1701 wind_comp_0.sg13g2_and2_2$1_0.VSS.n1700 0.172833
R5214 wind_comp_0.sg13g2_and2_2$1_0.VSS.n1699 wind_comp_0.sg13g2_and2_2$1_0.VSS.n1698 0.172833
R5215 wind_comp_0.sg13g2_and2_2$1_0.VSS.n1699 wind_comp_0.sg13g2_and2_2$1_0.VSS.n1694 0.172833
R5216 wind_comp_0.sg13g2_and2_2$1_0.VSS.n1712 wind_comp_0.sg13g2_and2_2$1_0.VSS.n1711 0.172833
R5217 wind_comp_0.sg13g2_and2_2$1_0.VSS.n1711 wind_comp_0.sg13g2_and2_2$1_0.VSS.n1710 0.172833
R5218 wind_comp_0.sg13g2_and2_2$1_0.VSS.n1713 wind_comp_0.sg13g2_and2_2$1_0.VSS.n1708 0.172833
R5219 wind_comp_0.sg13g2_and2_2$1_0.VSS.n1716 wind_comp_0.sg13g2_and2_2$1_0.VSS.n1708 0.172833
R5220 wind_comp_0.sg13g2_and2_2$1_0.VSS.n2560 wind_comp_0.sg13g2_and2_2$1_0.VSS.n2559 0.172833
R5221 wind_comp_0.sg13g2_and2_2$1_0.VSS.n2560 wind_comp_0.sg13g2_and2_2$1_0.VSS.n1309 0.172833
R5222 wind_comp_0.sg13g2_and2_2$1_0.VSS.n2553 wind_comp_0.sg13g2_and2_2$1_0.VSS.n1310 0.172833
R5223 wind_comp_0.sg13g2_and2_2$1_0.VSS.n2553 wind_comp_0.sg13g2_and2_2$1_0.VSS.n2552 0.172833
R5224 wind_comp_0.sg13g2_and2_2$1_0.VSS.n2561 wind_comp_0.sg13g2_and2_2$1_0.VSS.n2557 0.172833
R5225 wind_comp_0.sg13g2_and2_2$1_0.VSS.n2562 wind_comp_0.sg13g2_and2_2$1_0.VSS.n2561 0.172833
R5226 wind_comp_0.sg13g2_and2_2$1_0.VSS.n2555 wind_comp_0.sg13g2_and2_2$1_0.VSS.n2554 0.172833
R5227 wind_comp_0.sg13g2_and2_2$1_0.VSS.n2554 wind_comp_0.sg13g2_and2_2$1_0.VSS.n2550 0.172833
R5228 wind_comp_0.sg13g2_and2_2$1_0.VSS.n1857 wind_comp_0.sg13g2_and2_2$1_0.VSS.n1856 0.172833
R5229 wind_comp_0.sg13g2_and2_2$1_0.VSS.n1856 wind_comp_0.sg13g2_and2_2$1_0.VSS.n1855 0.172833
R5230 wind_comp_0.sg13g2_and2_2$1_0.VSS.n186 wind_comp_0.sg13g2_and2_2$1_0.VSS.n1852 0.172833
R5231 wind_comp_0.sg13g2_and2_2$1_0.VSS.n1854 wind_comp_0.sg13g2_and2_2$1_0.VSS.n1852 0.172833
R5232 wind_comp_0.sg13g2_and2_2$1_0.VSS.n1871 wind_comp_0.sg13g2_and2_2$1_0.VSS.n190 0.172833
R5233 wind_comp_0.sg13g2_and2_2$1_0.VSS.n1871 wind_comp_0.sg13g2_and2_2$1_0.VSS.n1870 0.172833
R5234 wind_comp_0.sg13g2_and2_2$1_0.VSS.n182 wind_comp_0.sg13g2_and2_2$1_0.VSS.n1872 0.172833
R5235 wind_comp_0.sg13g2_and2_2$1_0.VSS.n1872 wind_comp_0.sg13g2_and2_2$1_0.VSS.n1868 0.172833
R5236 wind_comp_0.sg13g2_and2_2$1_0.VSS.n1876 wind_comp_0.sg13g2_and2_2$1_0.VSS.n1875 0.172833
R5237 wind_comp_0.sg13g2_and2_2$1_0.VSS.n1875 wind_comp_0.sg13g2_and2_2$1_0.VSS.n1874 0.172833
R5238 wind_comp_0.sg13g2_and2_2$1_0.VSS.n1877 wind_comp_0.sg13g2_and2_2$1_0.VSS.n1867 0.172833
R5239 wind_comp_0.sg13g2_and2_2$1_0.VSS.n189 wind_comp_0.sg13g2_and2_2$1_0.VSS.n1867 0.172833
R5240 wind_comp_0.sg13g2_and2_2$1_0.VSS.n1861 wind_comp_0.sg13g2_and2_2$1_0.VSS.n1860 0.172833
R5241 wind_comp_0.sg13g2_and2_2$1_0.VSS.n1860 wind_comp_0.sg13g2_and2_2$1_0.VSS.n1859 0.172833
R5242 wind_comp_0.sg13g2_and2_2$1_0.VSS.n1862 wind_comp_0.sg13g2_and2_2$1_0.VSS.n1851 0.172833
R5243 wind_comp_0.sg13g2_and2_2$1_0.VSS.n92 wind_comp_0.sg13g2_and2_2$1_0.VSS.n1851 0.172833
R5244 wind_comp_0.sg13g2_and2_2$1_0.VSS.n2333 wind_comp_0.sg13g2_and2_2$1_0.VSS.n2328 0.172833
R5245 wind_comp_0.sg13g2_and2_2$1_0.VSS.n2334 wind_comp_0.sg13g2_and2_2$1_0.VSS.n2333 0.172833
R5246 wind_comp_0.sg13g2_and2_2$1_0.VSS.n2332 wind_comp_0.sg13g2_and2_2$1_0.VSS.n2331 0.172833
R5247 wind_comp_0.sg13g2_and2_2$1_0.VSS.n2332 wind_comp_0.sg13g2_and2_2$1_0.VSS.n2329 0.172833
R5248 wind_comp_0.sg13g2_and2_2$1_0.VSS.n2294 wind_comp_0.sg13g2_and2_2$1_0.VSS.n2293 0.172833
R5249 wind_comp_0.sg13g2_and2_2$1_0.VSS.n2293 wind_comp_0.sg13g2_and2_2$1_0.VSS.n2292 0.172833
R5250 wind_comp_0.sg13g2_and2_2$1_0.VSS.n2295 wind_comp_0.sg13g2_and2_2$1_0.VSS.n2228 0.172833
R5251 wind_comp_0.sg13g2_and2_2$1_0.VSS.n2298 wind_comp_0.sg13g2_and2_2$1_0.VSS.n2228 0.172833
R5252 wind_comp_0.sg13g2_and2_2$1_0.VSS.n2324 wind_comp_0.sg13g2_and2_2$1_0.VSS.n2319 0.172833
R5253 wind_comp_0.sg13g2_and2_2$1_0.VSS.n15 wind_comp_0.sg13g2_and2_2$1_0.VSS.n2324 0.172833
R5254 wind_comp_0.sg13g2_and2_2$1_0.VSS.n2323 wind_comp_0.sg13g2_and2_2$1_0.VSS.n2322 0.172833
R5255 wind_comp_0.sg13g2_and2_2$1_0.VSS.n2323 wind_comp_0.sg13g2_and2_2$1_0.VSS.n2320 0.172833
R5256 wind_comp_0.sg13g2_and2_2$1_0.VSS.n2304 wind_comp_0.sg13g2_and2_2$1_0.VSS.n2303 0.172833
R5257 wind_comp_0.sg13g2_and2_2$1_0.VSS.n2303 wind_comp_0.sg13g2_and2_2$1_0.VSS.n2302 0.172833
R5258 wind_comp_0.sg13g2_and2_2$1_0.VSS.n2305 wind_comp_0.sg13g2_and2_2$1_0.VSS.n2301 0.172833
R5259 wind_comp_0.sg13g2_and2_2$1_0.VSS.n2308 wind_comp_0.sg13g2_and2_2$1_0.VSS.n2301 0.172833
R5260 wind_comp_0.sg13g2_and2_2$1_0.VSS.n292 wind_comp_0.sg13g2_and2_2$1_0.VSS.n1913 0.172833
R5261 wind_comp_0.sg13g2_and2_2$1_0.VSS.n1913 wind_comp_0.sg13g2_and2_2$1_0.VSS.n1902 0.172833
R5262 wind_comp_0.sg13g2_and2_2$1_0.VSS.n1907 wind_comp_0.sg13g2_and2_2$1_0.VSS.n1906 0.172833
R5263 wind_comp_0.sg13g2_and2_2$1_0.VSS.n1906 wind_comp_0.sg13g2_and2_2$1_0.VSS.n293 0.172833
R5264 wind_comp_0.sg13g2_and2_2$1_0.VSS.n1908 wind_comp_0.sg13g2_and2_2$1_0.VSS.n1905 0.172833
R5265 wind_comp_0.sg13g2_and2_2$1_0.VSS.n147 wind_comp_0.sg13g2_and2_2$1_0.VSS.n1905 0.172833
R5266 wind_comp_0.sg13g2_and2_2$1_0.VSS.n1912 wind_comp_0.sg13g2_and2_2$1_0.VSS.n1911 0.172833
R5267 wind_comp_0.sg13g2_and2_2$1_0.VSS.n1912 wind_comp_0.sg13g2_and2_2$1_0.VSS.n1904 0.172833
R5268 wind_comp_0.sg13g2_and2_2$1_0.VSS.n298 wind_comp_0.sg13g2_and2_2$1_0.VSS.n1920 0.172833
R5269 wind_comp_0.sg13g2_and2_2$1_0.VSS.n1920 wind_comp_0.sg13g2_and2_2$1_0.VSS.n1916 0.172833
R5270 wind_comp_0.sg13g2_and2_2$1_0.VSS.n1923 wind_comp_0.sg13g2_and2_2$1_0.VSS.n1922 0.172833
R5271 wind_comp_0.sg13g2_and2_2$1_0.VSS.n1922 wind_comp_0.sg13g2_and2_2$1_0.VSS.n1921 0.172833
R5272 wind_comp_0.sg13g2_and2_2$1_0.VSS.n1924 wind_comp_0.sg13g2_and2_2$1_0.VSS.n1914 0.172833
R5273 wind_comp_0.sg13g2_and2_2$1_0.VSS.n153 wind_comp_0.sg13g2_and2_2$1_0.VSS.n1914 0.172833
R5274 wind_comp_0.sg13g2_and2_2$1_0.VSS.n1919 wind_comp_0.sg13g2_and2_2$1_0.VSS.n154 0.172833
R5275 wind_comp_0.sg13g2_and2_2$1_0.VSS.n1919 wind_comp_0.sg13g2_and2_2$1_0.VSS.n1918 0.172833
R5276 wind_comp_0.sg13g2_and2_2$1_0.VSS.n115 wind_comp_0.sg13g2_and2_2$1_0.VSS.n1898 0.172833
R5277 wind_comp_0.sg13g2_and2_2$1_0.VSS.n1898 wind_comp_0.sg13g2_and2_2$1_0.VSS.n1894 0.172833
R5278 wind_comp_0.sg13g2_and2_2$1_0.VSS.n1892 wind_comp_0.sg13g2_and2_2$1_0.VSS.n1888 0.172833
R5279 wind_comp_0.sg13g2_and2_2$1_0.VSS.n116 wind_comp_0.sg13g2_and2_2$1_0.VSS.n1892 0.172833
R5280 wind_comp_0.sg13g2_and2_2$1_0.VSS.n1891 wind_comp_0.sg13g2_and2_2$1_0.VSS.n1890 0.172833
R5281 wind_comp_0.sg13g2_and2_2$1_0.VSS.n1891 wind_comp_0.sg13g2_and2_2$1_0.VSS.n114 0.172833
R5282 wind_comp_0.sg13g2_and2_2$1_0.VSS.n1897 wind_comp_0.sg13g2_and2_2$1_0.VSS.n113 0.172833
R5283 wind_comp_0.sg13g2_and2_2$1_0.VSS.n1897 wind_comp_0.sg13g2_and2_2$1_0.VSS.n1896 0.172833
R5284 wind_comp_0.sg13g2_and2_2$1_0.VSS.n195 wind_comp_0.sg13g2_and2_2$1_0.VSS.n2216 0.172833
R5285 wind_comp_0.sg13g2_and2_2$1_0.VSS.n2216 wind_comp_0.sg13g2_and2_2$1_0.VSS.n2212 0.172833
R5286 wind_comp_0.sg13g2_and2_2$1_0.VSS.n2219 wind_comp_0.sg13g2_and2_2$1_0.VSS.n2218 0.172833
R5287 wind_comp_0.sg13g2_and2_2$1_0.VSS.n2218 wind_comp_0.sg13g2_and2_2$1_0.VSS.n2217 0.172833
R5288 wind_comp_0.sg13g2_and2_2$1_0.VSS.n2220 wind_comp_0.sg13g2_and2_2$1_0.VSS.n2210 0.172833
R5289 wind_comp_0.sg13g2_and2_2$1_0.VSS.n197 wind_comp_0.sg13g2_and2_2$1_0.VSS.n2210 0.172833
R5290 wind_comp_0.sg13g2_and2_2$1_0.VSS.n2215 wind_comp_0.sg13g2_and2_2$1_0.VSS.n196 0.172833
R5291 wind_comp_0.sg13g2_and2_2$1_0.VSS.n2215 wind_comp_0.sg13g2_and2_2$1_0.VSS.n2214 0.172833
R5292 wind_comp_0.sg13g2_and2_2$1_0.VSS.n2102 wind_comp_0.sg13g2_and2_2$1_0.VSS.n2101 0.172833
R5293 wind_comp_0.sg13g2_and2_2$1_0.VSS.n2102 wind_comp_0.sg13g2_and2_2$1_0.VSS.n2100 0.172833
R5294 wind_comp_0.sg13g2_and2_2$1_0.VSS.n2104 wind_comp_0.sg13g2_and2_2$1_0.VSS.n2103 0.172833
R5295 wind_comp_0.sg13g2_and2_2$1_0.VSS.n2103 wind_comp_0.sg13g2_and2_2$1_0.VSS.n2098 0.172833
R5296 wind_comp_0.sg13g2_and2_2$1_0.VSS.n37 wind_comp_0.sg13g2_and2_2$1_0.VSS.n2120 0.172833
R5297 wind_comp_0.sg13g2_and2_2$1_0.VSS.n2120 wind_comp_0.sg13g2_and2_2$1_0.VSS.n2089 0.172833
R5298 wind_comp_0.sg13g2_and2_2$1_0.VSS.n2119 wind_comp_0.sg13g2_and2_2$1_0.VSS.n2118 0.172833
R5299 wind_comp_0.sg13g2_and2_2$1_0.VSS.n2119 wind_comp_0.sg13g2_and2_2$1_0.VSS.n2091 0.172833
R5300 wind_comp_0.sg13g2_and2_2$1_0.VSS.n688 wind_comp_0.sg13g2_and2_2$1_0.VSS.n687 0.172833
R5301 wind_comp_0.sg13g2_and2_2$1_0.VSS.n687 wind_comp_0.sg13g2_and2_2$1_0.VSS.n682 0.172833
R5302 wind_comp_0.sg13g2_and2_2$1_0.VSS.n686 wind_comp_0.sg13g2_and2_2$1_0.VSS.n685 0.172833
R5303 wind_comp_0.sg13g2_and2_2$1_0.VSS.n686 wind_comp_0.sg13g2_and2_2$1_0.VSS.n684 0.172833
R5304 wind_comp_0.sg13g2_and2_2$1_0.VSS.n224 wind_comp_0.sg13g2_and2_2$1_0.VSS.n742 0.172833
R5305 wind_comp_0.sg13g2_and2_2$1_0.VSS.n742 wind_comp_0.sg13g2_and2_2$1_0.VSS.n735 0.172833
R5306 wind_comp_0.sg13g2_and2_2$1_0.VSS.n741 wind_comp_0.sg13g2_and2_2$1_0.VSS.n740 0.172833
R5307 wind_comp_0.sg13g2_and2_2$1_0.VSS.n741 wind_comp_0.sg13g2_and2_2$1_0.VSS.n737 0.172833
R5308 wind_comp_0.sg13g2_and2_2$1_0.VSS.n124 wind_comp_0.sg13g2_and2_2$1_0.VSS.n607 5.83527
R5309 wind_comp_0.sg13g2_and2_2$1_0.VSS.n117 wind_comp_0.sg13g2_and2_2$1_0.VSS.n107 0.166708
R5310 wind_comp_0.sg13g2_and2_2$1_0.VSS.n117 wind_comp_0.sg13g2_and2_2$1_0.VSS.n108 0.166708
R5311 wind_comp_0.sg13g2_and2_2$1_0.VSS.n117 wind_comp_0.sg13g2_and2_2$1_0.VSS.n109 0.166708
R5312 wind_comp_0.sg13g2_and2_2$1_0.VSS.n117 wind_comp_0.sg13g2_and2_2$1_0.VSS.n110 0.166708
R5313 wind_comp_0.sg13g2_and2_2$1_0.VSS.n117 wind_comp_0.sg13g2_and2_2$1_0.VSS.n111 0.166708
R5314 wind_comp_0.sg13g2_and2_2$1_0.VSS.n117 wind_comp_0.sg13g2_and2_2$1_0.VSS.n112 0.166708
R5315 wind_comp_0.sg13g2_and2_2$1_0.VSS.n1951 wind_comp_0.sg13g2_and2_2$1_0.VSS.n1932 0.166708
R5316 wind_comp_0.sg13g2_and2_2$1_0.VSS.n1951 wind_comp_0.sg13g2_and2_2$1_0.VSS.n1929 0.166708
R5317 wind_comp_0.sg13g2_and2_2$1_0.VSS.n1951 wind_comp_0.sg13g2_and2_2$1_0.VSS.n1933 0.166708
R5318 wind_comp_0.sg13g2_and2_2$1_0.VSS.n1951 wind_comp_0.sg13g2_and2_2$1_0.VSS.n1934 0.166708
R5319 wind_comp_0.sg13g2_and2_2$1_0.VSS.n1951 wind_comp_0.sg13g2_and2_2$1_0.VSS.n1950 0.166708
R5320 wind_comp_0.sg13g2_and2_2$1_0.VSS.n1702 wind_comp_0.sg13g2_and2_2$1_0.VSS.n1701 0.1655
R5321 wind_comp_0.sg13g2_and2_2$1_0.VSS.n1704 wind_comp_0.sg13g2_and2_2$1_0.VSS.n1694 0.1655
R5322 wind_comp_0.sg13g2_and2_2$1_0.VSS.n1710 wind_comp_0.sg13g2_and2_2$1_0.VSS.n1709 0.1655
R5323 wind_comp_0.sg13g2_and2_2$1_0.VSS.n1717 wind_comp_0.sg13g2_and2_2$1_0.VSS.n1716 0.1655
R5324 wind_comp_0.sg13g2_and2_2$1_0.VSS.n1857 wind_comp_0.sg13g2_and2_2$1_0.VSS.n120 0.1655
R5325 wind_comp_0.sg13g2_and2_2$1_0.VSS.n187 wind_comp_0.sg13g2_and2_2$1_0.VSS.n186 0.1655
R5326 wind_comp_0.sg13g2_and2_2$1_0.VSS.n191 wind_comp_0.sg13g2_and2_2$1_0.VSS.n190 0.1655
R5327 wind_comp_0.sg13g2_and2_2$1_0.VSS.n183 wind_comp_0.sg13g2_and2_2$1_0.VSS.n182 0.1655
R5328 wind_comp_0.sg13g2_and2_2$1_0.VSS.n1874 wind_comp_0.sg13g2_and2_2$1_0.VSS.n183 0.1655
R5329 wind_comp_0.sg13g2_and2_2$1_0.VSS.n191 wind_comp_0.sg13g2_and2_2$1_0.VSS.n189 0.1655
R5330 wind_comp_0.sg13g2_and2_2$1_0.VSS.n1859 wind_comp_0.sg13g2_and2_2$1_0.VSS.n187 0.1655
R5331 wind_comp_0.sg13g2_and2_2$1_0.VSS.n93 wind_comp_0.sg13g2_and2_2$1_0.VSS.n92 0.1655
R5332 wind_comp_0.sg13g2_and2_2$1_0.VSS.n249 wind_comp_0.sg13g2_and2_2$1_0.VSS.n248 0.163463
R5333 wind_comp_0.sg13g2_and2_2$1_0.VSS.n902 wind_comp_0.sg13g2_and2_2$1_0.VSS.n901 0.161833
R5334 wind_comp_0.sg13g2_and2_2$1_0.VSS.n901 wind_comp_0.sg13g2_and2_2$1_0.VSS.n895 0.161833
R5335 wind_comp_0.sg13g2_and2_2$1_0.VSS.n900 wind_comp_0.sg13g2_and2_2$1_0.VSS.n899 0.161833
R5336 wind_comp_0.sg13g2_and2_2$1_0.VSS.n900 wind_comp_0.sg13g2_and2_2$1_0.VSS.n897 0.161833
R5337 wind_comp_0.sg13g2_and2_2$1_0.VSS.n1997 wind_comp_0.sg13g2_and2_2$1_0.VSS.n1994 0.161833
R5338 wind_comp_0.sg13g2_and2_2$1_0.VSS.n1994 wind_comp_0.sg13g2_and2_2$1_0.VSS.n1993 0.161833
R5339 wind_comp_0.sg13g2_and2_2$1_0.VSS.n39 wind_comp_0.sg13g2_and2_2$1_0.VSS.n1990 0.161833
R5340 wind_comp_0.sg13g2_and2_2$1_0.VSS.n1992 wind_comp_0.sg13g2_and2_2$1_0.VSS.n1990 0.161833
R5341 wind_comp_0.sg13g2_and2_2$1_0.VSS.n33 wind_comp_0.sg13g2_and2_2$1_0.VSS.n1989 0.161833
R5342 wind_comp_0.sg13g2_and2_2$1_0.VSS.n1989 wind_comp_0.sg13g2_and2_2$1_0.VSS.n1984 0.161833
R5343 wind_comp_0.sg13g2_and2_2$1_0.VSS.n1988 wind_comp_0.sg13g2_and2_2$1_0.VSS.n1987 0.161833
R5344 wind_comp_0.sg13g2_and2_2$1_0.VSS.n1988 wind_comp_0.sg13g2_and2_2$1_0.VSS.n1986 0.161833
R5345 wind_comp_0.sg13g2_and2_2$1_0.VSS.n2025 wind_comp_0.sg13g2_and2_2$1_0.VSS.n2023 0.161833
R5346 wind_comp_0.sg13g2_and2_2$1_0.VSS.n2023 wind_comp_0.sg13g2_and2_2$1_0.VSS.n2022 0.161833
R5347 wind_comp_0.sg13g2_and2_2$1_0.VSS.n2027 wind_comp_0.sg13g2_and2_2$1_0.VSS.n2019 0.161833
R5348 wind_comp_0.sg13g2_and2_2$1_0.VSS.n2021 wind_comp_0.sg13g2_and2_2$1_0.VSS.n2019 0.161833
R5349 wind_comp_0.sg13g2_and2_2$1_0.VSS.n3 wind_comp_0.sg13g2_and2_2$1_0.VSS.n789 0.161833
R5350 wind_comp_0.sg13g2_and2_2$1_0.VSS.n789 wind_comp_0.sg13g2_and2_2$1_0.VSS.n784 0.161833
R5351 wind_comp_0.sg13g2_and2_2$1_0.VSS.n788 wind_comp_0.sg13g2_and2_2$1_0.VSS.n787 0.161833
R5352 wind_comp_0.sg13g2_and2_2$1_0.VSS.n788 wind_comp_0.sg13g2_and2_2$1_0.VSS.n786 0.161833
R5353 wind_comp_0.sg13g2_and2_2$1_0.VSS.n2580 wind_comp_0.sg13g2_and2_2$1_0.VSS.n2579 0.161833
R5354 wind_comp_0.sg13g2_and2_2$1_0.VSS.n2581 wind_comp_0.sg13g2_and2_2$1_0.VSS.n2580 0.161833
R5355 wind_comp_0.sg13g2_and2_2$1_0.VSS.n2578 wind_comp_0.sg13g2_and2_2$1_0.VSS.n750 0.161833
R5356 wind_comp_0.sg13g2_and2_2$1_0.VSS.n2583 wind_comp_0.sg13g2_and2_2$1_0.VSS.n750 0.161833
R5357 wind_comp_0.sg13g2_and2_2$1_0.VSS.n2587 wind_comp_0.sg13g2_and2_2$1_0.VSS.n2586 0.161833
R5358 wind_comp_0.sg13g2_and2_2$1_0.VSS.n2588 wind_comp_0.sg13g2_and2_2$1_0.VSS.n2587 0.161833
R5359 wind_comp_0.sg13g2_and2_2$1_0.VSS.n2585 wind_comp_0.sg13g2_and2_2$1_0.VSS.n749 0.161833
R5360 wind_comp_0.sg13g2_and2_2$1_0.VSS.n236 wind_comp_0.sg13g2_and2_2$1_0.VSS.n749 0.161833
R5361 wind_comp_0.sg13g2_and2_2$1_0.VSS.n779 wind_comp_0.sg13g2_and2_2$1_0.VSS.n778 0.161833
R5362 wind_comp_0.sg13g2_and2_2$1_0.VSS.n779 wind_comp_0.sg13g2_and2_2$1_0.VSS.n776 0.161833
R5363 wind_comp_0.sg13g2_and2_2$1_0.VSS.n780 wind_comp_0.sg13g2_and2_2$1_0.VSS.n775 0.161833
R5364 wind_comp_0.sg13g2_and2_2$1_0.VSS.n781 wind_comp_0.sg13g2_and2_2$1_0.VSS.n780 0.161833
R5365 wind_comp_0.sg13g2_and2_2$1_0.VSS.n975 wind_comp_0.sg13g2_and2_2$1_0.VSS.n974 0.161833
R5366 wind_comp_0.sg13g2_and2_2$1_0.VSS.n976 wind_comp_0.sg13g2_and2_2$1_0.VSS.n975 0.161833
R5367 wind_comp_0.sg13g2_and2_2$1_0.VSS.n973 wind_comp_0.sg13g2_and2_2$1_0.VSS.n971 0.161833
R5368 wind_comp_0.sg13g2_and2_2$1_0.VSS.n30 wind_comp_0.sg13g2_and2_2$1_0.VSS.n971 0.161833
R5369 wind_comp_0.sg13g2_and2_2$1_0.VSS.n1057 wind_comp_0.sg13g2_and2_2$1_0.VSS.n1049 0.161833
R5370 wind_comp_0.sg13g2_and2_2$1_0.VSS.n23 wind_comp_0.sg13g2_and2_2$1_0.VSS.n1057 0.161833
R5371 wind_comp_0.sg13g2_and2_2$1_0.VSS.n1056 wind_comp_0.sg13g2_and2_2$1_0.VSS.n1055 0.161833
R5372 wind_comp_0.sg13g2_and2_2$1_0.VSS.n1056 wind_comp_0.sg13g2_and2_2$1_0.VSS.n1053 0.161833
R5373 wind_comp_0.sg13g2_and2_2$1_0.VSS.n992 wind_comp_0.sg13g2_and2_2$1_0.VSS.n991 0.161833
R5374 wind_comp_0.sg13g2_and2_2$1_0.VSS.n993 wind_comp_0.sg13g2_and2_2$1_0.VSS.n992 0.161833
R5375 wind_comp_0.sg13g2_and2_2$1_0.VSS.n990 wind_comp_0.sg13g2_and2_2$1_0.VSS.n988 0.161833
R5376 wind_comp_0.sg13g2_and2_2$1_0.VSS.n995 wind_comp_0.sg13g2_and2_2$1_0.VSS.n988 0.161833
R5377 wind_comp_0.sg13g2_and2_2$1_0.VSS.n1024 wind_comp_0.sg13g2_and2_2$1_0.VSS.n1016 0.161833
R5378 wind_comp_0.sg13g2_and2_2$1_0.VSS.n1025 wind_comp_0.sg13g2_and2_2$1_0.VSS.n1024 0.161833
R5379 wind_comp_0.sg13g2_and2_2$1_0.VSS.n1023 wind_comp_0.sg13g2_and2_2$1_0.VSS.n1022 0.161833
R5380 wind_comp_0.sg13g2_and2_2$1_0.VSS.n1023 wind_comp_0.sg13g2_and2_2$1_0.VSS.n1020 0.161833
R5381 wind_comp_0.sg13g2_and2_2$1_0.VSS.n2235 wind_comp_0.sg13g2_and2_2$1_0.VSS.n2234 0.161833
R5382 wind_comp_0.sg13g2_and2_2$1_0.VSS.n2235 wind_comp_0.sg13g2_and2_2$1_0.VSS.n2232 0.161833
R5383 wind_comp_0.sg13g2_and2_2$1_0.VSS.n141 wind_comp_0.sg13g2_and2_2$1_0.VSS.n2236 0.161833
R5384 wind_comp_0.sg13g2_and2_2$1_0.VSS.n2236 wind_comp_0.sg13g2_and2_2$1_0.VSS.n2230 0.161833
R5385 wind_comp_0.sg13g2_and2_2$1_0.VSS.n889 wind_comp_0.sg13g2_and2_2$1_0.VSS.n887 0.161833
R5386 wind_comp_0.sg13g2_and2_2$1_0.VSS.n887 wind_comp_0.sg13g2_and2_2$1_0.VSS.n886 0.161833
R5387 wind_comp_0.sg13g2_and2_2$1_0.VSS.n891 wind_comp_0.sg13g2_and2_2$1_0.VSS.n883 0.161833
R5388 wind_comp_0.sg13g2_and2_2$1_0.VSS.n885 wind_comp_0.sg13g2_and2_2$1_0.VSS.n883 0.161833
R5389 wind_comp_0.sg13g2_and2_2$1_0.VSS.n2315 wind_comp_0.sg13g2_and2_2$1_0.VSS.n2314 0.161833
R5390 wind_comp_0.sg13g2_and2_2$1_0.VSS.n2315 wind_comp_0.sg13g2_and2_2$1_0.VSS.n2312 0.161833
R5391 wind_comp_0.sg13g2_and2_2$1_0.VSS.n2317 wind_comp_0.sg13g2_and2_2$1_0.VSS.n2316 0.161833
R5392 wind_comp_0.sg13g2_and2_2$1_0.VSS.n2316 wind_comp_0.sg13g2_and2_2$1_0.VSS.n2310 0.161833
R5393 wind_comp_0.sg13g2_and2_2$1_0.VSS.n2111 wind_comp_0.sg13g2_and2_2$1_0.VSS.n2096 0.161833
R5394 wind_comp_0.sg13g2_and2_2$1_0.VSS.n2112 wind_comp_0.sg13g2_and2_2$1_0.VSS.n2111 0.161833
R5395 wind_comp_0.sg13g2_and2_2$1_0.VSS.n2110 wind_comp_0.sg13g2_and2_2$1_0.VSS.n2109 0.161833
R5396 wind_comp_0.sg13g2_and2_2$1_0.VSS.n2110 wind_comp_0.sg13g2_and2_2$1_0.VSS.n2107 0.161833
R5397 wind_comp_0.sg13g2_and2_2$1_0.VSS.n4 wind_comp_0.sg13g2_and2_2$1_0.VSS.n20 1.41351
R5398 wind_comp_0.sg13g2_and2_2$1_0.VSS.n79 wind_comp_0.sg13g2_and2_2$1_0.VSS.n27 0.0727463
R5399 wind_comp_0.sg13g2_and2_2$1_0.VSS.n79 wind_comp_0.sg13g2_and2_2$1_0.VSS.n76 0.154383
R5400 wind_comp_0.sg13g2_and2_2$1_0.VSS.n2566 wind_comp_0.sg13g2_and2_2$1_0.VSS.n2565 0.151532
R5401 wind_comp_0.sg13g2_and2_2$1_0.VSS.n1598 wind_comp_0.sg13g2_and2_2$1_0.VSS.n1576 0.151188
R5402 wind_comp_0.sg13g2_and2_2$1_0.VSS.n702 wind_comp_0.comparator_0.dynamic_pcell$1_0.VSS 0.147819
R5403 wind_comp_0.sg13g2_and2_2$1_0.VSS.n2616 wind_comp_0.sg13g2_and2_2$1_0.VSS.n677 0.146155
R5404 wind_comp_0.comparator_0.dynamic_pcell$2_0.SRC_NET_MNO wind_comp_0.sg13g2_and2_2$1_0.VSS.n677 0.146155
R5405 wind_comp_0.comparator_0.dynamic_pcell$2_0.SRC_NET_MNO wind_comp_0.sg13g2_and2_2$1_0.VSS.n676 0.146155
R5406 wind_comp_0.sg13g2_and2_2$1_0.VSS.n2626 wind_comp_0.sg13g2_and2_2$1_0.VSS.n676 0.146155
R5407 wind_comp_0.sg13g2_and2_2$1_0.VSS.n2626 wind_comp_0.sg13g2_and2_2$1_0.VSS.n2625 0.146155
R5408 wind_comp_0.sg13g2_and2_2$1_0.VSS.n2625 wind_comp_0.sg13g2_and2_2$1_0.VSS.n2623 0.146155
R5409 wind_comp_0.sg13g2_and2_2$1_0.VSS.n2623 wind_comp_0.sg13g2_and2_2$1_0.VSS.n2621 0.146155
R5410 wind_comp_0.sg13g2_and2_2$1_0.VSS.n2615 wind_comp_0.sg13g2_and2_2$1_0.VSS.n2596 0.146155
R5411 wind_comp_0.comparator_0.dynamic_pcell$2_0.SRC_NET_MNO wind_comp_0.sg13g2_and2_2$1_0.VSS.n2596 0.146155
R5412 wind_comp_0.sg13g2_and2_2$1_0.VSS.n2606 wind_comp_0.comparator_0.dynamic_pcell$2_0.SRC_NET_MNO 0.146155
R5413 wind_comp_0.sg13g2_and2_2$1_0.VSS.n2608 wind_comp_0.sg13g2_and2_2$1_0.VSS.n2606 0.146155
R5414 wind_comp_0.sg13g2_and2_2$1_0.VSS.n2610 wind_comp_0.sg13g2_and2_2$1_0.VSS.n2608 0.146155
R5415 wind_comp_0.sg13g2_and2_2$1_0.VSS.n2611 wind_comp_0.sg13g2_and2_2$1_0.VSS.n2610 0.146155
R5416 wind_comp_0.sg13g2_and2_2$1_0.VSS.n2612 wind_comp_0.sg13g2_and2_2$1_0.VSS.n2611 0.146155
R5417 wind_comp_0.sg13g2_and2_2$1_0.VSS.n2125 wind_comp_0.sg13g2_and2_2$1_0.VSS.n2121 0.146155
R5418 wind_comp_0.comparator_0.dynamic_pcell$2_0.SRC_NET_MNO wind_comp_0.sg13g2_and2_2$1_0.VSS.n2121 0.146155
R5419 wind_comp_0.sg13g2_and2_2$1_0.VSS.n2574 wind_comp_0.sg13g2_and2_2$1_0.VSS.n2570 0.146155
R5420 wind_comp_0.comparator_0.dynamic_pcell$2_0.SRC_NET_MNO wind_comp_0.sg13g2_and2_2$1_0.VSS.n2570 0.146155
R5421 wind_comp_0.sg13g2_and2_2$1_0.VSS.n2288 wind_comp_0.sg13g2_and2_2$1_0.VSS.n2284 0.146155
R5422 wind_comp_0.comparator_1.dynamic_pcell$2_0.SRC_NET_MNO wind_comp_0.sg13g2_and2_2$1_0.VSS.n2284 0.146155
R5423 wind_comp_0.sg13g2_and2_2$1_0.VSS.n2256 wind_comp_0.sg13g2_and2_2$1_0.VSS.n2237 0.146155
R5424 wind_comp_0.comparator_1.dynamic_pcell$2_0.SRC_NET_MNO wind_comp_0.sg13g2_and2_2$1_0.VSS.n2237 0.146155
R5425 wind_comp_0.sg13g2_and2_2$1_0.VSS.n2247 wind_comp_0.comparator_1.dynamic_pcell$2_0.SRC_NET_MNO 0.146155
R5426 wind_comp_0.sg13g2_and2_2$1_0.VSS.n2249 wind_comp_0.sg13g2_and2_2$1_0.VSS.n2247 0.146155
R5427 wind_comp_0.sg13g2_and2_2$1_0.VSS.n2251 wind_comp_0.sg13g2_and2_2$1_0.VSS.n2249 0.146155
R5428 wind_comp_0.sg13g2_and2_2$1_0.VSS.n2252 wind_comp_0.sg13g2_and2_2$1_0.VSS.n2251 0.146155
R5429 wind_comp_0.sg13g2_and2_2$1_0.VSS.n2253 wind_comp_0.sg13g2_and2_2$1_0.VSS.n2252 0.146155
R5430 wind_comp_0.sg13g2_and2_2$1_0.VSS.n2277 wind_comp_0.sg13g2_and2_2$1_0.VSS.n2258 0.146155
R5431 wind_comp_0.comparator_1.dynamic_pcell$2_0.SRC_NET_MNO wind_comp_0.sg13g2_and2_2$1_0.VSS.n2258 0.146155
R5432 wind_comp_0.sg13g2_and2_2$1_0.VSS.n2268 wind_comp_0.comparator_1.dynamic_pcell$2_0.SRC_NET_MNO 0.146155
R5433 wind_comp_0.sg13g2_and2_2$1_0.VSS.n2270 wind_comp_0.sg13g2_and2_2$1_0.VSS.n2268 0.146155
R5434 wind_comp_0.sg13g2_and2_2$1_0.VSS.n2272 wind_comp_0.sg13g2_and2_2$1_0.VSS.n2270 0.146155
R5435 wind_comp_0.sg13g2_and2_2$1_0.VSS.n2273 wind_comp_0.sg13g2_and2_2$1_0.VSS.n2272 0.146155
R5436 wind_comp_0.sg13g2_and2_2$1_0.VSS.n2274 wind_comp_0.sg13g2_and2_2$1_0.VSS.n2273 0.146155
R5437 wind_comp_0.sg13g2_and2_2$1_0.VSS.n2282 wind_comp_0.sg13g2_and2_2$1_0.VSS.n2278 0.146155
R5438 wind_comp_0.comparator_1.dynamic_pcell$2_0.SRC_NET_MNO wind_comp_0.sg13g2_and2_2$1_0.VSS.n2278 0.146155
R5439 wind_comp_0.sg13g2_and2_2$1_0.VSS.n2617 wind_comp_0.sg13g2_and2_2$1_0.VSS.n679 0.14496
R5440 wind_comp_0.sg13g2_and2_2$1_0.VSS.n2622 wind_comp_0.sg13g2_and2_2$1_0.VSS.n2620 0.14496
R5441 wind_comp_0.sg13g2_and2_2$1_0.VSS.n2614 wind_comp_0.sg13g2_and2_2$1_0.VSS.n2597 0.14496
R5442 wind_comp_0.sg13g2_and2_2$1_0.VSS.n2613 wind_comp_0.sg13g2_and2_2$1_0.VSS.n2603 0.14496
R5443 wind_comp_0.sg13g2_and2_2$1_0.VSS.n2124 wind_comp_0.sg13g2_and2_2$1_0.VSS.n2122 0.14496
R5444 wind_comp_0.sg13g2_and2_2$1_0.VSS.n2573 wind_comp_0.sg13g2_and2_2$1_0.VSS.n2571 0.14496
R5445 wind_comp_0.sg13g2_and2_2$1_0.VSS.n2287 wind_comp_0.sg13g2_and2_2$1_0.VSS.n2285 0.14496
R5446 wind_comp_0.sg13g2_and2_2$1_0.VSS.n2255 wind_comp_0.sg13g2_and2_2$1_0.VSS.n2238 0.14496
R5447 wind_comp_0.sg13g2_and2_2$1_0.VSS.n2254 wind_comp_0.sg13g2_and2_2$1_0.VSS.n2244 0.14496
R5448 wind_comp_0.sg13g2_and2_2$1_0.VSS.n2276 wind_comp_0.sg13g2_and2_2$1_0.VSS.n2259 0.14496
R5449 wind_comp_0.sg13g2_and2_2$1_0.VSS.n2275 wind_comp_0.sg13g2_and2_2$1_0.VSS.n2265 0.14496
R5450 wind_comp_0.sg13g2_and2_2$1_0.VSS.n2281 wind_comp_0.sg13g2_and2_2$1_0.VSS.n2279 0.14496
R5451 wind_comp_0.sg13g2_and2_2$1_0.VSS.n2525 wind_comp_0.sg13g2_and2_2$1_0.VSS.n1704 0.144155
R5452 wind_comp_0.sg13g2_and2_2$1_0.VSS.n103 wind_comp_0.sg13g2_and2_2$1_0.VSS.n1611 0.146905
R5453 wind_comp_0.sg13g2_and2_2$1_0.VSS.n1244 wind_comp_0.sg13g2_and2_2$1_0.VSS.n702 0.135632
R5454 wind_comp_0.sg13g2_and2_2$1_0.VSS.n1576 wind_comp_0.sg13g2_and2_2$1_0.VSS.n1575 0.135279
R5455 wind_comp_0.sg13g2_and2_2$1_0.VSS.n2565 wind_comp_0.sg13g2_and2_2$1_0.VSS.n2564 0.13494
R5456 wind_comp_0.sg13g2_and2_2$1_0.VSS.n2631 wind_comp_0.sg13g2_and2_2$1_0.VSS.n678 0.133259
R5457 wind_comp_0.sg13g2_and2_2$1_0.VSS.n2624 wind_comp_0.sg13g2_and2_2$1_0.VSS.n2618 0.133259
R5458 wind_comp_0.sg13g2_and2_2$1_0.VSS.n2604 wind_comp_0.sg13g2_and2_2$1_0.VSS.n2599 0.133259
R5459 wind_comp_0.sg13g2_and2_2$1_0.VSS.n2609 wind_comp_0.sg13g2_and2_2$1_0.VSS.n2601 0.133259
R5460 wind_comp_0.sg13g2_and2_2$1_0.VSS.n2245 wind_comp_0.sg13g2_and2_2$1_0.VSS.n2240 0.133259
R5461 wind_comp_0.sg13g2_and2_2$1_0.VSS.n2250 wind_comp_0.sg13g2_and2_2$1_0.VSS.n2242 0.133259
R5462 wind_comp_0.sg13g2_and2_2$1_0.VSS.n2266 wind_comp_0.sg13g2_and2_2$1_0.VSS.n2261 0.133259
R5463 wind_comp_0.sg13g2_and2_2$1_0.VSS.n2271 wind_comp_0.sg13g2_and2_2$1_0.VSS.n2263 0.133259
R5464 wind_comp_0.sg13g2_and2_2$1_0.VSS.n362 wind_comp_0.sg13g2_and2_2$1_0.VSS.n1595 0.175041
R5465 wind_comp_0.sg13g2_and2_2$1_0.VSS.n249 wind_comp_0.sg13g2_and2_2$1_0.VSS.n244 0.124624
R5466 wind_comp_0.sg13g2_and2_2$1_0.VSS.n208 wind_comp_0.sg13g2_and2_2$1_0.VSS.n2566 0.160807
R5467 wind_comp_0.sg13g2_and2_2$1_0.VSS.n1537 wind_comp_0.sg13g2_and2_2$1_0.VSS.n123 1.03963
R5468 wind_comp_0.sg13g2_and2_2$1_0.VSS.n1717 wind_comp_0.sg13g2_and2_2$1_0.VSS.n1707 0.112109
R5469 wind_comp_0.sg13g2_and2_2$1_0.VSS.n1709 wind_comp_0.sg13g2_and2_2$1_0.VSS.n1707 0.112109
R5470 wind_comp_0.sg13g2_and2_2$1_0.VSS.n1704 wind_comp_0.sg13g2_and2_2$1_0.VSS.n1703 0.112109
R5471 wind_comp_0.sg13g2_and2_2$1_0.VSS.n1703 wind_comp_0.sg13g2_and2_2$1_0.VSS.n1702 0.112109
R5472 wind_comp_0.sg13g2_and2_2$1_0.VSS.n68 wind_comp_0.sg13g2_and2_2$1_0.VSS.n67 0.10905
R5473 wind_comp_0.sg13g2_and2_2$1_0.VSS.n249 wind_comp_0.sg13g2_and2_2$1_0.VSS.n247 0.108766
R5474 wind_comp_0.sg13g2_and2_2$1_0.VSS.t395 wind_comp_0.sg13g2_and2_2$1_0.VSS.t403 0.107758
R5475 wind_comp_0.sg13g2_and2_2$1_0.VSS.n605 wind_comp_0.sg13g2_and2_2$1_0.VSS.t394 0.107758
R5476 wind_comp_0.sg13g2_and2_2$1_0.VSS.t405 wind_comp_0.sg13g2_and2_2$1_0.VSS.t397 0.107758
R5477 wind_comp_0.sg13g2_and2_2$1_0.VSS.n201 wind_comp_0.sg13g2_and2_2$1_0.VSS.n118 0.0661242
R5478 wind_comp_0.sg13g2_and2_2$1_0.VSS.n201 wind_comp_0.sg13g2_and2_2$1_0.VSS.n185 0.106358
R5479 wind_comp_0.sg13g2_and2_2$1_0.VSS.n201 wind_comp_0.sg13g2_and2_2$1_0.VSS.n200 0.105772
R5480 wind_comp_0.sg13g2_and2_2$1_0.VSS.n19 wind_comp_0.comparator_1.dynamic_pcell$1_0.VSS 1.43221
R5481 wind_comp_0.sg13g2_and2_2$1_0.VSS.n2630 wind_comp_0.sg13g2_and2_2$1_0.VSS.n679 0.105022
R5482 wind_comp_0.sg13g2_and2_2$1_0.VSS.n2622 wind_comp_0.sg13g2_and2_2$1_0.VSS.n2619 0.105022
R5483 wind_comp_0.sg13g2_and2_2$1_0.VSS.n2598 wind_comp_0.sg13g2_and2_2$1_0.VSS.n2597 0.105022
R5484 wind_comp_0.sg13g2_and2_2$1_0.VSS.n2603 wind_comp_0.sg13g2_and2_2$1_0.VSS.n2602 0.105022
R5485 wind_comp_0.sg13g2_and2_2$1_0.VSS.n2239 wind_comp_0.sg13g2_and2_2$1_0.VSS.n2238 0.105022
R5486 wind_comp_0.sg13g2_and2_2$1_0.VSS.n2244 wind_comp_0.sg13g2_and2_2$1_0.VSS.n2243 0.105022
R5487 wind_comp_0.sg13g2_and2_2$1_0.VSS.n2260 wind_comp_0.sg13g2_and2_2$1_0.VSS.n2259 0.105022
R5488 wind_comp_0.sg13g2_and2_2$1_0.VSS.n2265 wind_comp_0.sg13g2_and2_2$1_0.VSS.n2264 0.105022
R5489 wind_comp_0.sg13g2_and2_2$1_0.VSS.n1204 wind_comp_0.sg13g2_and2_2$1_0.VSS.t285 0.104465
R5490 wind_comp_0.sg13g2_and2_2$1_0.VSS.n124 wind_comp_0.sg13g2_and2_2$1_0.VSS.n214 5.87156
R5491 wind_comp_0.sg13g2_and2_2$1_0.VSS.n1709 wind_comp_0.sg13g2_and2_2$1_0.VSS.n1706 0.0971218
R5492 wind_comp_0.sg13g2_and2_2$1_0.VSS.n2524 wind_comp_0.sg13g2_and2_2$1_0.VSS.n2523 0.094
R5493 wind_comp_0.sg13g2_and2_2$1_0.VSS.n2629 wind_comp_0.sg13g2_and2_2$1_0.VSS.n2628 0.0915345
R5494 wind_comp_0.sg13g2_and2_2$1_0.VSS.n2629 wind_comp_0.sg13g2_and2_2$1_0.VSS.n2627 0.0915345
R5495 wind_comp_0.sg13g2_and2_2$1_0.VSS.n2605 wind_comp_0.sg13g2_and2_2$1_0.VSS.n2600 0.0915345
R5496 wind_comp_0.sg13g2_and2_2$1_0.VSS.n2607 wind_comp_0.sg13g2_and2_2$1_0.VSS.n2600 0.0915345
R5497 wind_comp_0.sg13g2_and2_2$1_0.VSS.n2246 wind_comp_0.sg13g2_and2_2$1_0.VSS.n2241 0.0915345
R5498 wind_comp_0.sg13g2_and2_2$1_0.VSS.n2248 wind_comp_0.sg13g2_and2_2$1_0.VSS.n2241 0.0915345
R5499 wind_comp_0.sg13g2_and2_2$1_0.VSS.n2267 wind_comp_0.sg13g2_and2_2$1_0.VSS.n2262 0.0915345
R5500 wind_comp_0.sg13g2_and2_2$1_0.VSS.n2269 wind_comp_0.sg13g2_and2_2$1_0.VSS.n2262 0.0915345
R5501 wind_comp_0.sg13g2_and2_2$1_0.VSS.n2523 wind_comp_0.sg13g2_and2_2$1_0.VSS.n1705 0.08575
R5502 wind_comp_0.sg13g2_and2_2$1_0.VSS.n1354 wind_comp_0.sg13g2_and2_2$1_0.VSS.n246 0.084375
R5503 wind_comp_0.sg13g2_and2_2$1_0.VSS.n2631 wind_comp_0.sg13g2_and2_2$1_0.VSS.n2630 0.0784702
R5504 wind_comp_0.sg13g2_and2_2$1_0.VSS.n2624 wind_comp_0.sg13g2_and2_2$1_0.VSS.n2619 0.0784702
R5505 wind_comp_0.sg13g2_and2_2$1_0.VSS.n2604 wind_comp_0.sg13g2_and2_2$1_0.VSS.n2598 0.0784702
R5506 wind_comp_0.sg13g2_and2_2$1_0.VSS.n2609 wind_comp_0.sg13g2_and2_2$1_0.VSS.n2602 0.0784702
R5507 wind_comp_0.sg13g2_and2_2$1_0.VSS.n2245 wind_comp_0.sg13g2_and2_2$1_0.VSS.n2239 0.0784702
R5508 wind_comp_0.sg13g2_and2_2$1_0.VSS.n2250 wind_comp_0.sg13g2_and2_2$1_0.VSS.n2243 0.0784702
R5509 wind_comp_0.sg13g2_and2_2$1_0.VSS.n2266 wind_comp_0.sg13g2_and2_2$1_0.VSS.n2260 0.0784702
R5510 wind_comp_0.sg13g2_and2_2$1_0.VSS.n2271 wind_comp_0.sg13g2_and2_2$1_0.VSS.n2264 0.0784702
R5511 wind_comp_0.sg13g2_and2_2$1_0.VSS.n1336 wind_comp_0.sg13g2_and2_2$1_0.VSS.n249 0.0764968
R5512 wind_comp_0.sg13g2_and2_2$1_0.VSS.n1332 wind_comp_0.sg13g2_and2_2$1_0.VSS.n1331 0.0738333
R5513 wind_comp_0.sg13g2_and2_2$1_0.VSS.n1326 wind_comp_0.sg13g2_and2_2$1_0.VSS.n1325 0.0738333
R5514 wind_comp_0.sg13g2_and2_2$1_0.VSS.n1335 wind_comp_0.sg13g2_and2_2$1_0.VSS.n1334 0.072
R5515 wind_comp_0.sg13g2_and2_2$1_0.VSS.n1316 wind_comp_0.sg13g2_and2_2$1_0.VSS.n1315 0.072
R5516 wind_comp_0.sg13g2_and2_2$1_0.VSS.n2576 wind_comp_0.sg13g2_and2_2$1_0.VSS.n671 0.0718205
R5517 wind_comp_0.sg13g2_and2_2$1_0.VSS.n2576 wind_comp_0.comparator_0.sg13cmos5l_inv_16_1.VSS 0.0707861
R5518 wind_comp_0.sg13g2_and2_2$1_0.VSS.n1334 wind_comp_0.sg13g2_and2_2$1_0.VSS.n1333 0.0696218
R5519 wind_comp_0.sg13g2_and2_2$1_0.VSS.n1317 wind_comp_0.sg13g2_and2_2$1_0.VSS.n1316 0.0696218
R5520 wind_comp_0.sg13g2_and2_2$1_0.VSS.n1320 wind_comp_0.sg13g2_and2_2$1_0.VSS.n1319 0.067875
R5521 wind_comp_0.sg13g2_and2_2$1_0.VSS.n1319 wind_comp_0.sg13g2_and2_2$1_0.VSS.n1318 0.067875
R5522 wind_comp_0.sg13g2_and2_2$1_0.VSS.n45 wind_comp_0.sg13g2_and2_2$1_0.VSS.n782 0.931973
R5523 wind_comp_0.sg13g2_and2_2$1_0.VSS.n1353 wind_comp_0.sg13g2_and2_2$1_0.VSS.n1352 0.0665
R5524 wind_comp_0.sg13g2_and2_2$1_0.VSS.n1333 wind_comp_0.sg13g2_and2_2$1_0.VSS.n1332 0.0558718
R5525 wind_comp_0.sg13g2_and2_2$1_0.VSS.n1326 wind_comp_0.sg13g2_and2_2$1_0.VSS.n1317 0.0558718
R5526 wind_comp_0.sg13g2_and2_2$1_0.VSS.n1706 wind_comp_0.sg13g2_and2_2$1_0.VSS.n1705 0.0558718
R5527 wind_comp_0.sg13g2_and2_2$1_0.VSS.n249 wind_comp_0.sg13g2_and2_2$1_0.VSS.n125 1.4274
R5528 wind_comp_0.sg13g2_and2_2$1_0.VSS.n2567 wind_comp_0.sg13g2_and2_2$1_0.VSS.n1306 0.0529856
R5529 wind_comp_0.sg13g2_and2_2$1_0.VSS.n1335 wind_comp_0.sg13g2_and2_2$1_0.VSS.n248 0.05275
R5530 wind_comp_0.sg13g2_and2_2$1_0.VSS.n1315 wind_comp_0.sg13g2_and2_2$1_0.VSS.n1312 0.05275
R5531 wind_comp_0.sg13g2_and2_2$1_0.VSS.n1595 wind_comp_0.sg13g2_and2_2$1_0.VSS.n1589 0.0523661
R5532 wind_comp_0.sg13g2_and2_2$1_0.VSS.n362 wind_comp_0.sg13g2_and2_2$1_0.VSS.n1598 0.174907
R5533 wind_comp_0.sg13g2_and2_2$1_0.VSS.n1702 wind_comp_0.sg13g2_and2_2$1_0.VSS.n103 0.143817
R5534 wind_comp_0.sg13g2_and2_2$1_0.VSS.n2628 wind_comp_0.sg13g2_and2_2$1_0.VSS.n678 0.0498103
R5535 wind_comp_0.sg13g2_and2_2$1_0.VSS.n2627 wind_comp_0.sg13g2_and2_2$1_0.VSS.n2618 0.0498103
R5536 wind_comp_0.sg13g2_and2_2$1_0.VSS.n2605 wind_comp_0.sg13g2_and2_2$1_0.VSS.n2599 0.0498103
R5537 wind_comp_0.sg13g2_and2_2$1_0.VSS.n2607 wind_comp_0.sg13g2_and2_2$1_0.VSS.n2601 0.0498103
R5538 wind_comp_0.sg13g2_and2_2$1_0.VSS.n2246 wind_comp_0.sg13g2_and2_2$1_0.VSS.n2240 0.0498103
R5539 wind_comp_0.sg13g2_and2_2$1_0.VSS.n2248 wind_comp_0.sg13g2_and2_2$1_0.VSS.n2242 0.0498103
R5540 wind_comp_0.sg13g2_and2_2$1_0.VSS.n2267 wind_comp_0.sg13g2_and2_2$1_0.VSS.n2261 0.0498103
R5541 wind_comp_0.sg13g2_and2_2$1_0.VSS.n2269 wind_comp_0.sg13g2_and2_2$1_0.VSS.n2263 0.0498103
R5542 wind_comp_0.sg13g2_and2_2$1_0.VSS.n1338 wind_comp_0.sg13g2_and2_2$1_0.VSS.n1336 0.0489968
R5543 wind_comp_0.sg13g2_and2_2$1_0.VSS.n1610 wind_comp_0.sg13g2_and2_2$1_0.VSS.n880 0.046488
R5544 wind_comp_0.sg13g2_and2_2$1_0.VSS.n888 wind_comp_0.sg13g2_and2_2$1_0.VSS.n880 0.0462173
R5545 wind_comp_0.sg13g2_and2_2$1_0.VSS.n1253 wind_comp_0.sg13g2_and2_2$1_0.VSS.n720 0.046029
R5546 wind_comp_0.sg13g2_and2_2$1_0.VSS.n1836 wind_comp_0.sg13g2_and2_2$1_0.VSS.n1758 0.046029
R5547 wind_comp_0.sg13g2_and2_2$1_0.VSS.n1593 wind_comp_0.sg13g2_and2_2$1_0.VSS.n1595 0.0459273
R5548 wind_comp_0.sg13g2_and2_2$1_0.VSS.n2567 wind_comp_0.sg13g2_and2_2$1_0.VSS.n1293 0.0449835
R5549 wind_comp_0.sg13g2_and2_2$1_0.VSS.n1352 wind_comp_0.sg13g2_and2_2$1_0.VSS.n1340 0.0445
R5550 wind_comp_0.sg13g2_and2_2$1_0.VSS.n1518 wind_comp_0.sg13g2_and2_2$1_0.VSS.n1293 0.0422257
R5551 wind_comp_0.sg13g2_and2_2$1_0.VSS.n1652 wind_comp_0.sg13g2_and2_2$1_0.VSS.n1593 0.0412808
R5552 wind_comp_0.sg13g2_and2_2$1_0.VSS.n1338 wind_comp_0.sg13g2_and2_2$1_0.VSS.n1337 0.0398918
R5553 wind_comp_0.sg13g2_and2_2$1_0.VSS.n1375 wind_comp_0.sg13g2_and2_2$1_0.VSS.n244 0.0365054
R5554 wind_comp_0.sg13g2_and2_2$1_0.VSS.n1352 wind_comp_0.sg13g2_and2_2$1_0.VSS.n247 0.0361562
R5555 wind_comp_0.sg13g2_and2_2$1_0.VSS.n1312 wind_comp_0.sg13g2_and2_2$1_0.VSS.n1311 0.0351457
R5556 wind_comp_0.sg13g2_and2_2$1_0.VSS.n1611 wind_comp_0.sg13g2_and2_2$1_0.VSS.n1610 0.0351457
R5557 wind_comp_0.sg13g2_and2_2$1_0.VSS.n1235 wind_comp_0.sg13g2_and2_2$1_0.VSS.n721 0.0340238
R5558 wind_comp_0.sg13g2_and2_2$1_0.VSS.n1254 wind_comp_0.sg13g2_and2_2$1_0.VSS.n722 0.0340238
R5559 wind_comp_0.sg13g2_and2_2$1_0.VSS.n1234 wind_comp_0.sg13g2_and2_2$1_0.VSS.n723 0.0340238
R5560 wind_comp_0.sg13g2_and2_2$1_0.VSS.n1255 wind_comp_0.sg13g2_and2_2$1_0.VSS.n724 0.0340238
R5561 wind_comp_0.sg13g2_and2_2$1_0.VSS.n1233 wind_comp_0.sg13g2_and2_2$1_0.VSS.n725 0.0340238
R5562 wind_comp_0.sg13g2_and2_2$1_0.VSS.n1256 wind_comp_0.sg13g2_and2_2$1_0.VSS.n726 0.0340238
R5563 wind_comp_0.sg13g2_and2_2$1_0.VSS.n1232 wind_comp_0.sg13g2_and2_2$1_0.VSS.n727 0.0340238
R5564 wind_comp_0.sg13g2_and2_2$1_0.VSS.n1257 wind_comp_0.sg13g2_and2_2$1_0.VSS.n728 0.0340238
R5565 wind_comp_0.sg13g2_and2_2$1_0.VSS.n1231 wind_comp_0.sg13g2_and2_2$1_0.VSS.n729 0.0340238
R5566 wind_comp_0.sg13g2_and2_2$1_0.VSS.n1258 wind_comp_0.sg13g2_and2_2$1_0.VSS.n730 0.0340238
R5567 wind_comp_0.sg13g2_and2_2$1_0.VSS.n1230 wind_comp_0.sg13g2_and2_2$1_0.VSS.n731 0.0340238
R5568 wind_comp_0.sg13g2_and2_2$1_0.VSS.n1847 wind_comp_0.sg13g2_and2_2$1_0.VSS.n1815 0.0340238
R5569 wind_comp_0.sg13g2_and2_2$1_0.VSS.n1846 wind_comp_0.sg13g2_and2_2$1_0.VSS.n1753 0.0340238
R5570 wind_comp_0.sg13g2_and2_2$1_0.VSS.n1845 wind_comp_0.sg13g2_and2_2$1_0.VSS.n1814 0.0340238
R5571 wind_comp_0.sg13g2_and2_2$1_0.VSS.n1844 wind_comp_0.sg13g2_and2_2$1_0.VSS.n1754 0.0340238
R5572 wind_comp_0.sg13g2_and2_2$1_0.VSS.n1843 wind_comp_0.sg13g2_and2_2$1_0.VSS.n1813 0.0340238
R5573 wind_comp_0.sg13g2_and2_2$1_0.VSS.n1842 wind_comp_0.sg13g2_and2_2$1_0.VSS.n1755 0.0340238
R5574 wind_comp_0.sg13g2_and2_2$1_0.VSS.n1841 wind_comp_0.sg13g2_and2_2$1_0.VSS.n1812 0.0340238
R5575 wind_comp_0.sg13g2_and2_2$1_0.VSS.n1840 wind_comp_0.sg13g2_and2_2$1_0.VSS.n1756 0.0340238
R5576 wind_comp_0.sg13g2_and2_2$1_0.VSS.n1839 wind_comp_0.sg13g2_and2_2$1_0.VSS.n1811 0.0340238
R5577 wind_comp_0.sg13g2_and2_2$1_0.VSS.n1838 wind_comp_0.sg13g2_and2_2$1_0.VSS.n1757 0.0340238
R5578 wind_comp_0.sg13g2_and2_2$1_0.VSS.n1837 wind_comp_0.sg13g2_and2_2$1_0.VSS.n1810 0.0340238
R5579 wind_comp_0.sg13g2_and2_2$1_0.VSS.n1776 wind_comp_0.sg13g2_and2_2$1_0.VSS.n1727 0.0315669
R5580 wind_comp_0.sg13g2_and2_2$1_0.VSS.n1975 wind_comp_0.sg13g2_and2_2$1_0.VSS.n158 0.0311159
R5581 wind_comp_0.sg13g2_and2_2$1_0.VSS.n249 wind_comp_0.sg13g2_and2_2$1_0.VSS.n245 0.0305228
R5582 wind_comp_0.sg13g2_and2_2$1_0.VSS.n159 wind_comp_0.sg13g2_and2_2$1_0.VSS.n158 0.0302645
R5583 wind_comp_0.sg13g2_and2_2$1_0.VSS.n1244 wind_comp_0.sg13g2_and2_2$1_0.VSS.n703 0.0277381
R5584 wind_comp_0.sg13g2_and2_2$1_0.VSS.n1245 wind_comp_0.sg13g2_and2_2$1_0.VSS.n704 0.0277381
R5585 wind_comp_0.sg13g2_and2_2$1_0.VSS.n1243 wind_comp_0.sg13g2_and2_2$1_0.VSS.n705 0.0277381
R5586 wind_comp_0.sg13g2_and2_2$1_0.VSS.n1246 wind_comp_0.sg13g2_and2_2$1_0.VSS.n706 0.0277381
R5587 wind_comp_0.sg13g2_and2_2$1_0.VSS.n1242 wind_comp_0.sg13g2_and2_2$1_0.VSS.n707 0.0277381
R5588 wind_comp_0.sg13g2_and2_2$1_0.VSS.n1247 wind_comp_0.sg13g2_and2_2$1_0.VSS.n708 0.0277381
R5589 wind_comp_0.sg13g2_and2_2$1_0.VSS.n1241 wind_comp_0.sg13g2_and2_2$1_0.VSS.n709 0.0277381
R5590 wind_comp_0.sg13g2_and2_2$1_0.VSS.n1248 wind_comp_0.sg13g2_and2_2$1_0.VSS.n710 0.0277381
R5591 wind_comp_0.sg13g2_and2_2$1_0.VSS.n1240 wind_comp_0.sg13g2_and2_2$1_0.VSS.n711 0.0277381
R5592 wind_comp_0.sg13g2_and2_2$1_0.VSS.n1249 wind_comp_0.sg13g2_and2_2$1_0.VSS.n712 0.0277381
R5593 wind_comp_0.sg13g2_and2_2$1_0.VSS.n1239 wind_comp_0.sg13g2_and2_2$1_0.VSS.n713 0.0277381
R5594 wind_comp_0.sg13g2_and2_2$1_0.VSS.n1250 wind_comp_0.sg13g2_and2_2$1_0.VSS.n714 0.0277381
R5595 wind_comp_0.sg13g2_and2_2$1_0.VSS.n1238 wind_comp_0.sg13g2_and2_2$1_0.VSS.n715 0.0277381
R5596 wind_comp_0.sg13g2_and2_2$1_0.VSS.n1251 wind_comp_0.sg13g2_and2_2$1_0.VSS.n716 0.0277381
R5597 wind_comp_0.sg13g2_and2_2$1_0.VSS.n1237 wind_comp_0.sg13g2_and2_2$1_0.VSS.n717 0.0277381
R5598 wind_comp_0.sg13g2_and2_2$1_0.VSS.n1252 wind_comp_0.sg13g2_and2_2$1_0.VSS.n718 0.0277381
R5599 wind_comp_0.sg13g2_and2_2$1_0.VSS.n1236 wind_comp_0.sg13g2_and2_2$1_0.VSS.n719 0.0277381
R5600 wind_comp_0.sg13g2_and2_2$1_0.VSS.n1835 wind_comp_0.sg13g2_and2_2$1_0.VSS.n1759 0.0277381
R5601 wind_comp_0.sg13g2_and2_2$1_0.VSS.n1834 wind_comp_0.sg13g2_and2_2$1_0.VSS.n1809 0.0277381
R5602 wind_comp_0.sg13g2_and2_2$1_0.VSS.n1833 wind_comp_0.sg13g2_and2_2$1_0.VSS.n1760 0.0277381
R5603 wind_comp_0.sg13g2_and2_2$1_0.VSS.n1832 wind_comp_0.sg13g2_and2_2$1_0.VSS.n1808 0.0277381
R5604 wind_comp_0.sg13g2_and2_2$1_0.VSS.n1831 wind_comp_0.sg13g2_and2_2$1_0.VSS.n1761 0.0277381
R5605 wind_comp_0.sg13g2_and2_2$1_0.VSS.n1830 wind_comp_0.sg13g2_and2_2$1_0.VSS.n1807 0.0277381
R5606 wind_comp_0.sg13g2_and2_2$1_0.VSS.n1829 wind_comp_0.sg13g2_and2_2$1_0.VSS.n1762 0.0277381
R5607 wind_comp_0.sg13g2_and2_2$1_0.VSS.n1828 wind_comp_0.sg13g2_and2_2$1_0.VSS.n1806 0.0277381
R5608 wind_comp_0.sg13g2_and2_2$1_0.VSS.n1827 wind_comp_0.sg13g2_and2_2$1_0.VSS.n1763 0.0277381
R5609 wind_comp_0.sg13g2_and2_2$1_0.VSS.n1826 wind_comp_0.sg13g2_and2_2$1_0.VSS.n1805 0.0277381
R5610 wind_comp_0.sg13g2_and2_2$1_0.VSS.n1825 wind_comp_0.sg13g2_and2_2$1_0.VSS.n1764 0.0277381
R5611 wind_comp_0.sg13g2_and2_2$1_0.VSS.n1824 wind_comp_0.sg13g2_and2_2$1_0.VSS.n1804 0.0277381
R5612 wind_comp_0.sg13g2_and2_2$1_0.VSS.n1823 wind_comp_0.sg13g2_and2_2$1_0.VSS.n1765 0.0277381
R5613 wind_comp_0.sg13g2_and2_2$1_0.VSS.n1822 wind_comp_0.sg13g2_and2_2$1_0.VSS.n1803 0.0277381
R5614 wind_comp_0.sg13g2_and2_2$1_0.VSS.n1821 wind_comp_0.sg13g2_and2_2$1_0.VSS.n1766 0.0277381
R5615 wind_comp_0.sg13g2_and2_2$1_0.VSS.n1820 wind_comp_0.sg13g2_and2_2$1_0.VSS.n1802 0.0277381
R5616 wind_comp_0.sg13g2_and2_2$1_0.VSS.n1338 wind_comp_0.sg13g2_and2_2$1_0.VSS.n247 0.0273671
R5617 wind_comp_0.sg13g2_and2_2$1_0.VSS.n1644 wind_comp_0.sg13g2_and2_2$1_0.VSS.n1643 0.0237741
R5618 wind_comp_0.sg13g2_and2_2$1_0.VSS.n1513 wind_comp_0.sg13g2_and2_2$1_0.VSS.n1409 0.0237741
R5619 wind_comp_0.sg13g2_and2_2$1_0.VSS.n1776 wind_comp_0.sg13g2_and2_2$1_0.VSS.n1746 0.0230727
R5620 wind_comp_0.sg13g2_and2_2$1_0.VSS.n2233 wind_comp_0.sg13g2_and2_2$1_0.VSS.n876 0.0222008
R5621 wind_comp_0.sg13g2_and2_2$1_0.VSS.n1410 wind_comp_0.sg13g2_and2_2$1_0.VSS.n1409 0.0220949
R5622 wind_comp_0.sg13g2_and2_2$1_0.VSS.n1645 wind_comp_0.sg13g2_and2_2$1_0.VSS.n1644 0.0220949
R5623 wind_comp_0.sg13g2_and2_2$1_0.VSS.n1468 wind_comp_0.sg13g2_and2_2$1_0.VSS.n1467 0.0217714
R5624 wind_comp_0.sg13g2_and2_2$1_0.VSS.n1428 wind_comp_0.sg13g2_and2_2$1_0.VSS.n1425 0.0217714
R5625 wind_comp_0.sg13g2_and2_2$1_0.VSS.n1661 wind_comp_0.sg13g2_and2_2$1_0.VSS.n1636 0.0217714
R5626 wind_comp_0.sg13g2_and2_2$1_0.VSS.n1689 wind_comp_0.sg13g2_and2_2$1_0.VSS.n1688 0.0217714
R5627 wind_comp_0.sg13g2_and2_2$1_0.VSS.n1777 wind_comp_0.sg13g2_and2_2$1_0.VSS.n1746 0.0217355
R5628 wind_comp_0.sg13g2_and2_2$1_0.VSS.n1792 wind_comp_0.sg13g2_and2_2$1_0.VSS.n1726 0.0217355
R5629 wind_comp_0.sg13g2_and2_2$1_0.VSS.n1778 wind_comp_0.sg13g2_and2_2$1_0.VSS.n1747 0.0217355
R5630 wind_comp_0.sg13g2_and2_2$1_0.VSS.n1791 wind_comp_0.sg13g2_and2_2$1_0.VSS.n1725 0.0217355
R5631 wind_comp_0.sg13g2_and2_2$1_0.VSS.n1779 wind_comp_0.sg13g2_and2_2$1_0.VSS.n1748 0.0217355
R5632 wind_comp_0.sg13g2_and2_2$1_0.VSS.n1790 wind_comp_0.sg13g2_and2_2$1_0.VSS.n1724 0.0217355
R5633 wind_comp_0.sg13g2_and2_2$1_0.VSS.n1780 wind_comp_0.sg13g2_and2_2$1_0.VSS.n1749 0.0217355
R5634 wind_comp_0.sg13g2_and2_2$1_0.VSS.n1789 wind_comp_0.sg13g2_and2_2$1_0.VSS.n1723 0.0217355
R5635 wind_comp_0.sg13g2_and2_2$1_0.VSS.n1781 wind_comp_0.sg13g2_and2_2$1_0.VSS.n1750 0.0217355
R5636 wind_comp_0.sg13g2_and2_2$1_0.VSS.n1788 wind_comp_0.sg13g2_and2_2$1_0.VSS.n1722 0.0217355
R5637 wind_comp_0.sg13g2_and2_2$1_0.VSS.n1782 wind_comp_0.sg13g2_and2_2$1_0.VSS.n1751 0.0217355
R5638 wind_comp_0.sg13g2_and2_2$1_0.VSS.n1787 wind_comp_0.sg13g2_and2_2$1_0.VSS.n1721 0.0217355
R5639 wind_comp_0.sg13g2_and2_2$1_0.VSS.n1783 wind_comp_0.sg13g2_and2_2$1_0.VSS.n1752 0.0217355
R5640 wind_comp_0.sg13g2_and2_2$1_0.VSS.n2518 wind_comp_0.sg13g2_and2_2$1_0.VSS.n1720 0.0217355
R5641 wind_comp_0.sg13g2_and2_2$1_0.VSS.n2519 wind_comp_0.sg13g2_and2_2$1_0.VSS.n609 0.0217355
R5642 wind_comp_0.sg13g2_and2_2$1_0.VSS.n1579 wind_comp_0.sg13g2_and2_2$1_0.VSS.n1307 0.0214971
R5643 wind_comp_0.sg13g2_and2_2$1_0.VSS.n1464 wind_comp_0.sg13g2_and2_2$1_0.VSS.n1446 0.0214725
R5644 wind_comp_0.sg13g2_and2_2$1_0.VSS.n1496 wind_comp_0.sg13g2_and2_2$1_0.VSS.n1495 0.0214725
R5645 wind_comp_0.sg13g2_and2_2$1_0.VSS.n1665 wind_comp_0.sg13g2_and2_2$1_0.VSS.n1664 0.0214725
R5646 wind_comp_0.sg13g2_and2_2$1_0.VSS.n1623 wind_comp_0.sg13g2_and2_2$1_0.VSS.n1621 0.0214725
R5647 wind_comp_0.sg13g2_and2_2$1_0.VSS.n1784 wind_comp_0.sg13g2_and2_2$1_0.VSS.n876 0.0212623
R5648 wind_comp_0.sg13g2_and2_2$1_0.VSS.n1339 wind_comp_0.sg13g2_and2_2$1_0.VSS.n1338 0.021125
R5649 wind_comp_0.sg13g2_and2_2$1_0.VSS.n1235 wind_comp_0.sg13g2_and2_2$1_0.VSS.n720 0.0208861
R5650 wind_comp_0.sg13g2_and2_2$1_0.VSS.n1837 wind_comp_0.sg13g2_and2_2$1_0.VSS.n1758 0.0208861
R5651 wind_comp_0.sg13g2_and2_2$1_0.VSS.n1610 wind_comp_0.sg13g2_and2_2$1_0.VSS.n881 0.0200686
R5652 wind_comp_0.sg13g2_and2_2$1_0.VSS.n1472 wind_comp_0.sg13g2_and2_2$1_0.VSS.n1471 0.019978
R5653 wind_comp_0.sg13g2_and2_2$1_0.VSS.n1424 wind_comp_0.sg13g2_and2_2$1_0.VSS.n1421 0.019978
R5654 wind_comp_0.sg13g2_and2_2$1_0.VSS.n1638 wind_comp_0.sg13g2_and2_2$1_0.VSS.n1637 0.019978
R5655 wind_comp_0.sg13g2_and2_2$1_0.VSS.n1687 wind_comp_0.sg13g2_and2_2$1_0.VSS.n1685 0.019978
R5656 wind_comp_0.sg13g2_and2_2$1_0.VSS.n1450 wind_comp_0.sg13g2_and2_2$1_0.VSS.n1449 0.019679
R5657 wind_comp_0.sg13g2_and2_2$1_0.VSS.n1494 wind_comp_0.sg13g2_and2_2$1_0.VSS.n1491 0.019679
R5658 wind_comp_0.sg13g2_and2_2$1_0.VSS.n1670 wind_comp_0.sg13g2_and2_2$1_0.VSS.n1668 0.019679
R5659 wind_comp_0.sg13g2_and2_2$1_0.VSS.n1620 wind_comp_0.sg13g2_and2_2$1_0.VSS.n1618 0.019679
R5660 wind_comp_0.sg13g2_and2_2$1_0.VSS.n1352 wind_comp_0.sg13g2_and2_2$1_0.VSS.n1351 0.0194874
R5661 wind_comp_0.sg13g2_and2_2$1_0.VSS.n193 wind_comp_0.sg13g2_and2_2$1_0.VSS.n192 0.0183095
R5662 wind_comp_0.sg13g2_and2_2$1_0.VSS.n281 wind_comp_0.sg13g2_and2_2$1_0.VSS.n193 0.00396567
R5663 wind_comp_0.sg13g2_and2_2$1_0.VSS.n1476 wind_comp_0.sg13g2_and2_2$1_0.VSS.n1475 0.0181845
R5664 wind_comp_0.sg13g2_and2_2$1_0.VSS.n1420 wind_comp_0.sg13g2_and2_2$1_0.VSS.n1416 0.0181845
R5665 wind_comp_0.sg13g2_and2_2$1_0.VSS.n1641 wind_comp_0.sg13g2_and2_2$1_0.VSS.n1640 0.0181845
R5666 wind_comp_0.sg13g2_and2_2$1_0.VSS.n1684 wind_comp_0.sg13g2_and2_2$1_0.VSS.n1683 0.0181845
R5667 wind_comp_0.sg13g2_and2_2$1_0.VSS.n1454 wind_comp_0.sg13g2_and2_2$1_0.VSS.n1453 0.0178856
R5668 wind_comp_0.sg13g2_and2_2$1_0.VSS.n1617 wind_comp_0.sg13g2_and2_2$1_0.VSS.n1615 0.0178856
R5669 wind_comp_0.sg13g2_and2_2$1_0.VSS.n529 wind_comp_0.sg13g2_and2_2$1_0.VSS.n877 0.017295
R5670 wind_comp_0.sg13g2_and2_2$1_0.VSS.n452 wind_comp_0.sg13g2_and2_2$1_0.VSS.n893 0.017295
R5671 wind_comp_0.sg13g2_and2_2$1_0.VSS.n1465 wind_comp_0.sg13g2_and2_2$1_0.VSS.n1464 0.0170485
R5672 wind_comp_0.sg13g2_and2_2$1_0.VSS.n1495 wind_comp_0.sg13g2_and2_2$1_0.VSS.n1429 0.0170485
R5673 wind_comp_0.sg13g2_and2_2$1_0.VSS.n1662 wind_comp_0.sg13g2_and2_2$1_0.VSS.n1661 0.0167496
R5674 wind_comp_0.sg13g2_and2_2$1_0.VSS.n1688 wind_comp_0.sg13g2_and2_2$1_0.VSS.n1624 0.0167496
R5675 wind_comp_0.sg13g2_and2_2$1_0.VSS.n1664 wind_comp_0.sg13g2_and2_2$1_0.VSS.n1662 0.0167144
R5676 wind_comp_0.sg13g2_and2_2$1_0.VSS.n1624 wind_comp_0.sg13g2_and2_2$1_0.VSS.n1623 0.0167144
R5677 wind_comp_0.sg13g2_and2_2$1_0.VSS.n1768 wind_comp_0.sg13g2_and2_2$1_0.VSS.n1735 0.016639
R5678 wind_comp_0.sg13g2_and2_2$1_0.VSS.n1800 wind_comp_0.sg13g2_and2_2$1_0.VSS.n1738 0.016639
R5679 wind_comp_0.sg13g2_and2_2$1_0.VSS.n1769 wind_comp_0.sg13g2_and2_2$1_0.VSS.n1734 0.016639
R5680 wind_comp_0.sg13g2_and2_2$1_0.VSS.n1799 wind_comp_0.sg13g2_and2_2$1_0.VSS.n1739 0.016639
R5681 wind_comp_0.sg13g2_and2_2$1_0.VSS.n1770 wind_comp_0.sg13g2_and2_2$1_0.VSS.n1733 0.016639
R5682 wind_comp_0.sg13g2_and2_2$1_0.VSS.n1798 wind_comp_0.sg13g2_and2_2$1_0.VSS.n1740 0.016639
R5683 wind_comp_0.sg13g2_and2_2$1_0.VSS.n1771 wind_comp_0.sg13g2_and2_2$1_0.VSS.n1732 0.016639
R5684 wind_comp_0.sg13g2_and2_2$1_0.VSS.n1797 wind_comp_0.sg13g2_and2_2$1_0.VSS.n1741 0.016639
R5685 wind_comp_0.sg13g2_and2_2$1_0.VSS.n1772 wind_comp_0.sg13g2_and2_2$1_0.VSS.n1731 0.016639
R5686 wind_comp_0.sg13g2_and2_2$1_0.VSS.n1796 wind_comp_0.sg13g2_and2_2$1_0.VSS.n1742 0.016639
R5687 wind_comp_0.sg13g2_and2_2$1_0.VSS.n1773 wind_comp_0.sg13g2_and2_2$1_0.VSS.n1730 0.016639
R5688 wind_comp_0.sg13g2_and2_2$1_0.VSS.n1795 wind_comp_0.sg13g2_and2_2$1_0.VSS.n1743 0.016639
R5689 wind_comp_0.sg13g2_and2_2$1_0.VSS.n1774 wind_comp_0.sg13g2_and2_2$1_0.VSS.n1729 0.016639
R5690 wind_comp_0.sg13g2_and2_2$1_0.VSS.n1794 wind_comp_0.sg13g2_and2_2$1_0.VSS.n1744 0.016639
R5691 wind_comp_0.sg13g2_and2_2$1_0.VSS.n1775 wind_comp_0.sg13g2_and2_2$1_0.VSS.n1728 0.016639
R5692 wind_comp_0.sg13g2_and2_2$1_0.VSS.n1793 wind_comp_0.sg13g2_and2_2$1_0.VSS.n1745 0.016639
R5693 wind_comp_0.sg13g2_and2_2$1_0.VSS.n1786 wind_comp_0.sg13g2_and2_2$1_0.VSS.n1719 0.016639
R5694 wind_comp_0.sg13g2_and2_2$1_0.VSS.n1467 wind_comp_0.sg13g2_and2_2$1_0.VSS.n1465 0.0164155
R5695 wind_comp_0.sg13g2_and2_2$1_0.VSS.n1429 wind_comp_0.sg13g2_and2_2$1_0.VSS.n1428 0.0164155
R5696 wind_comp_0.sg13g2_and2_2$1_0.VSS.n1482 wind_comp_0.sg13g2_and2_2$1_0.VSS.n1478 0.016391
R5697 wind_comp_0.sg13g2_and2_2$1_0.VSS.n1415 wind_comp_0.sg13g2_and2_2$1_0.VSS.n1411 0.016391
R5698 wind_comp_0.sg13g2_and2_2$1_0.VSS.n1647 wind_comp_0.sg13g2_and2_2$1_0.VSS.n1646 0.016391
R5699 wind_comp_0.sg13g2_and2_2$1_0.VSS.n1682 wind_comp_0.sg13g2_and2_2$1_0.VSS.n1680 0.016391
R5700 wind_comp_0.sg13g2_and2_2$1_0.VSS.n2452 wind_comp_0.sg13g2_and2_2$1_0.VSS.n2340 0.0163797
R5701 wind_comp_0.sg13g2_and2_2$1_0.VSS.n2449 wind_comp_0.sg13g2_and2_2$1_0.VSS.n2340 0.0163797
R5702 wind_comp_0.sg13g2_and2_2$1_0.VSS.n2449 wind_comp_0.sg13g2_and2_2$1_0.VSS.n2448 0.0163797
R5703 wind_comp_0.sg13g2_and2_2$1_0.VSS.n2448 wind_comp_0.sg13g2_and2_2$1_0.VSS.n2447 0.0163797
R5704 wind_comp_0.sg13g2_and2_2$1_0.VSS.n2447 wind_comp_0.sg13g2_and2_2$1_0.VSS.n2343 0.0163797
R5705 wind_comp_0.sg13g2_and2_2$1_0.VSS.n2444 wind_comp_0.sg13g2_and2_2$1_0.VSS.n2343 0.0163797
R5706 wind_comp_0.sg13g2_and2_2$1_0.VSS.n2444 wind_comp_0.sg13g2_and2_2$1_0.VSS.n2443 0.0163797
R5707 wind_comp_0.sg13g2_and2_2$1_0.VSS.n2443 wind_comp_0.sg13g2_and2_2$1_0.VSS.n2441 0.0163797
R5708 wind_comp_0.sg13g2_and2_2$1_0.VSS.n2441 wind_comp_0.sg13g2_and2_2$1_0.VSS.n2347 0.0163797
R5709 wind_comp_0.sg13g2_and2_2$1_0.VSS.n2437 wind_comp_0.sg13g2_and2_2$1_0.VSS.n2347 0.0163797
R5710 wind_comp_0.sg13g2_and2_2$1_0.VSS.n2437 wind_comp_0.sg13g2_and2_2$1_0.VSS.n2435 0.0163797
R5711 wind_comp_0.sg13g2_and2_2$1_0.VSS.n2435 wind_comp_0.sg13g2_and2_2$1_0.VSS.n2433 0.0163797
R5712 wind_comp_0.sg13g2_and2_2$1_0.VSS.n2433 wind_comp_0.sg13g2_and2_2$1_0.VSS.n2351 0.0163797
R5713 wind_comp_0.sg13g2_and2_2$1_0.VSS.n2428 wind_comp_0.sg13g2_and2_2$1_0.VSS.n2351 0.0163797
R5714 wind_comp_0.sg13g2_and2_2$1_0.VSS.n2428 wind_comp_0.sg13g2_and2_2$1_0.VSS.n2426 0.0163797
R5715 wind_comp_0.sg13g2_and2_2$1_0.VSS.n2426 wind_comp_0.sg13g2_and2_2$1_0.VSS.n2424 0.0163797
R5716 wind_comp_0.sg13g2_and2_2$1_0.VSS.n2424 wind_comp_0.sg13g2_and2_2$1_0.VSS.n2355 0.0163797
R5717 wind_comp_0.sg13g2_and2_2$1_0.VSS.n2421 wind_comp_0.sg13g2_and2_2$1_0.VSS.n2355 0.0163797
R5718 wind_comp_0.sg13g2_and2_2$1_0.VSS.n2421 wind_comp_0.sg13g2_and2_2$1_0.VSS.n2420 0.0163797
R5719 wind_comp_0.sg13g2_and2_2$1_0.VSS.n2420 wind_comp_0.sg13g2_and2_2$1_0.VSS.n2418 0.0163797
R5720 wind_comp_0.sg13g2_and2_2$1_0.VSS.n2418 wind_comp_0.sg13g2_and2_2$1_0.VSS.n2358 0.0163797
R5721 wind_comp_0.sg13g2_and2_2$1_0.VSS.n2414 wind_comp_0.sg13g2_and2_2$1_0.VSS.n2358 0.0163797
R5722 wind_comp_0.sg13g2_and2_2$1_0.VSS.n2414 wind_comp_0.sg13g2_and2_2$1_0.VSS.n2412 0.0163797
R5723 wind_comp_0.sg13g2_and2_2$1_0.VSS.n96 wind_comp_0.sg13g2_and2_2$1_0.VSS.n2411 0.00889112
R5724 wind_comp_0.sg13g2_and2_2$1_0.VSS.n2411 wind_comp_0.sg13g2_and2_2$1_0.VSS.n2361 0.0163797
R5725 wind_comp_0.sg13g2_and2_2$1_0.VSS.n2408 wind_comp_0.sg13g2_and2_2$1_0.VSS.n2361 0.0163797
R5726 wind_comp_0.sg13g2_and2_2$1_0.VSS.n2408 wind_comp_0.sg13g2_and2_2$1_0.VSS.n2406 0.0163797
R5727 wind_comp_0.sg13g2_and2_2$1_0.VSS.n2406 wind_comp_0.sg13g2_and2_2$1_0.VSS.n2404 0.0163797
R5728 wind_comp_0.sg13g2_and2_2$1_0.VSS.n2404 wind_comp_0.sg13g2_and2_2$1_0.VSS.n2365 0.0163797
R5729 wind_comp_0.sg13g2_and2_2$1_0.VSS.n2401 wind_comp_0.sg13g2_and2_2$1_0.VSS.n2365 0.0163797
R5730 wind_comp_0.sg13g2_and2_2$1_0.VSS.n2401 wind_comp_0.sg13g2_and2_2$1_0.VSS.n2400 0.0163797
R5731 wind_comp_0.sg13g2_and2_2$1_0.VSS.n2400 wind_comp_0.sg13g2_and2_2$1_0.VSS.n2398 0.0163797
R5732 wind_comp_0.sg13g2_and2_2$1_0.VSS.n2398 wind_comp_0.sg13g2_and2_2$1_0.VSS.n2368 0.0163797
R5733 wind_comp_0.sg13g2_and2_2$1_0.VSS.n2394 wind_comp_0.sg13g2_and2_2$1_0.VSS.n2368 0.0163797
R5734 wind_comp_0.sg13g2_and2_2$1_0.VSS.n150 wind_comp_0.sg13g2_and2_2$1_0.VSS.n2393 0.00889112
R5735 wind_comp_0.sg13g2_and2_2$1_0.VSS.n2393 wind_comp_0.sg13g2_and2_2$1_0.VSS.n2392 0.0163797
R5736 wind_comp_0.sg13g2_and2_2$1_0.VSS.n2392 wind_comp_0.sg13g2_and2_2$1_0.VSS.n47 0.00889112
R5737 wind_comp_0.sg13g2_and2_2$1_0.VSS.n2389 wind_comp_0.sg13g2_and2_2$1_0.VSS.n2371 0.0163797
R5738 wind_comp_0.sg13g2_and2_2$1_0.VSS.n2389 wind_comp_0.sg13g2_and2_2$1_0.VSS.n42 0.00889112
R5739 wind_comp_0.sg13g2_and2_2$1_0.VSS.n2388 wind_comp_0.sg13g2_and2_2$1_0.VSS.n2387 0.0163797
R5740 wind_comp_0.sg13g2_and2_2$1_0.VSS.n2387 wind_comp_0.sg13g2_and2_2$1_0.VSS.n2375 0.0163797
R5741 wind_comp_0.sg13g2_and2_2$1_0.VSS.n2384 wind_comp_0.sg13g2_and2_2$1_0.VSS.n2375 0.0163797
R5742 wind_comp_0.sg13g2_and2_2$1_0.VSS.n2384 wind_comp_0.sg13g2_and2_2$1_0.VSS.n2382 0.0163797
R5743 wind_comp_0.sg13g2_and2_2$1_0.VSS.n2382 wind_comp_0.sg13g2_and2_2$1_0.VSS.n2378 0.0163797
R5744 wind_comp_0.sg13g2_and2_2$1_0.VSS.n2450 wind_comp_0.sg13g2_and2_2$1_0.VSS.n2341 0.0163797
R5745 wind_comp_0.sg13g2_and2_2$1_0.VSS.n2450 wind_comp_0.sg13g2_and2_2$1_0.VSS.n2342 0.0163797
R5746 wind_comp_0.sg13g2_and2_2$1_0.VSS.n2446 wind_comp_0.sg13g2_and2_2$1_0.VSS.n301 0.00889112
R5747 wind_comp_0.sg13g2_and2_2$1_0.VSS.n2446 wind_comp_0.sg13g2_and2_2$1_0.VSS.n2344 0.0163797
R5748 wind_comp_0.sg13g2_and2_2$1_0.VSS.n2445 wind_comp_0.sg13g2_and2_2$1_0.VSS.n302 0.00889112
R5749 wind_comp_0.sg13g2_and2_2$1_0.VSS.n2445 wind_comp_0.sg13g2_and2_2$1_0.VSS.n2345 0.0163797
R5750 wind_comp_0.sg13g2_and2_2$1_0.VSS.n2439 wind_comp_0.sg13g2_and2_2$1_0.VSS.n303 0.00889112
R5751 wind_comp_0.sg13g2_and2_2$1_0.VSS.n2439 wind_comp_0.sg13g2_and2_2$1_0.VSS.n2348 0.0163797
R5752 wind_comp_0.sg13g2_and2_2$1_0.VSS.n2438 wind_comp_0.sg13g2_and2_2$1_0.VSS.n304 0.00889112
R5753 wind_comp_0.sg13g2_and2_2$1_0.VSS.n2438 wind_comp_0.sg13g2_and2_2$1_0.VSS.n2349 0.0163797
R5754 wind_comp_0.sg13g2_and2_2$1_0.VSS.n2430 wind_comp_0.sg13g2_and2_2$1_0.VSS.n305 0.00889112
R5755 wind_comp_0.sg13g2_and2_2$1_0.VSS.n2430 wind_comp_0.sg13g2_and2_2$1_0.VSS.n2352 0.0163797
R5756 wind_comp_0.sg13g2_and2_2$1_0.VSS.n2429 wind_comp_0.sg13g2_and2_2$1_0.VSS.n306 0.00889112
R5757 wind_comp_0.sg13g2_and2_2$1_0.VSS.n2429 wind_comp_0.sg13g2_and2_2$1_0.VSS.n2353 0.0163797
R5758 wind_comp_0.sg13g2_and2_2$1_0.VSS.n2423 wind_comp_0.sg13g2_and2_2$1_0.VSS.n307 0.00889112
R5759 wind_comp_0.sg13g2_and2_2$1_0.VSS.n2423 wind_comp_0.sg13g2_and2_2$1_0.VSS.n2356 0.0163797
R5760 wind_comp_0.sg13g2_and2_2$1_0.VSS.n2422 wind_comp_0.sg13g2_and2_2$1_0.VSS.n308 0.00889112
R5761 wind_comp_0.sg13g2_and2_2$1_0.VSS.n2422 wind_comp_0.sg13g2_and2_2$1_0.VSS.n2357 0.0163797
R5762 wind_comp_0.sg13g2_and2_2$1_0.VSS.n2416 wind_comp_0.sg13g2_and2_2$1_0.VSS.n309 0.00889112
R5763 wind_comp_0.sg13g2_and2_2$1_0.VSS.n2416 wind_comp_0.sg13g2_and2_2$1_0.VSS.n2359 0.0163797
R5764 wind_comp_0.sg13g2_and2_2$1_0.VSS.n2415 wind_comp_0.sg13g2_and2_2$1_0.VSS.n310 0.00889112
R5765 wind_comp_0.sg13g2_and2_2$1_0.VSS.n2415 wind_comp_0.sg13g2_and2_2$1_0.VSS.n2360 0.0163797
R5766 wind_comp_0.sg13g2_and2_2$1_0.VSS.n2410 wind_comp_0.sg13g2_and2_2$1_0.VSS.n311 0.00889112
R5767 wind_comp_0.sg13g2_and2_2$1_0.VSS.n2410 wind_comp_0.sg13g2_and2_2$1_0.VSS.n2362 0.0163797
R5768 wind_comp_0.sg13g2_and2_2$1_0.VSS.n2409 wind_comp_0.sg13g2_and2_2$1_0.VSS.n312 0.00889112
R5769 wind_comp_0.sg13g2_and2_2$1_0.VSS.n2409 wind_comp_0.sg13g2_and2_2$1_0.VSS.n2363 0.0163797
R5770 wind_comp_0.sg13g2_and2_2$1_0.VSS.n2403 wind_comp_0.sg13g2_and2_2$1_0.VSS.n313 0.00889112
R5771 wind_comp_0.sg13g2_and2_2$1_0.VSS.n2403 wind_comp_0.sg13g2_and2_2$1_0.VSS.n2366 0.0163797
R5772 wind_comp_0.sg13g2_and2_2$1_0.VSS.n2402 wind_comp_0.sg13g2_and2_2$1_0.VSS.n314 0.00889112
R5773 wind_comp_0.sg13g2_and2_2$1_0.VSS.n2402 wind_comp_0.sg13g2_and2_2$1_0.VSS.n2367 0.0163797
R5774 wind_comp_0.sg13g2_and2_2$1_0.VSS.n2396 wind_comp_0.sg13g2_and2_2$1_0.VSS.n315 0.00889112
R5775 wind_comp_0.sg13g2_and2_2$1_0.VSS.n2396 wind_comp_0.sg13g2_and2_2$1_0.VSS.n2369 0.0163797
R5776 wind_comp_0.sg13g2_and2_2$1_0.VSS.n2395 wind_comp_0.sg13g2_and2_2$1_0.VSS.n316 0.00889112
R5777 wind_comp_0.sg13g2_and2_2$1_0.VSS.n2395 wind_comp_0.sg13g2_and2_2$1_0.VSS.n2370 0.0163797
R5778 wind_comp_0.sg13g2_and2_2$1_0.VSS.n2391 wind_comp_0.sg13g2_and2_2$1_0.VSS.n317 0.00889112
R5779 wind_comp_0.sg13g2_and2_2$1_0.VSS.n2391 wind_comp_0.sg13g2_and2_2$1_0.VSS.n2372 0.0163797
R5780 wind_comp_0.sg13g2_and2_2$1_0.VSS.n2390 wind_comp_0.sg13g2_and2_2$1_0.VSS.n318 0.00889112
R5781 wind_comp_0.sg13g2_and2_2$1_0.VSS.n2390 wind_comp_0.sg13g2_and2_2$1_0.VSS.n2373 0.0163797
R5782 wind_comp_0.sg13g2_and2_2$1_0.VSS.n2386 wind_comp_0.sg13g2_and2_2$1_0.VSS.n319 0.00889112
R5783 wind_comp_0.sg13g2_and2_2$1_0.VSS.n2386 wind_comp_0.sg13g2_and2_2$1_0.VSS.n2376 0.0163797
R5784 wind_comp_0.sg13g2_and2_2$1_0.VSS.n2385 wind_comp_0.sg13g2_and2_2$1_0.VSS.n320 0.00889112
R5785 wind_comp_0.sg13g2_and2_2$1_0.VSS.n2385 wind_comp_0.sg13g2_and2_2$1_0.VSS.n2377 0.0163797
R5786 wind_comp_0.sg13g2_and2_2$1_0.VSS.n2056 wind_comp_0.sg13g2_and2_2$1_0.VSS.n2054 0.0163797
R5787 wind_comp_0.sg13g2_and2_2$1_0.VSS.n2058 wind_comp_0.sg13g2_and2_2$1_0.VSS.n2056 0.0163797
R5788 wind_comp_0.sg13g2_and2_2$1_0.VSS.n2059 wind_comp_0.sg13g2_and2_2$1_0.VSS.n2058 0.0163797
R5789 wind_comp_0.sg13g2_and2_2$1_0.VSS.n2060 wind_comp_0.sg13g2_and2_2$1_0.VSS.n2059 0.0163797
R5790 wind_comp_0.sg13g2_and2_2$1_0.VSS.n2061 wind_comp_0.sg13g2_and2_2$1_0.VSS.n2060 0.0163797
R5791 wind_comp_0.sg13g2_and2_2$1_0.VSS.n2064 wind_comp_0.sg13g2_and2_2$1_0.VSS.n2061 0.0163797
R5792 wind_comp_0.sg13g2_and2_2$1_0.VSS.n2067 wind_comp_0.sg13g2_and2_2$1_0.VSS.n2064 0.0163797
R5793 wind_comp_0.sg13g2_and2_2$1_0.VSS.n2070 wind_comp_0.sg13g2_and2_2$1_0.VSS.n2067 0.0163797
R5794 wind_comp_0.sg13g2_and2_2$1_0.VSS.n2071 wind_comp_0.sg13g2_and2_2$1_0.VSS.n2070 0.0163797
R5795 wind_comp_0.sg13g2_and2_2$1_0.VSS.n2073 wind_comp_0.sg13g2_and2_2$1_0.VSS.n2071 0.0163797
R5796 wind_comp_0.sg13g2_and2_2$1_0.VSS.n2076 wind_comp_0.sg13g2_and2_2$1_0.VSS.n2073 0.0163797
R5797 wind_comp_0.sg13g2_and2_2$1_0.VSS.n2077 wind_comp_0.sg13g2_and2_2$1_0.VSS.n2076 0.0163797
R5798 wind_comp_0.sg13g2_and2_2$1_0.VSS.n2078 wind_comp_0.sg13g2_and2_2$1_0.VSS.n89 0.00889112
R5799 wind_comp_0.sg13g2_and2_2$1_0.VSS.n2079 wind_comp_0.sg13g2_and2_2$1_0.VSS.n2078 0.0163797
R5800 wind_comp_0.sg13g2_and2_2$1_0.VSS.n2080 wind_comp_0.sg13g2_and2_2$1_0.VSS.n2079 0.0163797
R5801 wind_comp_0.sg13g2_and2_2$1_0.VSS.n2081 wind_comp_0.sg13g2_and2_2$1_0.VSS.n2080 0.0163797
R5802 wind_comp_0.sg13g2_and2_2$1_0.VSS.n2082 wind_comp_0.sg13g2_and2_2$1_0.VSS.n2081 0.0163797
R5803 wind_comp_0.sg13g2_and2_2$1_0.VSS.n2083 wind_comp_0.sg13g2_and2_2$1_0.VSS.n2082 0.0163797
R5804 wind_comp_0.sg13g2_and2_2$1_0.VSS.n2084 wind_comp_0.sg13g2_and2_2$1_0.VSS.n2083 0.0163797
R5805 wind_comp_0.sg13g2_and2_2$1_0.VSS.n2085 wind_comp_0.sg13g2_and2_2$1_0.VSS.n2084 0.0163797
R5806 wind_comp_0.sg13g2_and2_2$1_0.VSS.n2086 wind_comp_0.sg13g2_and2_2$1_0.VSS.n2085 0.0163797
R5807 wind_comp_0.sg13g2_and2_2$1_0.VSS.n2087 wind_comp_0.sg13g2_and2_2$1_0.VSS.n2086 0.0163797
R5808 wind_comp_0.sg13g2_and2_2$1_0.VSS.n2087 wind_comp_0.sg13g2_and2_2$1_0.VSS.n2036 0.0163797
R5809 wind_comp_0.sg13g2_and2_2$1_0.VSS.n2050 wind_comp_0.sg13g2_and2_2$1_0.VSS.n2036 0.0163797
R5810 wind_comp_0.sg13g2_and2_2$1_0.VSS.n2050 wind_comp_0.sg13g2_and2_2$1_0.VSS.n2040 0.0163797
R5811 wind_comp_0.sg13g2_and2_2$1_0.VSS.n2044 wind_comp_0.sg13g2_and2_2$1_0.VSS.n2040 0.0163797
R5812 wind_comp_0.sg13g2_and2_2$1_0.VSS.n2044 wind_comp_0.sg13g2_and2_2$1_0.VSS.n1965 0.0163797
R5813 wind_comp_0.sg13g2_and2_2$1_0.VSS.n2131 wind_comp_0.sg13g2_and2_2$1_0.VSS.n1965 0.0163797
R5814 wind_comp_0.sg13g2_and2_2$1_0.VSS.n2132 wind_comp_0.sg13g2_and2_2$1_0.VSS.n2131 0.0163797
R5815 wind_comp_0.sg13g2_and2_2$1_0.VSS.n2132 wind_comp_0.sg13g2_and2_2$1_0.VSS.n1963 0.0163797
R5816 wind_comp_0.sg13g2_and2_2$1_0.VSS.n2138 wind_comp_0.sg13g2_and2_2$1_0.VSS.n1963 0.0163797
R5817 wind_comp_0.sg13g2_and2_2$1_0.VSS.n2139 wind_comp_0.sg13g2_and2_2$1_0.VSS.n2138 0.0163797
R5818 wind_comp_0.sg13g2_and2_2$1_0.VSS.n2142 wind_comp_0.sg13g2_and2_2$1_0.VSS.n2139 0.0163797
R5819 wind_comp_0.sg13g2_and2_2$1_0.VSS.n2143 wind_comp_0.sg13g2_and2_2$1_0.VSS.n2142 0.0163797
R5820 wind_comp_0.sg13g2_and2_2$1_0.VSS.n2146 wind_comp_0.sg13g2_and2_2$1_0.VSS.n2143 0.0163797
R5821 wind_comp_0.sg13g2_and2_2$1_0.VSS.n2149 wind_comp_0.sg13g2_and2_2$1_0.VSS.n2146 0.0163797
R5822 wind_comp_0.sg13g2_and2_2$1_0.VSS.n2150 wind_comp_0.sg13g2_and2_2$1_0.VSS.n2149 0.0163797
R5823 wind_comp_0.sg13g2_and2_2$1_0.VSS.n2153 wind_comp_0.sg13g2_and2_2$1_0.VSS.n2150 0.0163797
R5824 wind_comp_0.sg13g2_and2_2$1_0.VSS.n2154 wind_comp_0.sg13g2_and2_2$1_0.VSS.n2153 0.0163797
R5825 wind_comp_0.sg13g2_and2_2$1_0.VSS.n2039 wind_comp_0.sg13g2_and2_2$1_0.VSS.n2038 0.0163797
R5826 wind_comp_0.sg13g2_and2_2$1_0.VSS.n2038 wind_comp_0.sg13g2_and2_2$1_0.VSS.n56 0.00889112
R5827 wind_comp_0.sg13g2_and2_2$1_0.VSS.n321 wind_comp_0.sg13g2_and2_2$1_0.VSS.n323 0.0163797
R5828 wind_comp_0.sg13g2_and2_2$1_0.VSS.n55 wind_comp_0.sg13g2_and2_2$1_0.VSS.n322 0.00889112
R5829 wind_comp_0.sg13g2_and2_2$1_0.VSS.n322 wind_comp_0.sg13g2_and2_2$1_0.VSS.n325 0.0163797
R5830 wind_comp_0.sg13g2_and2_2$1_0.VSS.n54 wind_comp_0.sg13g2_and2_2$1_0.VSS.n324 0.00889112
R5831 wind_comp_0.sg13g2_and2_2$1_0.VSS.n324 wind_comp_0.sg13g2_and2_2$1_0.VSS.n327 0.0163797
R5832 wind_comp_0.sg13g2_and2_2$1_0.VSS.n58 wind_comp_0.sg13g2_and2_2$1_0.VSS.n326 0.00889112
R5833 wind_comp_0.sg13g2_and2_2$1_0.VSS.n326 wind_comp_0.sg13g2_and2_2$1_0.VSS.n329 0.0163797
R5834 wind_comp_0.sg13g2_and2_2$1_0.VSS.n57 wind_comp_0.sg13g2_and2_2$1_0.VSS.n328 0.00889112
R5835 wind_comp_0.sg13g2_and2_2$1_0.VSS.n328 wind_comp_0.sg13g2_and2_2$1_0.VSS.n331 0.0163797
R5836 wind_comp_0.sg13g2_and2_2$1_0.VSS.n59 wind_comp_0.sg13g2_and2_2$1_0.VSS.n330 0.00889112
R5837 wind_comp_0.sg13g2_and2_2$1_0.VSS.n330 wind_comp_0.sg13g2_and2_2$1_0.VSS.n333 0.0163797
R5838 wind_comp_0.sg13g2_and2_2$1_0.VSS.n60 wind_comp_0.sg13g2_and2_2$1_0.VSS.n332 0.00889112
R5839 wind_comp_0.sg13g2_and2_2$1_0.VSS.n332 wind_comp_0.sg13g2_and2_2$1_0.VSS.n335 0.0163797
R5840 wind_comp_0.sg13g2_and2_2$1_0.VSS.n63 wind_comp_0.sg13g2_and2_2$1_0.VSS.n334 0.00889112
R5841 wind_comp_0.sg13g2_and2_2$1_0.VSS.n334 wind_comp_0.sg13g2_and2_2$1_0.VSS.n337 0.0163797
R5842 wind_comp_0.sg13g2_and2_2$1_0.VSS.n64 wind_comp_0.sg13g2_and2_2$1_0.VSS.n336 0.00889112
R5843 wind_comp_0.sg13g2_and2_2$1_0.VSS.n336 wind_comp_0.sg13g2_and2_2$1_0.VSS.n339 0.0163797
R5844 wind_comp_0.sg13g2_and2_2$1_0.VSS.n62 wind_comp_0.sg13g2_and2_2$1_0.VSS.n338 0.00889112
R5845 wind_comp_0.sg13g2_and2_2$1_0.VSS.n338 wind_comp_0.sg13g2_and2_2$1_0.VSS.n2037 0.0163797
R5846 wind_comp_0.sg13g2_and2_2$1_0.VSS.n2052 wind_comp_0.sg13g2_and2_2$1_0.VSS.n340 0.00889112
R5847 wind_comp_0.sg13g2_and2_2$1_0.VSS.n2052 wind_comp_0.sg13g2_and2_2$1_0.VSS.n2051 0.0163797
R5848 wind_comp_0.sg13g2_and2_2$1_0.VSS.n179 wind_comp_0.sg13g2_and2_2$1_0.VSS.n341 0.00889112
R5849 wind_comp_0.sg13g2_and2_2$1_0.VSS.n2043 wind_comp_0.sg13g2_and2_2$1_0.VSS.n341 0.0163797
R5850 wind_comp_0.sg13g2_and2_2$1_0.VSS.n180 wind_comp_0.sg13g2_and2_2$1_0.VSS.n342 0.00889112
R5851 wind_comp_0.sg13g2_and2_2$1_0.VSS.n342 wind_comp_0.sg13g2_and2_2$1_0.VSS.n344 0.0163797
R5852 wind_comp_0.sg13g2_and2_2$1_0.VSS.n178 wind_comp_0.sg13g2_and2_2$1_0.VSS.n343 0.00889112
R5853 wind_comp_0.sg13g2_and2_2$1_0.VSS.n2042 wind_comp_0.sg13g2_and2_2$1_0.VSS.n343 0.0163797
R5854 wind_comp_0.sg13g2_and2_2$1_0.VSS.n177 wind_comp_0.sg13g2_and2_2$1_0.VSS.n345 0.00889112
R5855 wind_comp_0.sg13g2_and2_2$1_0.VSS.n345 wind_comp_0.sg13g2_and2_2$1_0.VSS.n347 0.0163797
R5856 wind_comp_0.sg13g2_and2_2$1_0.VSS.n174 wind_comp_0.sg13g2_and2_2$1_0.VSS.n346 0.00889112
R5857 wind_comp_0.sg13g2_and2_2$1_0.VSS.n346 wind_comp_0.sg13g2_and2_2$1_0.VSS.n349 0.0163797
R5858 wind_comp_0.sg13g2_and2_2$1_0.VSS.n173 wind_comp_0.sg13g2_and2_2$1_0.VSS.n348 0.00889112
R5859 wind_comp_0.sg13g2_and2_2$1_0.VSS.n348 wind_comp_0.sg13g2_and2_2$1_0.VSS.n351 0.0163797
R5860 wind_comp_0.sg13g2_and2_2$1_0.VSS.n175 wind_comp_0.sg13g2_and2_2$1_0.VSS.n350 0.00889112
R5861 wind_comp_0.sg13g2_and2_2$1_0.VSS.n350 wind_comp_0.sg13g2_and2_2$1_0.VSS.n1962 0.0163797
R5862 wind_comp_0.sg13g2_and2_2$1_0.VSS.n1482 wind_comp_0.sg13g2_and2_2$1_0.VSS.n1481 0.0160921
R5863 wind_comp_0.sg13g2_and2_2$1_0.VSS.n1480 wind_comp_0.sg13g2_and2_2$1_0.VSS.n1479 0.0160921
R5864 wind_comp_0.sg13g2_and2_2$1_0.VSS.n1411 wind_comp_0.sg13g2_and2_2$1_0.VSS.n1410 0.0160921
R5865 wind_comp_0.sg13g2_and2_2$1_0.VSS.n1647 wind_comp_0.sg13g2_and2_2$1_0.VSS.n1645 0.0160921
R5866 wind_comp_0.sg13g2_and2_2$1_0.VSS.n1673 wind_comp_0.sg13g2_and2_2$1_0.VSS.n1672 0.0160921
R5867 wind_comp_0.sg13g2_and2_2$1_0.VSS.n1680 wind_comp_0.sg13g2_and2_2$1_0.VSS.n1679 0.0160921
R5868 wind_comp_0.sg13g2_and2_2$1_0.VSS.n1674 wind_comp_0.sg13g2_and2_2$1_0.VSS.n881 0.0158424
R5869 wind_comp_0.sg13g2_and2_2$1_0.VSS.n1577 wind_comp_0.sg13g2_and2_2$1_0.VSS.n1308 0.0157932
R5870 wind_comp_0.sg13g2_and2_2$1_0.VSS.n128 wind_comp_0.sg13g2_and2_2$1_0.VSS.n127 0.637169
R5871 wind_comp_0.sg13g2_and2_2$1_0.VSS.n1311 wind_comp_0.sg13g2_and2_2$1_0.VSS.n751 0.0157504
R5872 wind_comp_0.sg13g2_and2_2$1_0.VSS.n630 wind_comp_0.sg13g2_and2_2$1_0.VSS.n2209 0.0113098
R5873 wind_comp_0.sg13g2_and2_2$1_0.VSS.n1456 wind_comp_0.sg13g2_and2_2$1_0.VSS.n1454 0.0145975
R5874 wind_comp_0.sg13g2_and2_2$1_0.VSS.n1481 wind_comp_0.sg13g2_and2_2$1_0.VSS.n1480 0.0145975
R5875 wind_comp_0.sg13g2_and2_2$1_0.VSS.n1679 wind_comp_0.sg13g2_and2_2$1_0.VSS.n1672 0.0145975
R5876 wind_comp_0.sg13g2_and2_2$1_0.VSS.n1693 wind_comp_0.sg13g2_and2_2$1_0.VSS.n1615 0.0145975
R5877 wind_comp_0.sg13g2_and2_2$1_0.VSS.n1817 wind_comp_0.comparator_1.dynamic_pcell$1_0.VSS 0.0143889
R5878 wind_comp_0.sg13g2_and2_2$1_0.VSS.n1478 wind_comp_0.sg13g2_and2_2$1_0.VSS.n1476 0.0142986
R5879 wind_comp_0.sg13g2_and2_2$1_0.VSS.n1416 wind_comp_0.sg13g2_and2_2$1_0.VSS.n1415 0.0142986
R5880 wind_comp_0.sg13g2_and2_2$1_0.VSS.n1646 wind_comp_0.sg13g2_and2_2$1_0.VSS.n1641 0.0142986
R5881 wind_comp_0.sg13g2_and2_2$1_0.VSS.n1683 wind_comp_0.sg13g2_and2_2$1_0.VSS.n1682 0.0142986
R5882 wind_comp_0.sg13g2_and2_2$1_0.VSS.n751 wind_comp_0.comparator_0.sg13cmos5l_inv_16_1.VSS 0.0141253
R5883 wind_comp_0.sg13g2_and2_2$1_0.VSS.n2233 wind_comp_0.sg13g2_and2_2$1_0.VSS.n877 0.0138721
R5884 wind_comp_0.sg13g2_and2_2$1_0.VSS.n893 wind_comp_0.sg13g2_and2_2$1_0.VSS.n892 0.0138721
R5885 wind_comp_0.sg13g2_and2_2$1_0.VSS.n36 wind_comp_0.sg13g2_and2_2$1_0.VSS.n28 0.00325716
R5886 wind_comp_0.sg13g2_and2_2$1_0.VSS.n1801 wind_comp_0.sg13g2_and2_2$1_0.VSS.n1735 0.0132413
R5887 wind_comp_0.sg13g2_and2_2$1_0.VSS.n1768 wind_comp_0.sg13g2_and2_2$1_0.VSS.n1738 0.0132413
R5888 wind_comp_0.sg13g2_and2_2$1_0.VSS.n1800 wind_comp_0.sg13g2_and2_2$1_0.VSS.n1734 0.0132413
R5889 wind_comp_0.sg13g2_and2_2$1_0.VSS.n1769 wind_comp_0.sg13g2_and2_2$1_0.VSS.n1739 0.0132413
R5890 wind_comp_0.sg13g2_and2_2$1_0.VSS.n1799 wind_comp_0.sg13g2_and2_2$1_0.VSS.n1733 0.0132413
R5891 wind_comp_0.sg13g2_and2_2$1_0.VSS.n1770 wind_comp_0.sg13g2_and2_2$1_0.VSS.n1740 0.0132413
R5892 wind_comp_0.sg13g2_and2_2$1_0.VSS.n1798 wind_comp_0.sg13g2_and2_2$1_0.VSS.n1732 0.0132413
R5893 wind_comp_0.sg13g2_and2_2$1_0.VSS.n1771 wind_comp_0.sg13g2_and2_2$1_0.VSS.n1741 0.0132413
R5894 wind_comp_0.sg13g2_and2_2$1_0.VSS.n1797 wind_comp_0.sg13g2_and2_2$1_0.VSS.n1731 0.0132413
R5895 wind_comp_0.sg13g2_and2_2$1_0.VSS.n1772 wind_comp_0.sg13g2_and2_2$1_0.VSS.n1742 0.0132413
R5896 wind_comp_0.sg13g2_and2_2$1_0.VSS.n1796 wind_comp_0.sg13g2_and2_2$1_0.VSS.n1730 0.0132413
R5897 wind_comp_0.sg13g2_and2_2$1_0.VSS.n1773 wind_comp_0.sg13g2_and2_2$1_0.VSS.n1743 0.0132413
R5898 wind_comp_0.sg13g2_and2_2$1_0.VSS.n1795 wind_comp_0.sg13g2_and2_2$1_0.VSS.n1729 0.0132413
R5899 wind_comp_0.sg13g2_and2_2$1_0.VSS.n1774 wind_comp_0.sg13g2_and2_2$1_0.VSS.n1744 0.0132413
R5900 wind_comp_0.sg13g2_and2_2$1_0.VSS.n1794 wind_comp_0.sg13g2_and2_2$1_0.VSS.n1728 0.0132413
R5901 wind_comp_0.sg13g2_and2_2$1_0.VSS.n1775 wind_comp_0.sg13g2_and2_2$1_0.VSS.n1745 0.0132413
R5902 wind_comp_0.sg13g2_and2_2$1_0.VSS.n1793 wind_comp_0.sg13g2_and2_2$1_0.VSS.n1727 0.0132413
R5903 wind_comp_0.sg13g2_and2_2$1_0.VSS.n1316 wind_comp_0.sg13g2_and2_2$1_0.VSS.n752 0.0130908
R5904 wind_comp_0.comparator_0.sg13cmos5l_inv_16_1.VSS wind_comp_0.sg13g2_and2_2$1_0.VSS.n528 0.0128155
R5905 wind_comp_0.sg13g2_and2_2$1_0.VSS.n1035 wind_comp_0.sg13g2_and2_2$1_0.VSS.n838 0.0128108
R5906 wind_comp_0.sg13g2_and2_2$1_0.VSS.n1453 wind_comp_0.sg13g2_and2_2$1_0.VSS.n1450 0.012804
R5907 wind_comp_0.sg13g2_and2_2$1_0.VSS.n1491 wind_comp_0.sg13g2_and2_2$1_0.VSS.n1490 0.012804
R5908 wind_comp_0.sg13g2_and2_2$1_0.VSS.n1670 wind_comp_0.sg13g2_and2_2$1_0.VSS.n1669 0.012804
R5909 wind_comp_0.sg13g2_and2_2$1_0.VSS.n1618 wind_comp_0.sg13g2_and2_2$1_0.VSS.n1617 0.012804
R5910 wind_comp_0.sg13g2_and2_2$1_0.VSS.n1475 wind_comp_0.sg13g2_and2_2$1_0.VSS.n1472 0.0125051
R5911 wind_comp_0.sg13g2_and2_2$1_0.VSS.n1421 wind_comp_0.sg13g2_and2_2$1_0.VSS.n1420 0.0125051
R5912 wind_comp_0.sg13g2_and2_2$1_0.VSS.n1640 wind_comp_0.sg13g2_and2_2$1_0.VSS.n1638 0.0125051
R5913 wind_comp_0.sg13g2_and2_2$1_0.VSS.n1685 wind_comp_0.sg13g2_and2_2$1_0.VSS.n1684 0.0125051
R5914 wind_comp_0.sg13g2_and2_2$1_0.VSS.n1817 wind_comp_0.sg13g2_and2_2$1_0.VSS.n1767 0.0120238
R5915 wind_comp_0.sg13g2_and2_2$1_0.VSS.n234 wind_comp_0.sg13g2_and2_2$1_0.VSS.n233 0.00844198
R5916 wind_comp_0.sg13g2_and2_2$1_0.VSS.n1674 wind_comp_0.sg13g2_and2_2$1_0.VSS.n882 0.0110951
R5917 wind_comp_0.sg13g2_and2_2$1_0.VSS.n454 wind_comp_0.sg13g2_and2_2$1_0.VSS.n771 0.0093528
R5918 wind_comp_0.sg13g2_and2_2$1_0.VSS.n1449 wind_comp_0.sg13g2_and2_2$1_0.VSS.n1446 0.0110106
R5919 wind_comp_0.sg13g2_and2_2$1_0.VSS.n1496 wind_comp_0.sg13g2_and2_2$1_0.VSS.n1494 0.0110106
R5920 wind_comp_0.sg13g2_and2_2$1_0.VSS.n1668 wind_comp_0.sg13g2_and2_2$1_0.VSS.n1665 0.0110106
R5921 wind_comp_0.sg13g2_and2_2$1_0.VSS.n1621 wind_comp_0.sg13g2_and2_2$1_0.VSS.n1620 0.0110106
R5922 wind_comp_0.sg13g2_and2_2$1_0.VSS.n1044 wind_comp_0.sg13g2_and2_2$1_0.VSS.n859 0.0108949
R5923 wind_comp_0.sg13g2_and2_2$1_0.VSS.n1471 wind_comp_0.sg13g2_and2_2$1_0.VSS.n1468 0.0107116
R5924 wind_comp_0.sg13g2_and2_2$1_0.VSS.n1425 wind_comp_0.sg13g2_and2_2$1_0.VSS.n1424 0.0107116
R5925 wind_comp_0.sg13g2_and2_2$1_0.VSS.n1637 wind_comp_0.sg13g2_and2_2$1_0.VSS.n1636 0.0107116
R5926 wind_comp_0.sg13g2_and2_2$1_0.VSS.n1689 wind_comp_0.sg13g2_and2_2$1_0.VSS.n1687 0.0107116
R5927 wind_comp_0.sg13g2_and2_2$1_0.VSS.n619 wind_comp_0.sg13g2_and2_2$1_0.VSS.n1653 0.0105637
R5928 wind_comp_0.sg13g2_and2_2$1_0.VSS.n2015 wind_comp_0.sg13g2_and2_2$1_0.VSS.n767 0.0105889
R5929 wind_comp_0.sg13g2_and2_2$1_0.VSS.n1316 wind_comp_0.sg13g2_and2_2$1_0.VSS.n753 0.0105081
R5930 wind_comp_0.sg13g2_and2_2$1_0.VSS.n690 wind_comp_0.sg13g2_and2_2$1_0.VSS.n140 0.0259808
R5931 wind_comp_0.sg13g2_and2_2$1_0.VSS.n1490 wind_comp_0.sg13g2_and2_2$1_0.VSS.n1487 0.0102147
R5932 wind_comp_0.sg13g2_and2_2$1_0.VSS.n1669 wind_comp_0.sg13g2_and2_2$1_0.VSS.n1632 0.0102147
R5933 wind_comp_0.sg13g2_and2_2$1_0.VSS.n1705 wind_comp_0.sg13g2_and2_2$1_0.VSS.n878 0.0101338
R5934 wind_comp_0.sg13g2_and2_2$1_0.VSS.n1353 wind_comp_0.sg13g2_and2_2$1_0.VSS.n246 0.010125
R5935 wind_comp_0.sg13g2_and2_2$1_0.VSS.n1007 wind_comp_0.sg13g2_and2_2$1_0.VSS.n815 0.0100791
R5936 wind_comp_0.sg13g2_and2_2$1_0.VSS.n1010 wind_comp_0.sg13g2_and2_2$1_0.VSS.n816 0.0100791
R5937 wind_comp_0.sg13g2_and2_2$1_0.VSS.n1009 wind_comp_0.sg13g2_and2_2$1_0.VSS.n817 0.0100791
R5938 wind_comp_0.sg13g2_and2_2$1_0.VSS.n1012 wind_comp_0.sg13g2_and2_2$1_0.VSS.n818 0.0100791
R5939 wind_comp_0.sg13g2_and2_2$1_0.VSS.n1011 wind_comp_0.sg13g2_and2_2$1_0.VSS.n819 0.0100791
R5940 wind_comp_0.sg13g2_and2_2$1_0.VSS.n1014 wind_comp_0.sg13g2_and2_2$1_0.VSS.n820 0.0100791
R5941 wind_comp_0.sg13g2_and2_2$1_0.VSS.n1013 wind_comp_0.sg13g2_and2_2$1_0.VSS.n821 0.0100791
R5942 wind_comp_0.sg13g2_and2_2$1_0.VSS.n1028 wind_comp_0.sg13g2_and2_2$1_0.VSS.n822 0.0100791
R5943 wind_comp_0.sg13g2_and2_2$1_0.VSS.n909 wind_comp_0.sg13g2_and2_2$1_0.VSS.n824 0.0100791
R5944 wind_comp_0.sg13g2_and2_2$1_0.VSS.n908 wind_comp_0.sg13g2_and2_2$1_0.VSS.n825 0.0100791
R5945 wind_comp_0.sg13g2_and2_2$1_0.VSS.n907 wind_comp_0.sg13g2_and2_2$1_0.VSS.n826 0.0100791
R5946 wind_comp_0.sg13g2_and2_2$1_0.VSS.n987 wind_comp_0.sg13g2_and2_2$1_0.VSS.n827 0.0100791
R5947 wind_comp_0.sg13g2_and2_2$1_0.VSS.n986 wind_comp_0.sg13g2_and2_2$1_0.VSS.n828 0.0100791
R5948 wind_comp_0.sg13g2_and2_2$1_0.VSS.n998 wind_comp_0.sg13g2_and2_2$1_0.VSS.n829 0.0100791
R5949 wind_comp_0.sg13g2_and2_2$1_0.VSS.n1031 wind_comp_0.sg13g2_and2_2$1_0.VSS.n831 0.0100791
R5950 wind_comp_0.sg13g2_and2_2$1_0.VSS.n1029 wind_comp_0.sg13g2_and2_2$1_0.VSS.n832 0.0100791
R5951 wind_comp_0.sg13g2_and2_2$1_0.VSS.n1030 wind_comp_0.sg13g2_and2_2$1_0.VSS.n833 0.0100791
R5952 wind_comp_0.sg13g2_and2_2$1_0.VSS.n1033 wind_comp_0.sg13g2_and2_2$1_0.VSS.n834 0.0100791
R5953 wind_comp_0.sg13g2_and2_2$1_0.VSS.n1032 wind_comp_0.sg13g2_and2_2$1_0.VSS.n835 0.0100791
R5954 wind_comp_0.sg13g2_and2_2$1_0.VSS.n1036 wind_comp_0.sg13g2_and2_2$1_0.VSS.n836 0.0100791
R5955 wind_comp_0.sg13g2_and2_2$1_0.VSS.n1034 wind_comp_0.sg13g2_and2_2$1_0.VSS.n837 0.0100791
R5956 wind_comp_0.sg13g2_and2_2$1_0.VSS.n622 wind_comp_0.sg13g2_and2_2$1_0.VSS.n620 0.0057562
R5957 wind_comp_0.sg13g2_and2_2$1_0.VSS.n626 wind_comp_0.sg13g2_and2_2$1_0.VSS.n624 0.0057562
R5958 wind_comp_0.sg13g2_and2_2$1_0.VSS.n2209 wind_comp_0.sg13g2_and2_2$1_0.VSS.n2208 0.0100026
R5959 wind_comp_0.sg13g2_and2_2$1_0.VSS.n2434 wind_comp_0.sg13g2_and2_2$1_0.VSS.n926 0.0100026
R5960 wind_comp_0.sg13g2_and2_2$1_0.VSS.n664 wind_comp_0.sg13g2_and2_2$1_0.VSS.n662 0.00574865
R5961 wind_comp_0.sg13g2_and2_2$1_0.VSS.n1819 wind_comp_0.sg13g2_and2_2$1_0.VSS.n1818 0.00994444
R5962 wind_comp_0.sg13g2_and2_2$1_0.VSS.n223 wind_comp_0.sg13g2_and2_2$1_0.VSS.n872 0.0153373
R5963 wind_comp_0.sg13g2_and2_2$1_0.VSS.n2045 wind_comp_0.sg13g2_and2_2$1_0.VSS.n2041 0.00992388
R5964 wind_comp_0.sg13g2_and2_2$1_0.VSS.n878 wind_comp_0.sg13g2_and2_2$1_0.VSS.n529 0.00964582
R5965 wind_comp_0.sg13g2_and2_2$1_0.VSS.n452 wind_comp_0.sg13g2_and2_2$1_0.VSS.n667 0.00964582
R5966 wind_comp_0.sg13g2_and2_2$1_0.VSS.n129 wind_comp_0.sg13g2_and2_2$1_0.VSS.n654 0.181802
R5967 wind_comp_0.sg13g2_and2_2$1_0.VSS.n2432 wind_comp_0.sg13g2_and2_2$1_0.VSS.n927 0.00963593
R5968 wind_comp_0.sg13g2_and2_2$1_0.VSS.n1043 wind_comp_0.sg13g2_and2_2$1_0.VSS.n859 0.00961773
R5969 wind_comp_0.sg13g2_and2_2$1_0.VSS.n1819 wind_comp_0.sg13g2_and2_2$1_0.VSS.n1736 0.00957407
R5970 wind_comp_0.sg13g2_and2_2$1_0.VSS.n1865 wind_comp_0.sg13g2_and2_2$1_0.VSS.n1737 0.00957407
R5971 wind_comp_0.sg13g2_and2_2$1_0.VSS.n94 wind_comp_0.sg13g2_and2_2$1_0.VSS.n1866 0.0160848
R5972 wind_comp_0.sg13g2_and2_2$1_0.VSS.n670 wind_comp_0.sg13g2_and2_2$1_0.VSS.n667 0.00954685
R5973 wind_comp_0.sg13g2_and2_2$1_0.VSS.n2576 wind_comp_0.sg13g2_and2_2$1_0.VSS.n528 0.00954685
R5974 wind_comp_0.sg13g2_and2_2$1_0.VSS.n1000 wind_comp_0.sg13g2_and2_2$1_0.VSS.n805 0.00944049
R5975 wind_comp_0.sg13g2_and2_2$1_0.VSS.n999 wind_comp_0.sg13g2_and2_2$1_0.VSS.n806 0.00944049
R5976 wind_comp_0.sg13g2_and2_2$1_0.VSS.n1017 wind_comp_0.sg13g2_and2_2$1_0.VSS.n808 0.00944049
R5977 wind_comp_0.sg13g2_and2_2$1_0.VSS.n1002 wind_comp_0.sg13g2_and2_2$1_0.VSS.n809 0.00944049
R5978 wind_comp_0.sg13g2_and2_2$1_0.VSS.n1001 wind_comp_0.sg13g2_and2_2$1_0.VSS.n810 0.00944049
R5979 wind_comp_0.sg13g2_and2_2$1_0.VSS.n1004 wind_comp_0.sg13g2_and2_2$1_0.VSS.n811 0.00944049
R5980 wind_comp_0.sg13g2_and2_2$1_0.VSS.n1003 wind_comp_0.sg13g2_and2_2$1_0.VSS.n812 0.00944049
R5981 wind_comp_0.sg13g2_and2_2$1_0.VSS.n1006 wind_comp_0.sg13g2_and2_2$1_0.VSS.n813 0.00944049
R5982 wind_comp_0.sg13g2_and2_2$1_0.VSS.n1005 wind_comp_0.sg13g2_and2_2$1_0.VSS.n814 0.00944049
R5983 wind_comp_0.sg13g2_and2_2$1_0.VSS.n1008 wind_comp_0.sg13g2_and2_2$1_0.VSS.n815 0.00944049
R5984 wind_comp_0.sg13g2_and2_2$1_0.VSS.n2335 wind_comp_0.sg13g2_and2_2$1_0.VSS.n872 0.00936032
R5985 wind_comp_0.sg13g2_and2_2$1_0.VSS.n2011 wind_comp_0.sg13g2_and2_2$1_0.VSS.n767 0.00935118
R5986 wind_comp_0.sg13g2_and2_2$1_0.VSS.n1331 wind_comp_0.sg13g2_and2_2$1_0.VSS.n756 0.00933417
R5987 wind_comp_0.sg13g2_and2_2$1_0.VSS.n1487 wind_comp_0.sg13g2_and2_2$1_0.VSS.n1486 0.00916848
R5988 wind_comp_0.sg13g2_and2_2$1_0.VSS.n1518 wind_comp_0.sg13g2_and2_2$1_0.VSS.n1276 0.00916848
R5989 wind_comp_0.sg13g2_and2_2$1_0.VSS.n1652 wind_comp_0.sg13g2_and2_2$1_0.VSS.n1594 0.00916848
R5990 wind_comp_0.sg13g2_and2_2$1_0.VSS.n1675 wind_comp_0.sg13g2_and2_2$1_0.VSS.n1632 0.00916848
R5991 wind_comp_0.sg13g2_and2_2$1_0.VSS.n1975 wind_comp_0.sg13g2_and2_2$1_0.VSS.n803 0.00916385
R5992 wind_comp_0.sg13g2_and2_2$1_0.VSS.n1974 wind_comp_0.sg13g2_and2_2$1_0.VSS.n802 0.00916385
R5993 wind_comp_0.sg13g2_and2_2$1_0.VSS.n1976 wind_comp_0.sg13g2_and2_2$1_0.VSS.n801 0.00916385
R5994 wind_comp_0.sg13g2_and2_2$1_0.VSS.n2000 wind_comp_0.sg13g2_and2_2$1_0.VSS.n799 0.00916385
R5995 wind_comp_0.sg13g2_and2_2$1_0.VSS.n2001 wind_comp_0.sg13g2_and2_2$1_0.VSS.n798 0.00916385
R5996 wind_comp_0.sg13g2_and2_2$1_0.VSS.n2377 wind_comp_0.sg13g2_and2_2$1_0.VSS.n181 0.00888816
R5997 wind_comp_0.sg13g2_and2_2$1_0.VSS.n2451 wind_comp_0.sg13g2_and2_2$1_0.VSS.n2341 0.00888816
R5998 wind_comp_0.sg13g2_and2_2$1_0.VSS.n2053 wind_comp_0.sg13g2_and2_2$1_0.VSS.n2039 0.00888816
R5999 wind_comp_0.sg13g2_and2_2$1_0.VSS.n1962 wind_comp_0.sg13g2_and2_2$1_0.VSS.n176 0.00888816
R6000 wind_comp_0.sg13g2_and2_2$1_0.VSS.n1245 wind_comp_0.sg13g2_and2_2$1_0.VSS.n703 0.00888095
R6001 wind_comp_0.sg13g2_and2_2$1_0.VSS.n1243 wind_comp_0.sg13g2_and2_2$1_0.VSS.n704 0.00888095
R6002 wind_comp_0.sg13g2_and2_2$1_0.VSS.n1246 wind_comp_0.sg13g2_and2_2$1_0.VSS.n705 0.00888095
R6003 wind_comp_0.sg13g2_and2_2$1_0.VSS.n1242 wind_comp_0.sg13g2_and2_2$1_0.VSS.n706 0.00888095
R6004 wind_comp_0.sg13g2_and2_2$1_0.VSS.n1247 wind_comp_0.sg13g2_and2_2$1_0.VSS.n707 0.00888095
R6005 wind_comp_0.sg13g2_and2_2$1_0.VSS.n1241 wind_comp_0.sg13g2_and2_2$1_0.VSS.n708 0.00888095
R6006 wind_comp_0.sg13g2_and2_2$1_0.VSS.n1248 wind_comp_0.sg13g2_and2_2$1_0.VSS.n709 0.00888095
R6007 wind_comp_0.sg13g2_and2_2$1_0.VSS.n1240 wind_comp_0.sg13g2_and2_2$1_0.VSS.n710 0.00888095
R6008 wind_comp_0.sg13g2_and2_2$1_0.VSS.n1249 wind_comp_0.sg13g2_and2_2$1_0.VSS.n711 0.00888095
R6009 wind_comp_0.sg13g2_and2_2$1_0.VSS.n1239 wind_comp_0.sg13g2_and2_2$1_0.VSS.n712 0.00888095
R6010 wind_comp_0.sg13g2_and2_2$1_0.VSS.n1250 wind_comp_0.sg13g2_and2_2$1_0.VSS.n713 0.00888095
R6011 wind_comp_0.sg13g2_and2_2$1_0.VSS.n1238 wind_comp_0.sg13g2_and2_2$1_0.VSS.n714 0.00888095
R6012 wind_comp_0.sg13g2_and2_2$1_0.VSS.n1251 wind_comp_0.sg13g2_and2_2$1_0.VSS.n715 0.00888095
R6013 wind_comp_0.sg13g2_and2_2$1_0.VSS.n1237 wind_comp_0.sg13g2_and2_2$1_0.VSS.n716 0.00888095
R6014 wind_comp_0.sg13g2_and2_2$1_0.VSS.n1252 wind_comp_0.sg13g2_and2_2$1_0.VSS.n717 0.00888095
R6015 wind_comp_0.sg13g2_and2_2$1_0.VSS.n1236 wind_comp_0.sg13g2_and2_2$1_0.VSS.n718 0.00888095
R6016 wind_comp_0.sg13g2_and2_2$1_0.VSS.n1253 wind_comp_0.sg13g2_and2_2$1_0.VSS.n719 0.00888095
R6017 wind_comp_0.sg13g2_and2_2$1_0.VSS.n1836 wind_comp_0.sg13g2_and2_2$1_0.VSS.n1759 0.00888095
R6018 wind_comp_0.sg13g2_and2_2$1_0.VSS.n1835 wind_comp_0.sg13g2_and2_2$1_0.VSS.n1809 0.00888095
R6019 wind_comp_0.sg13g2_and2_2$1_0.VSS.n1834 wind_comp_0.sg13g2_and2_2$1_0.VSS.n1760 0.00888095
R6020 wind_comp_0.sg13g2_and2_2$1_0.VSS.n1833 wind_comp_0.sg13g2_and2_2$1_0.VSS.n1808 0.00888095
R6021 wind_comp_0.sg13g2_and2_2$1_0.VSS.n1832 wind_comp_0.sg13g2_and2_2$1_0.VSS.n1761 0.00888095
R6022 wind_comp_0.sg13g2_and2_2$1_0.VSS.n1831 wind_comp_0.sg13g2_and2_2$1_0.VSS.n1807 0.00888095
R6023 wind_comp_0.sg13g2_and2_2$1_0.VSS.n1830 wind_comp_0.sg13g2_and2_2$1_0.VSS.n1762 0.00888095
R6024 wind_comp_0.sg13g2_and2_2$1_0.VSS.n1829 wind_comp_0.sg13g2_and2_2$1_0.VSS.n1806 0.00888095
R6025 wind_comp_0.sg13g2_and2_2$1_0.VSS.n1828 wind_comp_0.sg13g2_and2_2$1_0.VSS.n1763 0.00888095
R6026 wind_comp_0.sg13g2_and2_2$1_0.VSS.n1827 wind_comp_0.sg13g2_and2_2$1_0.VSS.n1805 0.00888095
R6027 wind_comp_0.sg13g2_and2_2$1_0.VSS.n1826 wind_comp_0.sg13g2_and2_2$1_0.VSS.n1764 0.00888095
R6028 wind_comp_0.sg13g2_and2_2$1_0.VSS.n1825 wind_comp_0.sg13g2_and2_2$1_0.VSS.n1804 0.00888095
R6029 wind_comp_0.sg13g2_and2_2$1_0.VSS.n1824 wind_comp_0.sg13g2_and2_2$1_0.VSS.n1765 0.00888095
R6030 wind_comp_0.sg13g2_and2_2$1_0.VSS.n1823 wind_comp_0.sg13g2_and2_2$1_0.VSS.n1803 0.00888095
R6031 wind_comp_0.sg13g2_and2_2$1_0.VSS.n1822 wind_comp_0.sg13g2_and2_2$1_0.VSS.n1766 0.00888095
R6032 wind_comp_0.sg13g2_and2_2$1_0.VSS.n1821 wind_comp_0.sg13g2_and2_2$1_0.VSS.n1802 0.00888095
R6033 wind_comp_0.sg13g2_and2_2$1_0.VSS.n1820 wind_comp_0.sg13g2_and2_2$1_0.VSS.n1767 0.00888095
R6034 wind_comp_0.sg13g2_and2_2$1_0.VSS.n2563 wind_comp_0.sg13g2_and2_2$1_0.VSS.n1307 0.00886957
R6035 wind_comp_0.sg13g2_and2_2$1_0.VSS.n360 wind_comp_0.sg13g2_and2_2$1_0.VSS.n359 0.00517334
R6036 wind_comp_0.sg13g2_and2_2$1_0.VSS.n629 wind_comp_0.sg13g2_and2_2$1_0.VSS.n627 0.00885078
R6037 wind_comp_0.sg13g2_and2_2$1_0.VSS.n628 wind_comp_0.sg13g2_and2_2$1_0.VSS.n1960 0.00885078
R6038 wind_comp_0.sg13g2_and2_2$1_0.VSS.n284 wind_comp_0.sg13g2_and2_2$1_0.VSS.n283 0.00517334
R6039 wind_comp_0.sg13g2_and2_2$1_0.VSS.n398 wind_comp_0.sg13g2_and2_2$1_0.VSS.n397 0.00517334
R6040 wind_comp_0.sg13g2_and2_2$1_0.VSS.n2156 wind_comp_0.sg13g2_and2_2$1_0.VSS.n2155 0.00885078
R6041 wind_comp_0.sg13g2_and2_2$1_0.VSS.n2158 wind_comp_0.sg13g2_and2_2$1_0.VSS.n2157 0.00885078
R6042 wind_comp_0.sg13g2_and2_2$1_0.VSS.n2160 wind_comp_0.sg13g2_and2_2$1_0.VSS.n2159 0.00885078
R6043 wind_comp_0.sg13g2_and2_2$1_0.VSS.n2162 wind_comp_0.sg13g2_and2_2$1_0.VSS.n2161 0.00885078
R6044 wind_comp_0.sg13g2_and2_2$1_0.VSS.n2164 wind_comp_0.sg13g2_and2_2$1_0.VSS.n2163 0.00885078
R6045 wind_comp_0.sg13g2_and2_2$1_0.VSS.n2166 wind_comp_0.sg13g2_and2_2$1_0.VSS.n2165 0.00885078
R6046 wind_comp_0.sg13g2_and2_2$1_0.VSS.n2168 wind_comp_0.sg13g2_and2_2$1_0.VSS.n2167 0.00885078
R6047 wind_comp_0.sg13g2_and2_2$1_0.VSS.n2170 wind_comp_0.sg13g2_and2_2$1_0.VSS.n2169 0.00885078
R6048 wind_comp_0.sg13g2_and2_2$1_0.VSS.n2172 wind_comp_0.sg13g2_and2_2$1_0.VSS.n2171 0.00885078
R6049 wind_comp_0.sg13g2_and2_2$1_0.VSS.n2174 wind_comp_0.sg13g2_and2_2$1_0.VSS.n2173 0.00885078
R6050 wind_comp_0.sg13g2_and2_2$1_0.VSS.n2176 wind_comp_0.sg13g2_and2_2$1_0.VSS.n2175 0.00885078
R6051 wind_comp_0.sg13g2_and2_2$1_0.VSS.n2178 wind_comp_0.sg13g2_and2_2$1_0.VSS.n2177 0.00885078
R6052 wind_comp_0.sg13g2_and2_2$1_0.VSS.n2180 wind_comp_0.sg13g2_and2_2$1_0.VSS.n2179 0.00885078
R6053 wind_comp_0.sg13g2_and2_2$1_0.VSS.n2182 wind_comp_0.sg13g2_and2_2$1_0.VSS.n2181 0.00885078
R6054 wind_comp_0.sg13g2_and2_2$1_0.VSS.n2184 wind_comp_0.sg13g2_and2_2$1_0.VSS.n2183 0.00885078
R6055 wind_comp_0.sg13g2_and2_2$1_0.VSS.n2186 wind_comp_0.sg13g2_and2_2$1_0.VSS.n2185 0.00885078
R6056 wind_comp_0.sg13g2_and2_2$1_0.VSS.n2188 wind_comp_0.sg13g2_and2_2$1_0.VSS.n2187 0.00885078
R6057 wind_comp_0.sg13g2_and2_2$1_0.VSS.n2190 wind_comp_0.sg13g2_and2_2$1_0.VSS.n2189 0.00885078
R6058 wind_comp_0.sg13g2_and2_2$1_0.VSS.n2192 wind_comp_0.sg13g2_and2_2$1_0.VSS.n2191 0.00885078
R6059 wind_comp_0.sg13g2_and2_2$1_0.VSS.n2194 wind_comp_0.sg13g2_and2_2$1_0.VSS.n2193 0.00885078
R6060 wind_comp_0.sg13g2_and2_2$1_0.VSS.n2196 wind_comp_0.sg13g2_and2_2$1_0.VSS.n2195 0.00885078
R6061 wind_comp_0.sg13g2_and2_2$1_0.VSS.n2198 wind_comp_0.sg13g2_and2_2$1_0.VSS.n2197 0.00885078
R6062 wind_comp_0.sg13g2_and2_2$1_0.VSS.n2200 wind_comp_0.sg13g2_and2_2$1_0.VSS.n2199 0.00885078
R6063 wind_comp_0.sg13g2_and2_2$1_0.VSS.n2202 wind_comp_0.sg13g2_and2_2$1_0.VSS.n2201 0.00885078
R6064 wind_comp_0.sg13g2_and2_2$1_0.VSS.n2204 wind_comp_0.sg13g2_and2_2$1_0.VSS.n2203 0.00885078
R6065 wind_comp_0.sg13g2_and2_2$1_0.VSS.n2206 wind_comp_0.sg13g2_and2_2$1_0.VSS.n2205 0.00885078
R6066 wind_comp_0.sg13g2_and2_2$1_0.VSS.n2346 wind_comp_0.sg13g2_and2_2$1_0.VSS.n925 0.00885078
R6067 wind_comp_0.sg13g2_and2_2$1_0.VSS.n2381 wind_comp_0.sg13g2_and2_2$1_0.VSS.n2380 0.00885078
R6068 wind_comp_0.sg13g2_and2_2$1_0.VSS.n892 wind_comp_0.sg13g2_and2_2$1_0.VSS.n882 0.00874719
R6069 wind_comp_0.sg13g2_and2_2$1_0.VSS.n2092 wind_comp_0.sg13g2_and2_2$1_0.VSS.n693 0.0085734
R6070 wind_comp_0.sg13g2_and2_2$1_0.VSS.n2116 wind_comp_0.sg13g2_and2_2$1_0.VSS.n695 0.0085734
R6071 wind_comp_0.sg13g2_and2_2$1_0.VSS.n2114 wind_comp_0.sg13g2_and2_2$1_0.VSS.n2094 0.0085734
R6072 wind_comp_0.sg13g2_and2_2$1_0.VSS.n2093 wind_comp_0.sg13g2_and2_2$1_0.VSS.n692 0.0085734
R6073 wind_comp_0.sg13g2_and2_2$1_0.VSS.n2592 wind_comp_0.sg13g2_and2_2$1_0.VSS.n352 0.0085734
R6074 wind_comp_0.sg13g2_and2_2$1_0.VSS.n1885 wind_comp_0.sg13g2_and2_2$1_0.VSS.n18 0.126125
R6075 wind_comp_0.sg13g2_and2_2$1_0.VSS.n1884 wind_comp_0.sg13g2_and2_2$1_0.VSS.n863 0.0085734
R6076 wind_comp_0.sg13g2_and2_2$1_0.VSS.n1886 wind_comp_0.sg13g2_and2_2$1_0.VSS.n864 0.0085734
R6077 wind_comp_0.sg13g2_and2_2$1_0.VSS.n2226 wind_comp_0.sg13g2_and2_2$1_0.VSS.n866 0.0085734
R6078 wind_comp_0.sg13g2_and2_2$1_0.VSS.n2225 wind_comp_0.sg13g2_and2_2$1_0.VSS.n867 0.0085734
R6079 wind_comp_0.sg13g2_and2_2$1_0.VSS.n2047 wind_comp_0.sg13g2_and2_2$1_0.VSS.n2046 0.00856283
R6080 wind_comp_0.sg13g2_and2_2$1_0.VSS.n2133 wind_comp_0.sg13g2_and2_2$1_0.VSS.n1964 0.00856283
R6081 wind_comp_0.sg13g2_and2_2$1_0.VSS.n2383 wind_comp_0.sg13g2_and2_2$1_0.VSS.n1059 0.00848409
R6082 wind_comp_0.sg13g2_and2_2$1_0.VSS.n1457 wind_comp_0.sg13g2_and2_2$1_0.VSS.n1456 0.0084212
R6083 wind_comp_0.sg13g2_and2_2$1_0.VSS.n668 wind_comp_0.sg13g2_and2_2$1_0.VSS.n1693 0.0084212
R6084 wind_comp_0.sg13g2_and2_2$1_0.VSS.n931 wind_comp_0.sg13g2_and2_2$1_0.VSS.n659 0.00841885
R6085 wind_comp_0.sg13g2_and2_2$1_0.VSS.n933 wind_comp_0.sg13g2_and2_2$1_0.VSS.n613 0.00841885
R6086 wind_comp_0.sg13g2_and2_2$1_0.VSS.n612 wind_comp_0.sg13g2_and2_2$1_0.VSS.n911 0.00841885
R6087 wind_comp_0.sg13g2_and2_2$1_0.VSS.n287 wind_comp_0.sg13g2_and2_2$1_0.VSS.n286 0.00495758
R6088 wind_comp_0.sg13g2_and2_2$1_0.VSS.n355 wind_comp_0.sg13g2_and2_2$1_0.VSS.n354 0.0049585
R6089 wind_comp_0.sg13g2_and2_2$1_0.VSS.n2563 wind_comp_0.sg13g2_and2_2$1_0.VSS.n1308 0.00832034
R6090 wind_comp_0.sg13g2_and2_2$1_0.VSS.n2350 wind_comp_0.sg13g2_and2_2$1_0.VSS.n928 0.00827487
R6091 wind_comp_0.sg13g2_and2_2$1_0.VSS.n2427 wind_comp_0.sg13g2_and2_2$1_0.VSS.n930 0.00827487
R6092 wind_comp_0.sg13g2_and2_2$1_0.VSS.n2049 wind_comp_0.sg13g2_and2_2$1_0.VSS.n2048 0.00819614
R6093 wind_comp_0.sg13g2_and2_2$1_0.VSS.n2135 wind_comp_0.sg13g2_and2_2$1_0.VSS.n2134 0.00819614
R6094 wind_comp_0.sg13g2_and2_2$1_0.VSS.n1043 wind_comp_0.sg13g2_and2_2$1_0.VSS.n860 0.00816328
R6095 wind_comp_0.sg13g2_and2_2$1_0.VSS.n1046 wind_comp_0.sg13g2_and2_2$1_0.VSS.n861 0.00816328
R6096 wind_comp_0.sg13g2_and2_2$1_0.VSS.n1045 wind_comp_0.sg13g2_and2_2$1_0.VSS.n862 0.00816328
R6097 wind_comp_0.sg13g2_and2_2$1_0.VSS.n1047 wind_comp_0.sg13g2_and2_2$1_0.VSS.n21 0.0166536
R6098 wind_comp_0.sg13g2_and2_2$1_0.VSS.n1777 wind_comp_0.sg13g2_and2_2$1_0.VSS.n1726 0.00814479
R6099 wind_comp_0.sg13g2_and2_2$1_0.VSS.n1792 wind_comp_0.sg13g2_and2_2$1_0.VSS.n1747 0.00814479
R6100 wind_comp_0.sg13g2_and2_2$1_0.VSS.n1778 wind_comp_0.sg13g2_and2_2$1_0.VSS.n1725 0.00814479
R6101 wind_comp_0.sg13g2_and2_2$1_0.VSS.n1791 wind_comp_0.sg13g2_and2_2$1_0.VSS.n1748 0.00814479
R6102 wind_comp_0.sg13g2_and2_2$1_0.VSS.n1779 wind_comp_0.sg13g2_and2_2$1_0.VSS.n1724 0.00814479
R6103 wind_comp_0.sg13g2_and2_2$1_0.VSS.n1790 wind_comp_0.sg13g2_and2_2$1_0.VSS.n1749 0.00814479
R6104 wind_comp_0.sg13g2_and2_2$1_0.VSS.n1780 wind_comp_0.sg13g2_and2_2$1_0.VSS.n1723 0.00814479
R6105 wind_comp_0.sg13g2_and2_2$1_0.VSS.n1789 wind_comp_0.sg13g2_and2_2$1_0.VSS.n1750 0.00814479
R6106 wind_comp_0.sg13g2_and2_2$1_0.VSS.n1781 wind_comp_0.sg13g2_and2_2$1_0.VSS.n1722 0.00814479
R6107 wind_comp_0.sg13g2_and2_2$1_0.VSS.n1788 wind_comp_0.sg13g2_and2_2$1_0.VSS.n1751 0.00814479
R6108 wind_comp_0.sg13g2_and2_2$1_0.VSS.n1782 wind_comp_0.sg13g2_and2_2$1_0.VSS.n1721 0.00814479
R6109 wind_comp_0.sg13g2_and2_2$1_0.VSS.n1787 wind_comp_0.sg13g2_and2_2$1_0.VSS.n1752 0.00814479
R6110 wind_comp_0.sg13g2_and2_2$1_0.VSS.n1783 wind_comp_0.sg13g2_and2_2$1_0.VSS.n1720 0.00814479
R6111 wind_comp_0.sg13g2_and2_2$1_0.VSS.n2519 wind_comp_0.sg13g2_and2_2$1_0.VSS.n2518 0.00814479
R6112 wind_comp_0.sg13g2_and2_2$1_0.VSS.n609 wind_comp_0.sg13g2_and2_2$1_0.VSS.n1719 0.00814479
R6113 wind_comp_0.sg13g2_and2_2$1_0.VSS.n660 wind_comp_0.sg13g2_and2_2$1_0.VSS.n658 0.00813089
R6114 wind_comp_0.sg13g2_and2_2$1_0.VSS.n664 wind_comp_0.sg13g2_and2_2$1_0.VSS.n663 0.00813089
R6115 wind_comp_0.sg13g2_and2_2$1_0.VSS.n1850 wind_comp_0.sg13g2_and2_2$1_0.VSS.n188 0.0110922
R6116 wind_comp_0.sg13g2_and2_2$1_0.VSS.n1849 wind_comp_0.sg13g2_and2_2$1_0.VSS.n1848 0.00809259
R6117 wind_comp_0.sg13g2_and2_2$1_0.VSS.n670 wind_comp_0.sg13g2_and2_2$1_0.VSS.n669 0.00801334
R6118 wind_comp_0.sg13g2_and2_2$1_0.VSS.n2136 wind_comp_0.sg13g2_and2_2$1_0.VSS.n2135 0.00798691
R6119 wind_comp_0.sg13g2_and2_2$1_0.VSS.n2011 wind_comp_0.sg13g2_and2_2$1_0.VSS.n768 0.00792616
R6120 wind_comp_0.sg13g2_and2_2$1_0.VSS.n2012 wind_comp_0.sg13g2_and2_2$1_0.VSS.n769 0.00792616
R6121 wind_comp_0.sg13g2_and2_2$1_0.VSS.n2017 wind_comp_0.sg13g2_and2_2$1_0.VSS.n770 0.00792616
R6122 wind_comp_0.sg13g2_and2_2$1_0.VSS.n2016 wind_comp_0.sg13g2_and2_2$1_0.VSS.n771 0.00792616
R6123 wind_comp_0.sg13g2_and2_2$1_0.VSS.n670 wind_comp_0.sg13g2_and2_2$1_0.VSS.n668 0.0079087
R6124 wind_comp_0.sg13g2_and2_2$1_0.VSS.n2350 wind_comp_0.sg13g2_and2_2$1_0.VSS.n929 0.00790818
R6125 wind_comp_0.sg13g2_and2_2$1_0.VSS.n2427 wind_comp_0.sg13g2_and2_2$1_0.VSS.n929 0.00790818
R6126 wind_comp_0.sg13g2_and2_2$1_0.VSS.n1325 wind_comp_0.sg13g2_and2_2$1_0.VSS.n754 0.00789594
R6127 wind_comp_0.sg13g2_and2_2$1_0.VSS.n955 wind_comp_0.sg13g2_and2_2$1_0.VSS.n615 0.00784293
R6128 wind_comp_0.sg13g2_and2_2$1_0.VSS.n614 wind_comp_0.sg13g2_and2_2$1_0.VSS.n916 0.00784293
R6129 wind_comp_0.sg13g2_and2_2$1_0.VSS.n962 wind_comp_0.sg13g2_and2_2$1_0.VSS.n665 0.00784293
R6130 wind_comp_0.sg13g2_and2_2$1_0.VSS.n290 wind_comp_0.sg13g2_and2_2$1_0.VSS.n289 0.00466988
R6131 wind_comp_0.sg13g2_and2_2$1_0.VSS.n1034 wind_comp_0.sg13g2_and2_2$1_0.VSS.n838 0.00770191
R6132 wind_comp_0.sg13g2_and2_2$1_0.VSS.n2383 wind_comp_0.sg13g2_and2_2$1_0.VSS.n1058 0.00769895
R6133 wind_comp_0.sg13g2_and2_2$1_0.VSS.n1457 wind_comp_0.comparator_0.sg13cmos5l_inv_16_1.VSS 0.00767391
R6134 wind_comp_0.sg13g2_and2_2$1_0.VSS.n1705 wind_comp_0.sg13g2_and2_2$1_0.VSS.n879 0.00766115
R6135 wind_comp_0.sg13g2_and2_2$1_0.VSS.n2048 wind_comp_0.sg13g2_and2_2$1_0.VSS.n2047 0.00762022
R6136 wind_comp_0.sg13g2_and2_2$1_0.VSS.n2134 wind_comp_0.sg13g2_and2_2$1_0.VSS.n2133 0.00762022
R6137 wind_comp_0.sg13g2_and2_2$1_0.VSS.n2148 wind_comp_0.sg13g2_and2_2$1_0.VSS.n2147 0.00741099
R6138 wind_comp_0.sg13g2_and2_2$1_0.VSS.n2516 wind_comp_0.sg13g2_and2_2$1_0.VSS.n1194 0.00741099
R6139 wind_comp_0.sg13g2_and2_2$1_0.VSS.n2515 wind_comp_0.sg13g2_and2_2$1_0.VSS.n1193 0.00741099
R6140 wind_comp_0.sg13g2_and2_2$1_0.VSS.n2514 wind_comp_0.sg13g2_and2_2$1_0.VSS.n1190 0.00741099
R6141 wind_comp_0.sg13g2_and2_2$1_0.VSS.n2513 wind_comp_0.sg13g2_and2_2$1_0.VSS.n1189 0.00741099
R6142 wind_comp_0.sg13g2_and2_2$1_0.VSS.n2512 wind_comp_0.sg13g2_and2_2$1_0.VSS.n1186 0.00741099
R6143 wind_comp_0.sg13g2_and2_2$1_0.VSS.n2511 wind_comp_0.sg13g2_and2_2$1_0.VSS.n1185 0.00741099
R6144 wind_comp_0.sg13g2_and2_2$1_0.VSS.n2510 wind_comp_0.sg13g2_and2_2$1_0.VSS.n1182 0.00741099
R6145 wind_comp_0.sg13g2_and2_2$1_0.VSS.n2509 wind_comp_0.sg13g2_and2_2$1_0.VSS.n1181 0.00741099
R6146 wind_comp_0.sg13g2_and2_2$1_0.VSS.n2508 wind_comp_0.sg13g2_and2_2$1_0.VSS.n1178 0.00741099
R6147 wind_comp_0.sg13g2_and2_2$1_0.VSS.n2507 wind_comp_0.sg13g2_and2_2$1_0.VSS.n1177 0.00741099
R6148 wind_comp_0.sg13g2_and2_2$1_0.VSS.n2506 wind_comp_0.sg13g2_and2_2$1_0.VSS.n1174 0.00741099
R6149 wind_comp_0.sg13g2_and2_2$1_0.VSS.n2505 wind_comp_0.sg13g2_and2_2$1_0.VSS.n1173 0.00741099
R6150 wind_comp_0.sg13g2_and2_2$1_0.VSS.n2504 wind_comp_0.sg13g2_and2_2$1_0.VSS.n1170 0.00741099
R6151 wind_comp_0.sg13g2_and2_2$1_0.VSS.n2503 wind_comp_0.sg13g2_and2_2$1_0.VSS.n1169 0.00741099
R6152 wind_comp_0.sg13g2_and2_2$1_0.VSS.n2502 wind_comp_0.sg13g2_and2_2$1_0.VSS.n1166 0.00741099
R6153 wind_comp_0.sg13g2_and2_2$1_0.VSS.n2501 wind_comp_0.sg13g2_and2_2$1_0.VSS.n1165 0.00741099
R6154 wind_comp_0.sg13g2_and2_2$1_0.VSS.n2500 wind_comp_0.sg13g2_and2_2$1_0.VSS.n1162 0.00741099
R6155 wind_comp_0.sg13g2_and2_2$1_0.VSS.n2499 wind_comp_0.sg13g2_and2_2$1_0.VSS.n1161 0.00741099
R6156 wind_comp_0.sg13g2_and2_2$1_0.VSS.n2498 wind_comp_0.sg13g2_and2_2$1_0.VSS.n1158 0.00741099
R6157 wind_comp_0.sg13g2_and2_2$1_0.VSS.n2497 wind_comp_0.sg13g2_and2_2$1_0.VSS.n1157 0.00741099
R6158 wind_comp_0.sg13g2_and2_2$1_0.VSS.n2496 wind_comp_0.sg13g2_and2_2$1_0.VSS.n1154 0.00741099
R6159 wind_comp_0.sg13g2_and2_2$1_0.VSS.n2495 wind_comp_0.sg13g2_and2_2$1_0.VSS.n1153 0.00741099
R6160 wind_comp_0.sg13g2_and2_2$1_0.VSS.n2494 wind_comp_0.sg13g2_and2_2$1_0.VSS.n1150 0.00741099
R6161 wind_comp_0.sg13g2_and2_2$1_0.VSS.n2493 wind_comp_0.sg13g2_and2_2$1_0.VSS.n1149 0.00741099
R6162 wind_comp_0.sg13g2_and2_2$1_0.VSS.n2492 wind_comp_0.sg13g2_and2_2$1_0.VSS.n1146 0.00741099
R6163 wind_comp_0.sg13g2_and2_2$1_0.VSS.n2491 wind_comp_0.sg13g2_and2_2$1_0.VSS.n1145 0.00741099
R6164 wind_comp_0.sg13g2_and2_2$1_0.VSS.n2490 wind_comp_0.sg13g2_and2_2$1_0.VSS.n1142 0.00741099
R6165 wind_comp_0.sg13g2_and2_2$1_0.VSS.n2489 wind_comp_0.sg13g2_and2_2$1_0.VSS.n1141 0.00741099
R6166 wind_comp_0.sg13g2_and2_2$1_0.VSS.n2488 wind_comp_0.sg13g2_and2_2$1_0.VSS.n1139 0.00741099
R6167 wind_comp_0.sg13g2_and2_2$1_0.VSS.n2487 wind_comp_0.sg13g2_and2_2$1_0.VSS.n1137 0.00741099
R6168 wind_comp_0.sg13g2_and2_2$1_0.VSS.n2486 wind_comp_0.sg13g2_and2_2$1_0.VSS.n1134 0.00741099
R6169 wind_comp_0.sg13g2_and2_2$1_0.VSS.n2485 wind_comp_0.sg13g2_and2_2$1_0.VSS.n1133 0.00741099
R6170 wind_comp_0.sg13g2_and2_2$1_0.VSS.n2484 wind_comp_0.sg13g2_and2_2$1_0.VSS.n1130 0.00741099
R6171 wind_comp_0.sg13g2_and2_2$1_0.VSS.n2483 wind_comp_0.sg13g2_and2_2$1_0.VSS.n1129 0.00741099
R6172 wind_comp_0.sg13g2_and2_2$1_0.VSS.n2482 wind_comp_0.sg13g2_and2_2$1_0.VSS.n1126 0.00741099
R6173 wind_comp_0.sg13g2_and2_2$1_0.VSS.n2481 wind_comp_0.sg13g2_and2_2$1_0.VSS.n1125 0.00741099
R6174 wind_comp_0.sg13g2_and2_2$1_0.VSS.n2480 wind_comp_0.sg13g2_and2_2$1_0.VSS.n1122 0.00741099
R6175 wind_comp_0.sg13g2_and2_2$1_0.VSS.n2479 wind_comp_0.sg13g2_and2_2$1_0.VSS.n1121 0.00741099
R6176 wind_comp_0.sg13g2_and2_2$1_0.VSS.n2207 wind_comp_0.sg13g2_and2_2$1_0.VSS.n2206 0.00733226
R6177 wind_comp_0.sg13g2_and2_2$1_0.VSS.n2381 wind_comp_0.sg13g2_and2_2$1_0.VSS.n1059 0.00733226
R6178 wind_comp_0.sg13g2_and2_2$1_0.VSS.n454 wind_comp_0.sg13g2_and2_2$1_0.VSS.n772 0.0130659
R6179 wind_comp_0.sg13g2_and2_2$1_0.VSS.n2018 wind_comp_0.sg13g2_and2_2$1_0.VSS.n773 0.00730731
R6180 wind_comp_0.sg13g2_and2_2$1_0.VSS.n1588 wind_comp_0.sg13g2_and2_2$1_0.VSS.n1577 0.00722554
R6181 wind_comp_0.sg13g2_and2_2$1_0.VSS.n2128 wind_comp_0.sg13g2_and2_2$1_0.VSS.n1966 0.00712304
R6182 wind_comp_0.sg13g2_and2_2$1_0.VSS.n2417 wind_comp_0.sg13g2_and2_2$1_0.VSS.n937 0.00712304
R6183 wind_comp_0.sg13g2_and2_2$1_0.VSS.n2374 wind_comp_0.sg13g2_and2_2$1_0.VSS.n1058 0.00712304
R6184 wind_comp_0.sg13g2_and2_2$1_0.VSS.n1513 wind_comp_0.sg13g2_and2_2$1_0.VSS.n616 0.0145976
R6185 wind_comp_0.sg13g2_and2_2$1_0.VSS.n1643 wind_comp_0.sg13g2_and2_2$1_0.VSS.n618 0.0145976
R6186 wind_comp_0.sg13g2_and2_2$1_0.VSS.n2407 wind_comp_0.sg13g2_and2_2$1_0.VSS.n914 0.00697906
R6187 wind_comp_0.sg13g2_and2_2$1_0.VSS.n1479 wind_comp_0.sg13g2_and2_2$1_0.VSS.n1435 0.00692663
R6188 wind_comp_0.sg13g2_and2_2$1_0.VSS.n1676 wind_comp_0.sg13g2_and2_2$1_0.VSS.n1673 0.00692663
R6189 wind_comp_0.sg13g2_and2_2$1_0.VSS.n985 wind_comp_0.sg13g2_and2_2$1_0.VSS.n839 0.00688607
R6190 wind_comp_0.sg13g2_and2_2$1_0.VSS.n984 wind_comp_0.sg13g2_and2_2$1_0.VSS.n840 0.00688607
R6191 wind_comp_0.sg13g2_and2_2$1_0.VSS.n983 wind_comp_0.sg13g2_and2_2$1_0.VSS.n841 0.00688607
R6192 wind_comp_0.sg13g2_and2_2$1_0.VSS.n982 wind_comp_0.sg13g2_and2_2$1_0.VSS.n842 0.00688607
R6193 wind_comp_0.sg13g2_and2_2$1_0.VSS.n981 wind_comp_0.sg13g2_and2_2$1_0.VSS.n843 0.00688607
R6194 wind_comp_0.sg13g2_and2_2$1_0.VSS.n980 wind_comp_0.sg13g2_and2_2$1_0.VSS.n844 0.00688607
R6195 wind_comp_0.sg13g2_and2_2$1_0.VSS.n163 wind_comp_0.sg13g2_and2_2$1_0.VSS.n162 0.00419183
R6196 wind_comp_0.sg13g2_and2_2$1_0.VSS.n979 wind_comp_0.sg13g2_and2_2$1_0.VSS.n845 0.00688607
R6197 wind_comp_0.sg13g2_and2_2$1_0.VSS.n978 wind_comp_0.sg13g2_and2_2$1_0.VSS.n846 0.00688607
R6198 wind_comp_0.sg13g2_and2_2$1_0.VSS.n905 wind_comp_0.sg13g2_and2_2$1_0.VSS.n847 0.00688607
R6199 wind_comp_0.sg13g2_and2_2$1_0.VSS.n906 wind_comp_0.sg13g2_and2_2$1_0.VSS.n848 0.00688607
R6200 wind_comp_0.sg13g2_and2_2$1_0.VSS.n904 wind_comp_0.sg13g2_and2_2$1_0.VSS.n849 0.00688607
R6201 wind_comp_0.sg13g2_and2_2$1_0.VSS.n1050 wind_comp_0.sg13g2_and2_2$1_0.VSS.n850 0.00688607
R6202 wind_comp_0.sg13g2_and2_2$1_0.VSS.n1038 wind_comp_0.sg13g2_and2_2$1_0.VSS.n852 0.00688607
R6203 wind_comp_0.sg13g2_and2_2$1_0.VSS.n1037 wind_comp_0.sg13g2_and2_2$1_0.VSS.n853 0.00688607
R6204 wind_comp_0.sg13g2_and2_2$1_0.VSS.n1040 wind_comp_0.sg13g2_and2_2$1_0.VSS.n854 0.00688607
R6205 wind_comp_0.sg13g2_and2_2$1_0.VSS.n1039 wind_comp_0.sg13g2_and2_2$1_0.VSS.n855 0.00688607
R6206 wind_comp_0.sg13g2_and2_2$1_0.VSS.n1042 wind_comp_0.sg13g2_and2_2$1_0.VSS.n856 0.00688607
R6207 wind_comp_0.sg13g2_and2_2$1_0.VSS.n1041 wind_comp_0.sg13g2_and2_2$1_0.VSS.n857 0.00688607
R6208 wind_comp_0.sg13g2_and2_2$1_0.VSS.n1044 wind_comp_0.sg13g2_and2_2$1_0.VSS.n858 0.00688607
R6209 wind_comp_0.sg13g2_and2_2$1_0.VSS.n1311 wind_comp_0.sg13g2_and2_2$1_0.VSS.n752 0.00686886
R6210 wind_comp_0.sg13g2_and2_2$1_0.VSS.n733 wind_comp_0.sg13g2_and2_2$1_0.VSS.n732 0.00684338
R6211 wind_comp_0.sg13g2_and2_2$1_0.VSS.n2591 wind_comp_0.sg13g2_and2_2$1_0.VSS.n2590 0.00684338
R6212 wind_comp_0.sg13g2_and2_2$1_0.VSS.n2326 wind_comp_0.sg13g2_and2_2$1_0.VSS.n873 0.00684338
R6213 wind_comp_0.sg13g2_and2_2$1_0.VSS.n1785 wind_comp_0.sg13g2_and2_2$1_0.VSS.n874 0.00684338
R6214 wind_comp_0.sg13g2_and2_2$1_0.VSS.n2137 wind_comp_0.sg13g2_and2_2$1_0.VSS.n2136 0.00683508
R6215 wind_comp_0.sg13g2_and2_2$1_0.VSS.n1334 wind_comp_0.sg13g2_and2_2$1_0.VSS.n756 0.00675146
R6216 wind_comp_0.sg13g2_and2_2$1_0.VSS.n1334 wind_comp_0.sg13g2_and2_2$1_0.VSS.n250 0.0153351
R6217 wind_comp_0.sg13g2_and2_2$1_0.VSS.n2003 wind_comp_0.sg13g2_and2_2$1_0.VSS.n797 0.00668847
R6218 wind_comp_0.sg13g2_and2_2$1_0.VSS.n2005 wind_comp_0.sg13g2_and2_2$1_0.VSS.n796 0.00668847
R6219 wind_comp_0.sg13g2_and2_2$1_0.VSS.n2004 wind_comp_0.sg13g2_and2_2$1_0.VSS.n795 0.00668847
R6220 wind_comp_0.sg13g2_and2_2$1_0.VSS.n2008 wind_comp_0.sg13g2_and2_2$1_0.VSS.n794 0.00668847
R6221 wind_comp_0.sg13g2_and2_2$1_0.VSS.n2006 wind_comp_0.sg13g2_and2_2$1_0.VSS.n793 0.00668847
R6222 wind_comp_0.sg13g2_and2_2$1_0.VSS.n2007 wind_comp_0.sg13g2_and2_2$1_0.VSS.n792 0.00668847
R6223 wind_comp_0.sg13g2_and2_2$1_0.VSS.n168 wind_comp_0.sg13g2_and2_2$1_0.VSS.n167 0.00409311
R6224 wind_comp_0.sg13g2_and2_2$1_0.VSS.n1979 wind_comp_0.sg13g2_and2_2$1_0.VSS.n791 0.00668847
R6225 wind_comp_0.sg13g2_and2_2$1_0.VSS.n1982 wind_comp_0.sg13g2_and2_2$1_0.VSS.n790 0.00668847
R6226 wind_comp_0.sg13g2_and2_2$1_0.VSS.n1981 wind_comp_0.sg13g2_and2_2$1_0.VSS.n757 0.00668847
R6227 wind_comp_0.sg13g2_and2_2$1_0.VSS.n1980 wind_comp_0.sg13g2_and2_2$1_0.VSS.n758 0.00668847
R6228 wind_comp_0.sg13g2_and2_2$1_0.VSS.n2024 wind_comp_0.sg13g2_and2_2$1_0.VSS.n759 0.00668847
R6229 wind_comp_0.sg13g2_and2_2$1_0.VSS.n216 wind_comp_0.sg13g2_and2_2$1_0.VSS.n215 0.00409311
R6230 wind_comp_0.sg13g2_and2_2$1_0.VSS.n1977 wind_comp_0.sg13g2_and2_2$1_0.VSS.n760 0.00668847
R6231 wind_comp_0.sg13g2_and2_2$1_0.VSS.n1978 wind_comp_0.sg13g2_and2_2$1_0.VSS.n761 0.00668847
R6232 wind_comp_0.sg13g2_and2_2$1_0.VSS.n2009 wind_comp_0.sg13g2_and2_2$1_0.VSS.n762 0.00668847
R6233 wind_comp_0.sg13g2_and2_2$1_0.VSS.n2010 wind_comp_0.sg13g2_and2_2$1_0.VSS.n763 0.00668847
R6234 wind_comp_0.sg13g2_and2_2$1_0.VSS.n2014 wind_comp_0.sg13g2_and2_2$1_0.VSS.n764 0.00668847
R6235 wind_comp_0.sg13g2_and2_2$1_0.VSS.n2013 wind_comp_0.sg13g2_and2_2$1_0.VSS.n765 0.00668847
R6236 wind_comp_0.sg13g2_and2_2$1_0.VSS.n2015 wind_comp_0.sg13g2_and2_2$1_0.VSS.n766 0.00668847
R6237 wind_comp_0.sg13g2_and2_2$1_0.VSS.n2425 wind_comp_0.sg13g2_and2_2$1_0.VSS.n930 0.00654712
R6238 wind_comp_0.sg13g2_and2_2$1_0.VSS.n2397 wind_comp_0.sg13g2_and2_2$1_0.VSS.n959 0.00654712
R6239 wind_comp_0.sg13g2_and2_2$1_0.VSS.n1351 wind_comp_0.sg13g2_and2_2$1_0.VSS.n1350 0.00654622
R6240 wind_comp_0.sg13g2_and2_2$1_0.VSS.n1319 wind_comp_0.sg13g2_and2_2$1_0.VSS.n755 0.0063698
R6241 wind_comp_0.sg13g2_and2_2$1_0.VSS.n237 wind_comp_0.sg13g2_and2_2$1_0.VSS.n235 0.00388287
R6242 wind_comp_0.sg13g2_and2_2$1_0.VSS.n748 wind_comp_0.sg13g2_and2_2$1_0.VSS.n747 0.00626671
R6243 wind_comp_0.sg13g2_and2_2$1_0.VSS.n746 wind_comp_0.sg13g2_and2_2$1_0.VSS.n745 0.00626671
R6244 wind_comp_0.sg13g2_and2_2$1_0.VSS.n744 wind_comp_0.sg13g2_and2_2$1_0.VSS.n743 0.00626671
R6245 wind_comp_0.sg13g2_and2_2$1_0.VSS.n226 wind_comp_0.sg13g2_and2_2$1_0.VSS.n225 0.00388287
R6246 wind_comp_0.sg13g2_and2_2$1_0.VSS.n1881 wind_comp_0.sg13g2_and2_2$1_0.VSS.n869 0.00626671
R6247 wind_comp_0.sg13g2_and2_2$1_0.VSS.n1882 wind_comp_0.sg13g2_and2_2$1_0.VSS.n870 0.00626671
R6248 wind_comp_0.sg13g2_and2_2$1_0.VSS.n2325 wind_comp_0.sg13g2_and2_2$1_0.VSS.n871 0.00626671
R6249 wind_comp_0.sg13g2_and2_2$1_0.VSS.n222 wind_comp_0.sg13g2_and2_2$1_0.VSS.n221 0.00388287
R6250 wind_comp_0.sg13g2_and2_2$1_0.VSS.n2046 wind_comp_0.sg13g2_and2_2$1_0.VSS.n2045 0.00625916
R6251 wind_comp_0.sg13g2_and2_2$1_0.VSS.n2130 wind_comp_0.sg13g2_and2_2$1_0.VSS.n1964 0.00625916
R6252 wind_comp_0.sg13g2_and2_2$1_0.VSS.n1019 wind_comp_0.sg13g2_and2_2$1_0.VSS.n1018 0.00624746
R6253 wind_comp_0.sg13g2_and2_2$1_0.VSS.n1027 wind_comp_0.sg13g2_and2_2$1_0.VSS.n1026 0.00624746
R6254 wind_comp_0.sg13g2_and2_2$1_0.VSS.n2208 wind_comp_0.sg13g2_and2_2$1_0.VSS.n2207 0.00618043
R6255 wind_comp_0.sg13g2_and2_2$1_0.VSS.n2434 wind_comp_0.sg13g2_and2_2$1_0.VSS.n927 0.00618043
R6256 wind_comp_0.sg13g2_and2_2$1_0.VSS.n1486 wind_comp_0.sg13g2_and2_2$1_0.VSS.n1435 0.00617935
R6257 wind_comp_0.sg13g2_and2_2$1_0.VSS.n1402 wind_comp_0.sg13g2_and2_2$1_0.VSS.n1276 0.00617935
R6258 wind_comp_0.sg13g2_and2_2$1_0.VSS.n1653 wind_comp_0.sg13g2_and2_2$1_0.VSS.n1594 0.00617935
R6259 wind_comp_0.sg13g2_and2_2$1_0.VSS.n1676 wind_comp_0.sg13g2_and2_2$1_0.VSS.n1675 0.00617935
R6260 wind_comp_0.sg13g2_and2_2$1_0.VSS.n2591 wind_comp_0.sg13g2_and2_2$1_0.VSS.n245 0.00613217
R6261 wind_comp_0.sg13g2_and2_2$1_0.VSS.n2029 wind_comp_0.sg13g2_and2_2$1_0.VSS.n2028 0.00611518
R6262 wind_comp_0.sg13g2_and2_2$1_0.VSS.n219 wind_comp_0.sg13g2_and2_2$1_0.VSS.n218 0.00380666
R6263 wind_comp_0.sg13g2_and2_2$1_0.VSS.n242 wind_comp_0.sg13g2_and2_2$1_0.VSS.n241 0.00380666
R6264 wind_comp_0.sg13g2_and2_2$1_0.VSS.n2030 wind_comp_0.sg13g2_and2_2$1_0.VSS.n1972 0.00611518
R6265 wind_comp_0.sg13g2_and2_2$1_0.VSS.n2065 wind_comp_0.sg13g2_and2_2$1_0.VSS.n2032 0.00611518
R6266 wind_comp_0.sg13g2_and2_2$1_0.VSS.n674 wind_comp_0.sg13g2_and2_2$1_0.VSS.n672 0.00611518
R6267 wind_comp_0.sg13g2_and2_2$1_0.VSS.n673 wind_comp_0.sg13g2_and2_2$1_0.VSS.n1970 0.00611518
R6268 wind_comp_0.sg13g2_and2_2$1_0.VSS.n2072 wind_comp_0.sg13g2_and2_2$1_0.VSS.n2033 0.00611518
R6269 wind_comp_0.sg13g2_and2_2$1_0.VSS.n1996 wind_comp_0.sg13g2_and2_2$1_0.VSS.n1995 0.00606962
R6270 wind_comp_0.sg13g2_and2_2$1_0.VSS.n1784 wind_comp_0.sg13g2_and2_2$1_0.VSS.n875 0.00604023
R6271 wind_comp_0.sg13g2_and2_2$1_0.VSS.n1375 wind_comp_0.sg13g2_and2_2$1_0.VSS.n1354 0.006
R6272 wind_comp_0.sg13g2_and2_2$1_0.VSS.n2128 wind_comp_0.sg13g2_and2_2$1_0.VSS.n2127 0.00597838
R6273 wind_comp_0.sg13g2_and2_2$1_0.VSS.n2431 wind_comp_0.sg13g2_and2_2$1_0.VSS.n2224 0.00597838
R6274 wind_comp_0.sg13g2_and2_2$1_0.VSS.n2145 wind_comp_0.sg13g2_and2_2$1_0.VSS.n1961 0.0059712
R6275 wind_comp_0.sg13g2_and2_2$1_0.VSS.n2436 wind_comp_0.sg13g2_and2_2$1_0.VSS.n925 0.0059712
R6276 wind_comp_0.sg13g2_and2_2$1_0.VSS.n2405 wind_comp_0.sg13g2_and2_2$1_0.VSS.n950 0.0059712
R6277 wind_comp_0.sg13g2_and2_2$1_0.VSS.n2105 wind_comp_0.sg13g2_and2_2$1_0.VSS.n28 0.0180227
R6278 wind_comp_0.sg13g2_and2_2$1_0.VSS.n2127 wind_comp_0.sg13g2_and2_2$1_0.VSS.n621 0.00590029
R6279 wind_comp_0.sg13g2_and2_2$1_0.VSS.n2224 wind_comp_0.sg13g2_and2_2$1_0.VSS.n625 0.00590029
R6280 wind_comp_0.sg13g2_and2_2$1_0.VSS.n2041 wind_comp_0.sg13g2_and2_2$1_0.VSS.n1966 0.00589247
R6281 wind_comp_0.sg13g2_and2_2$1_0.VSS.n2419 wind_comp_0.sg13g2_and2_2$1_0.VSS.n912 0.00582723
R6282 wind_comp_0.sg13g2_and2_2$1_0.VSS.n2399 wind_comp_0.sg13g2_and2_2$1_0.VSS.n917 0.00582723
R6283 wind_comp_0.sg13g2_and2_2$1_0.VSS.n128 wind_comp_0.sg13g2_and2_2$1_0.VSS.n52 0.638816
R6284 wind_comp_0.sg13g2_and2_2$1_0.VSS.n2106 wind_comp_0.sg13g2_and2_2$1_0.VSS.n610 0.00569004
R6285 wind_comp_0.sg13g2_and2_2$1_0.VSS.n2117 wind_comp_0.sg13g2_and2_2$1_0.VSS.n694 0.00569004
R6286 wind_comp_0.sg13g2_and2_2$1_0.VSS.n739 wind_comp_0.sg13g2_and2_2$1_0.VSS.n738 0.00569004
R6287 wind_comp_0.sg13g2_and2_2$1_0.VSS.n16 wind_comp_0.sg13g2_and2_2$1_0.VSS.n623 0.00569004
R6288 wind_comp_0.sg13g2_and2_2$1_0.VSS.n2337 wind_comp_0.sg13g2_and2_2$1_0.VSS.n2336 0.00569004
R6289 wind_comp_0.sg13g2_and2_2$1_0.VSS.n240 wind_comp_0.sg13g2_and2_2$1_0.VSS.n611 0.00568325
R6290 wind_comp_0.sg13g2_and2_2$1_0.VSS.n2152 wind_comp_0.sg13g2_and2_2$1_0.VSS.n2151 0.00568325
R6291 wind_comp_0.sg13g2_and2_2$1_0.VSS.n2478 wind_comp_0.sg13g2_and2_2$1_0.VSS.n1118 0.00568325
R6292 wind_comp_0.sg13g2_and2_2$1_0.VSS.n2477 wind_comp_0.sg13g2_and2_2$1_0.VSS.n1117 0.00568325
R6293 wind_comp_0.sg13g2_and2_2$1_0.VSS.n2476 wind_comp_0.sg13g2_and2_2$1_0.VSS.n1114 0.00568325
R6294 wind_comp_0.sg13g2_and2_2$1_0.VSS.n2475 wind_comp_0.sg13g2_and2_2$1_0.VSS.n1113 0.00568325
R6295 wind_comp_0.sg13g2_and2_2$1_0.VSS.n2474 wind_comp_0.sg13g2_and2_2$1_0.VSS.n1110 0.00568325
R6296 wind_comp_0.sg13g2_and2_2$1_0.VSS.n2473 wind_comp_0.sg13g2_and2_2$1_0.VSS.n1109 0.00568325
R6297 wind_comp_0.sg13g2_and2_2$1_0.VSS.n2472 wind_comp_0.sg13g2_and2_2$1_0.VSS.n1106 0.00568325
R6298 wind_comp_0.sg13g2_and2_2$1_0.VSS.n2471 wind_comp_0.sg13g2_and2_2$1_0.VSS.n1105 0.00568325
R6299 wind_comp_0.sg13g2_and2_2$1_0.VSS.n2470 wind_comp_0.sg13g2_and2_2$1_0.VSS.n1102 0.00568325
R6300 wind_comp_0.sg13g2_and2_2$1_0.VSS.n2469 wind_comp_0.sg13g2_and2_2$1_0.VSS.n1101 0.00568325
R6301 wind_comp_0.sg13g2_and2_2$1_0.VSS.n2468 wind_comp_0.sg13g2_and2_2$1_0.VSS.n1098 0.00568325
R6302 wind_comp_0.sg13g2_and2_2$1_0.VSS.n2467 wind_comp_0.sg13g2_and2_2$1_0.VSS.n1097 0.00568325
R6303 wind_comp_0.sg13g2_and2_2$1_0.VSS.n2466 wind_comp_0.sg13g2_and2_2$1_0.VSS.n1094 0.00568325
R6304 wind_comp_0.sg13g2_and2_2$1_0.VSS.n2465 wind_comp_0.sg13g2_and2_2$1_0.VSS.n1093 0.00568325
R6305 wind_comp_0.sg13g2_and2_2$1_0.VSS.n2464 wind_comp_0.sg13g2_and2_2$1_0.VSS.n1091 0.00568325
R6306 wind_comp_0.sg13g2_and2_2$1_0.VSS.n2463 wind_comp_0.sg13g2_and2_2$1_0.VSS.n1089 0.00568325
R6307 wind_comp_0.sg13g2_and2_2$1_0.VSS.n2462 wind_comp_0.sg13g2_and2_2$1_0.VSS.n1086 0.00568325
R6308 wind_comp_0.sg13g2_and2_2$1_0.VSS.n2461 wind_comp_0.sg13g2_and2_2$1_0.VSS.n1085 0.00568325
R6309 wind_comp_0.sg13g2_and2_2$1_0.VSS.n2460 wind_comp_0.sg13g2_and2_2$1_0.VSS.n1082 0.00568325
R6310 wind_comp_0.sg13g2_and2_2$1_0.VSS.n2459 wind_comp_0.sg13g2_and2_2$1_0.VSS.n1081 0.00568325
R6311 wind_comp_0.sg13g2_and2_2$1_0.VSS.n2458 wind_comp_0.sg13g2_and2_2$1_0.VSS.n1078 0.00568325
R6312 wind_comp_0.sg13g2_and2_2$1_0.VSS.n2457 wind_comp_0.sg13g2_and2_2$1_0.VSS.n1077 0.00568325
R6313 wind_comp_0.sg13g2_and2_2$1_0.VSS.n2456 wind_comp_0.sg13g2_and2_2$1_0.VSS.n1074 0.00568325
R6314 wind_comp_0.sg13g2_and2_2$1_0.VSS.n2455 wind_comp_0.sg13g2_and2_2$1_0.VSS.n1073 0.00568325
R6315 wind_comp_0.sg13g2_and2_2$1_0.VSS.n2454 wind_comp_0.sg13g2_and2_2$1_0.VSS.n1070 0.00568325
R6316 wind_comp_0.sg13g2_and2_2$1_0.VSS.n2453 wind_comp_0.sg13g2_and2_2$1_0.VSS.n655 0.00568325
R6317 wind_comp_0.sg13g2_and2_2$1_0.VSS.n239 wind_comp_0.sg13g2_and2_2$1_0.VSS.n238 0.00359083
R6318 wind_comp_0.sg13g2_and2_2$1_0.VSS.n230 wind_comp_0.sg13g2_and2_2$1_0.VSS.n919 0.0110771
R6319 wind_comp_0.sg13g2_and2_2$1_0.VSS.n2223 wind_comp_0.sg13g2_and2_2$1_0.VSS.n921 0.00568325
R6320 wind_comp_0.sg13g2_and2_2$1_0.VSS.n2338 wind_comp_0.sg13g2_and2_2$1_0.VSS.n924 0.00568325
R6321 wind_comp_0.sg13g2_and2_2$1_0.VSS.n997 wind_comp_0.sg13g2_and2_2$1_0.VSS.n996 0.00560885
R6322 wind_comp_0.sg13g2_and2_2$1_0.VSS.n1052 wind_comp_0.sg13g2_and2_2$1_0.VSS.n1051 0.00560885
R6323 wind_comp_0.sg13g2_and2_2$1_0.VSS.n1325 wind_comp_0.sg13g2_and2_2$1_0.VSS.n753 0.00557751
R6324 wind_comp_0.sg13g2_and2_2$1_0.VSS.n671 wind_comp_0.sg13g2_and2_2$1_0.VSS.n20 0.00555935
R6325 wind_comp_0.sg13g2_and2_2$1_0.VSS.n253 wind_comp_0.sg13g2_and2_2$1_0.VSS.n252 0.00351889
R6326 wind_comp_0.sg13g2_and2_2$1_0.VSS.n675 wind_comp_0.sg13g2_and2_2$1_0.VSS.n232 0.00841426
R6327 wind_comp_0.sg13g2_and2_2$1_0.VSS.n171 wind_comp_0.sg13g2_and2_2$1_0.VSS.n170 0.00351889
R6328 wind_comp_0.sg13g2_and2_2$1_0.VSS.n1969 wind_comp_0.sg13g2_and2_2$1_0.VSS.n1968 0.00553927
R6329 wind_comp_0.sg13g2_and2_2$1_0.VSS.n188 wind_comp_0.sg13g2_and2_2$1_0.VSS.n187 0.00349963
R6330 wind_comp_0.sg13g2_and2_2$1_0.VSS.n1850 wind_comp_0.sg13g2_and2_2$1_0.VSS.n1849 0.0055
R6331 wind_comp_0.sg13g2_and2_2$1_0.VSS.n773 wind_comp_0.sg13g2_and2_2$1_0.VSS.n5 0.00962438
R6332 wind_comp_0.sg13g2_and2_2$1_0.VSS.n657 wind_comp_0.sg13g2_and2_2$1_0.VSS.n228 0.00819833
R6333 wind_comp_0.sg13g2_and2_2$1_0.VSS.n2413 wind_comp_0.sg13g2_and2_2$1_0.VSS.n940 0.00539529
R6334 wind_comp_0.sg13g2_and2_2$1_0.VSS.n166 wind_comp_0.sg13g2_and2_2$1_0.VSS.n165 0.00337499
R6335 wind_comp_0.sg13g2_and2_2$1_0.VSS.n252 wind_comp_0.sg13g2_and2_2$1_0.VSS.n251 0.0082702
R6336 wind_comp_0.sg13g2_and2_2$1_0.VSS.n134 wind_comp_0.sg13g2_and2_2$1_0.VSS.n133 0.00437668
R6337 wind_comp_0.sg13g2_and2_2$1_0.VSS.n232 wind_comp_0.sg13g2_and2_2$1_0.VSS.n231 0.00337499
R6338 wind_comp_0.sg13g2_and2_2$1_0.VSS.n172 wind_comp_0.sg13g2_and2_2$1_0.VSS.n2034 0.0106452
R6339 wind_comp_0.sg13g2_and2_2$1_0.VSS.n1968 wind_comp_0.sg13g2_and2_2$1_0.VSS.n1967 0.00525131
R6340 wind_comp_0.sg13g2_and2_2$1_0.VSS.n675 wind_comp_0.sg13g2_and2_2$1_0.VSS.n171 0.0082702
R6341 wind_comp_0.sg13g2_and2_2$1_0.VSS.n2106 wind_comp_0.sg13g2_and2_2$1_0.VSS.n2105 0.00511337
R6342 wind_comp_0.sg13g2_and2_2$1_0.VSS.n2115 wind_comp_0.sg13g2_and2_2$1_0.VSS.n2113 0.00511337
R6343 wind_comp_0.sg13g2_and2_2$1_0.VSS.n691 wind_comp_0.sg13g2_and2_2$1_0.VSS.n689 0.00511337
R6344 wind_comp_0.sg13g2_and2_2$1_0.VSS.n739 wind_comp_0.sg13g2_and2_2$1_0.VSS.n527 0.00511337
R6345 wind_comp_0.sg13g2_and2_2$1_0.VSS.n17 wind_comp_0.sg13g2_and2_2$1_0.VSS.n16 0.0180955
R6346 wind_comp_0.sg13g2_and2_2$1_0.VSS.n2313 wind_comp_0.sg13g2_and2_2$1_0.VSS.n865 0.00511337
R6347 wind_comp_0.sg13g2_and2_2$1_0.VSS.n2300 wind_comp_0.sg13g2_and2_2$1_0.VSS.n2299 0.00511337
R6348 wind_comp_0.sg13g2_and2_2$1_0.VSS.n2336 wind_comp_0.sg13g2_and2_2$1_0.VSS.n2335 0.00511337
R6349 wind_comp_0.sg13g2_and2_2$1_0.VSS.n2141 wind_comp_0.sg13g2_and2_2$1_0.VSS.n2140 0.00510733
R6350 wind_comp_0.sg13g2_and2_2$1_0.VSS.n2478 wind_comp_0.sg13g2_and2_2$1_0.VSS.n1121 0.00510733
R6351 wind_comp_0.sg13g2_and2_2$1_0.VSS.n2477 wind_comp_0.sg13g2_and2_2$1_0.VSS.n1118 0.00510733
R6352 wind_comp_0.sg13g2_and2_2$1_0.VSS.n2476 wind_comp_0.sg13g2_and2_2$1_0.VSS.n1117 0.00510733
R6353 wind_comp_0.sg13g2_and2_2$1_0.VSS.n2475 wind_comp_0.sg13g2_and2_2$1_0.VSS.n1114 0.00510733
R6354 wind_comp_0.sg13g2_and2_2$1_0.VSS.n2474 wind_comp_0.sg13g2_and2_2$1_0.VSS.n1113 0.00510733
R6355 wind_comp_0.sg13g2_and2_2$1_0.VSS.n2473 wind_comp_0.sg13g2_and2_2$1_0.VSS.n1110 0.00510733
R6356 wind_comp_0.sg13g2_and2_2$1_0.VSS.n2472 wind_comp_0.sg13g2_and2_2$1_0.VSS.n1109 0.00510733
R6357 wind_comp_0.sg13g2_and2_2$1_0.VSS.n2471 wind_comp_0.sg13g2_and2_2$1_0.VSS.n1106 0.00510733
R6358 wind_comp_0.sg13g2_and2_2$1_0.VSS.n2470 wind_comp_0.sg13g2_and2_2$1_0.VSS.n1105 0.00510733
R6359 wind_comp_0.sg13g2_and2_2$1_0.VSS.n2469 wind_comp_0.sg13g2_and2_2$1_0.VSS.n1102 0.00510733
R6360 wind_comp_0.sg13g2_and2_2$1_0.VSS.n2468 wind_comp_0.sg13g2_and2_2$1_0.VSS.n1101 0.00510733
R6361 wind_comp_0.sg13g2_and2_2$1_0.VSS.n2467 wind_comp_0.sg13g2_and2_2$1_0.VSS.n1098 0.00510733
R6362 wind_comp_0.sg13g2_and2_2$1_0.VSS.n2466 wind_comp_0.sg13g2_and2_2$1_0.VSS.n1097 0.00510733
R6363 wind_comp_0.sg13g2_and2_2$1_0.VSS.n2465 wind_comp_0.sg13g2_and2_2$1_0.VSS.n1094 0.00510733
R6364 wind_comp_0.sg13g2_and2_2$1_0.VSS.n2464 wind_comp_0.sg13g2_and2_2$1_0.VSS.n1093 0.00510733
R6365 wind_comp_0.sg13g2_and2_2$1_0.VSS.n2463 wind_comp_0.sg13g2_and2_2$1_0.VSS.n1091 0.00510733
R6366 wind_comp_0.sg13g2_and2_2$1_0.VSS.n2462 wind_comp_0.sg13g2_and2_2$1_0.VSS.n1089 0.00510733
R6367 wind_comp_0.sg13g2_and2_2$1_0.VSS.n2461 wind_comp_0.sg13g2_and2_2$1_0.VSS.n1086 0.00510733
R6368 wind_comp_0.sg13g2_and2_2$1_0.VSS.n2460 wind_comp_0.sg13g2_and2_2$1_0.VSS.n1085 0.00510733
R6369 wind_comp_0.sg13g2_and2_2$1_0.VSS.n2459 wind_comp_0.sg13g2_and2_2$1_0.VSS.n1082 0.00510733
R6370 wind_comp_0.sg13g2_and2_2$1_0.VSS.n2458 wind_comp_0.sg13g2_and2_2$1_0.VSS.n1081 0.00510733
R6371 wind_comp_0.sg13g2_and2_2$1_0.VSS.n2457 wind_comp_0.sg13g2_and2_2$1_0.VSS.n1078 0.00510733
R6372 wind_comp_0.sg13g2_and2_2$1_0.VSS.n2456 wind_comp_0.sg13g2_and2_2$1_0.VSS.n1077 0.00510733
R6373 wind_comp_0.sg13g2_and2_2$1_0.VSS.n2455 wind_comp_0.sg13g2_and2_2$1_0.VSS.n1074 0.00510733
R6374 wind_comp_0.sg13g2_and2_2$1_0.VSS.n2454 wind_comp_0.sg13g2_and2_2$1_0.VSS.n1073 0.00510733
R6375 wind_comp_0.sg13g2_and2_2$1_0.VSS.n2453 wind_comp_0.sg13g2_and2_2$1_0.VSS.n1070 0.00510733
R6376 wind_comp_0.sg13g2_and2_2$1_0.VSS.n229 wind_comp_0.sg13g2_and2_2$1_0.VSS.n228 0.00330304
R6377 wind_comp_0.sg13g2_and2_2$1_0.VSS.n2339 wind_comp_0.sg13g2_and2_2$1_0.VSS.n921 0.00510733
R6378 wind_comp_0.sg13g2_and2_2$1_0.VSS.n2338 wind_comp_0.sg13g2_and2_2$1_0.VSS.n923 0.00510733
R6379 wind_comp_0.sg13g2_and2_2$1_0.VSS.n1402 wind_comp_0.sg13g2_and2_2$1_0.VSS.n617 0.0105637
R6380 wind_comp_0.sg13g2_and2_2$1_0.VSS.n996 wind_comp_0.sg13g2_and2_2$1_0.VSS.n830 0.00497025
R6381 wind_comp_0.sg13g2_and2_2$1_0.VSS.n1035 wind_comp_0.sg13g2_and2_2$1_0.VSS.n839 0.00497025
R6382 wind_comp_0.sg13g2_and2_2$1_0.VSS.n985 wind_comp_0.sg13g2_and2_2$1_0.VSS.n840 0.00497025
R6383 wind_comp_0.sg13g2_and2_2$1_0.VSS.n984 wind_comp_0.sg13g2_and2_2$1_0.VSS.n841 0.00497025
R6384 wind_comp_0.sg13g2_and2_2$1_0.VSS.n983 wind_comp_0.sg13g2_and2_2$1_0.VSS.n842 0.00497025
R6385 wind_comp_0.sg13g2_and2_2$1_0.VSS.n982 wind_comp_0.sg13g2_and2_2$1_0.VSS.n843 0.00497025
R6386 wind_comp_0.sg13g2_and2_2$1_0.VSS.n981 wind_comp_0.sg13g2_and2_2$1_0.VSS.n844 0.00497025
R6387 wind_comp_0.sg13g2_and2_2$1_0.VSS.n980 wind_comp_0.sg13g2_and2_2$1_0.VSS.n162 0.00866208
R6388 wind_comp_0.sg13g2_and2_2$1_0.VSS.n164 wind_comp_0.sg13g2_and2_2$1_0.VSS.n845 0.0108967
R6389 wind_comp_0.sg13g2_and2_2$1_0.VSS.n979 wind_comp_0.sg13g2_and2_2$1_0.VSS.n846 0.00497025
R6390 wind_comp_0.sg13g2_and2_2$1_0.VSS.n978 wind_comp_0.sg13g2_and2_2$1_0.VSS.n847 0.00497025
R6391 wind_comp_0.sg13g2_and2_2$1_0.VSS.n905 wind_comp_0.sg13g2_and2_2$1_0.VSS.n848 0.00497025
R6392 wind_comp_0.sg13g2_and2_2$1_0.VSS.n906 wind_comp_0.sg13g2_and2_2$1_0.VSS.n849 0.00497025
R6393 wind_comp_0.sg13g2_and2_2$1_0.VSS.n904 wind_comp_0.sg13g2_and2_2$1_0.VSS.n850 0.00497025
R6394 wind_comp_0.sg13g2_and2_2$1_0.VSS.n1050 wind_comp_0.sg13g2_and2_2$1_0.VSS.n851 0.00497025
R6395 wind_comp_0.sg13g2_and2_2$1_0.VSS.n1051 wind_comp_0.sg13g2_and2_2$1_0.VSS.n852 0.00497025
R6396 wind_comp_0.sg13g2_and2_2$1_0.VSS.n1038 wind_comp_0.sg13g2_and2_2$1_0.VSS.n853 0.00497025
R6397 wind_comp_0.sg13g2_and2_2$1_0.VSS.n1037 wind_comp_0.sg13g2_and2_2$1_0.VSS.n854 0.00497025
R6398 wind_comp_0.sg13g2_and2_2$1_0.VSS.n1040 wind_comp_0.sg13g2_and2_2$1_0.VSS.n855 0.00497025
R6399 wind_comp_0.sg13g2_and2_2$1_0.VSS.n1039 wind_comp_0.sg13g2_and2_2$1_0.VSS.n856 0.00497025
R6400 wind_comp_0.sg13g2_and2_2$1_0.VSS.n1042 wind_comp_0.sg13g2_and2_2$1_0.VSS.n857 0.00497025
R6401 wind_comp_0.sg13g2_and2_2$1_0.VSS.n1041 wind_comp_0.sg13g2_and2_2$1_0.VSS.n858 0.00497025
R6402 wind_comp_0.sg13g2_and2_2$1_0.VSS.n1818 wind_comp_0.sg13g2_and2_2$1_0.VSS.n1817 0.00494444
R6403 wind_comp_0.sg13g2_and2_2$1_0.VSS.n2002 wind_comp_0.sg13g2_and2_2$1_0.VSS.n797 0.00483193
R6404 wind_comp_0.sg13g2_and2_2$1_0.VSS.n2003 wind_comp_0.sg13g2_and2_2$1_0.VSS.n796 0.00483193
R6405 wind_comp_0.sg13g2_and2_2$1_0.VSS.n2005 wind_comp_0.sg13g2_and2_2$1_0.VSS.n795 0.00483193
R6406 wind_comp_0.sg13g2_and2_2$1_0.VSS.n2004 wind_comp_0.sg13g2_and2_2$1_0.VSS.n794 0.00483193
R6407 wind_comp_0.sg13g2_and2_2$1_0.VSS.n2008 wind_comp_0.sg13g2_and2_2$1_0.VSS.n793 0.00483193
R6408 wind_comp_0.sg13g2_and2_2$1_0.VSS.n2006 wind_comp_0.sg13g2_and2_2$1_0.VSS.n792 0.00483193
R6409 wind_comp_0.sg13g2_and2_2$1_0.VSS.n2007 wind_comp_0.sg13g2_and2_2$1_0.VSS.n167 0.00842503
R6410 wind_comp_0.sg13g2_and2_2$1_0.VSS.n169 wind_comp_0.sg13g2_and2_2$1_0.VSS.n791 0.0105905
R6411 wind_comp_0.sg13g2_and2_2$1_0.VSS.n1979 wind_comp_0.sg13g2_and2_2$1_0.VSS.n790 0.00483193
R6412 wind_comp_0.sg13g2_and2_2$1_0.VSS.n1982 wind_comp_0.sg13g2_and2_2$1_0.VSS.n757 0.00483193
R6413 wind_comp_0.sg13g2_and2_2$1_0.VSS.n1981 wind_comp_0.sg13g2_and2_2$1_0.VSS.n758 0.00483193
R6414 wind_comp_0.sg13g2_and2_2$1_0.VSS.n1980 wind_comp_0.sg13g2_and2_2$1_0.VSS.n759 0.00483193
R6415 wind_comp_0.sg13g2_and2_2$1_0.VSS.n2024 wind_comp_0.sg13g2_and2_2$1_0.VSS.n215 0.00842503
R6416 wind_comp_0.sg13g2_and2_2$1_0.VSS.n217 wind_comp_0.sg13g2_and2_2$1_0.VSS.n760 0.0105905
R6417 wind_comp_0.sg13g2_and2_2$1_0.VSS.n1977 wind_comp_0.sg13g2_and2_2$1_0.VSS.n761 0.00483193
R6418 wind_comp_0.sg13g2_and2_2$1_0.VSS.n1978 wind_comp_0.sg13g2_and2_2$1_0.VSS.n762 0.00483193
R6419 wind_comp_0.sg13g2_and2_2$1_0.VSS.n2009 wind_comp_0.sg13g2_and2_2$1_0.VSS.n763 0.00483193
R6420 wind_comp_0.sg13g2_and2_2$1_0.VSS.n2010 wind_comp_0.sg13g2_and2_2$1_0.VSS.n764 0.00483193
R6421 wind_comp_0.sg13g2_and2_2$1_0.VSS.n2014 wind_comp_0.sg13g2_and2_2$1_0.VSS.n765 0.00483193
R6422 wind_comp_0.sg13g2_and2_2$1_0.VSS.n2013 wind_comp_0.sg13g2_and2_2$1_0.VSS.n766 0.00483193
R6423 wind_comp_0.sg13g2_and2_2$1_0.VSS.n2436 wind_comp_0.sg13g2_and2_2$1_0.VSS.n926 0.00481937
R6424 wind_comp_0.sg13g2_and2_2$1_0.VSS.n2354 wind_comp_0.sg13g2_and2_2$1_0.VSS.n932 0.00481937
R6425 wind_comp_0.sg13g2_and2_2$1_0.VSS.n888 wind_comp_0.sg13g2_and2_2$1_0.VSS.n879 0.00472625
R6426 wind_comp_0.sg13g2_and2_2$1_0.VSS.n898 wind_comp_0.sg13g2_and2_2$1_0.VSS.n669 0.00472625
R6427 wind_comp_0.sg13g2_and2_2$1_0.VSS.n2028 wind_comp_0.sg13g2_and2_2$1_0.VSS.n1973 0.00467539
R6428 wind_comp_0.sg13g2_and2_2$1_0.VSS.n611 wind_comp_0.sg13g2_and2_2$1_0.VSS.n220 0.0100693
R6429 wind_comp_0.sg13g2_and2_2$1_0.VSS.n2062 wind_comp_0.sg13g2_and2_2$1_0.VSS.n243 0.0100693
R6430 wind_comp_0.sg13g2_and2_2$1_0.VSS.n2031 wind_comp_0.sg13g2_and2_2$1_0.VSS.n2030 0.00467539
R6431 wind_comp_0.sg13g2_and2_2$1_0.VSS.n2068 wind_comp_0.sg13g2_and2_2$1_0.VSS.n2032 0.00467539
R6432 wind_comp_0.sg13g2_and2_2$1_0.VSS.n672 wind_comp_0.sg13g2_and2_2$1_0.VSS.n1971 0.00467539
R6433 wind_comp_0.sg13g2_and2_2$1_0.VSS.n2072 wind_comp_0.sg13g2_and2_2$1_0.VSS.n1970 0.00467539
R6434 wind_comp_0.sg13g2_and2_2$1_0.VSS.n2074 wind_comp_0.sg13g2_and2_2$1_0.VSS.n2033 0.00467539
R6435 wind_comp_0.sg13g2_and2_2$1_0.VSS.n87 wind_comp_0.sg13g2_and2_2$1_0.VSS.n86 0.00244769
R6436 wind_comp_0.sg13g2_and2_2$1_0.VSS.n674 wind_comp_0.sg13g2_and2_2$1_0.VSS.n673 0.00467539
R6437 wind_comp_0.sg13g2_and2_2$1_0.VSS.n2379 wind_comp_0.sg13g2_and2_2$1_0.VSS.n804 0.00465094
R6438 wind_comp_0.sg13g2_and2_2$1_0.VSS.n748 wind_comp_0.sg13g2_and2_2$1_0.VSS.n235 0.00791956
R6439 wind_comp_0.sg13g2_and2_2$1_0.VSS.n747 wind_comp_0.sg13g2_and2_2$1_0.VSS.n746 0.0045367
R6440 wind_comp_0.sg13g2_and2_2$1_0.VSS.n745 wind_comp_0.sg13g2_and2_2$1_0.VSS.n744 0.0045367
R6441 wind_comp_0.sg13g2_and2_2$1_0.VSS.n743 wind_comp_0.sg13g2_and2_2$1_0.VSS.n226 0.00791956
R6442 wind_comp_0.sg13g2_and2_2$1_0.VSS.n525 wind_comp_0.sg13g2_and2_2$1_0.VSS.n227 0.0153373
R6443 wind_comp_0.sg13g2_and2_2$1_0.VSS.n143 wind_comp_0.sg13g2_and2_2$1_0.VSS.n869 0.0202141
R6444 wind_comp_0.sg13g2_and2_2$1_0.VSS.n1881 wind_comp_0.sg13g2_and2_2$1_0.VSS.n870 0.0045367
R6445 wind_comp_0.sg13g2_and2_2$1_0.VSS.n1882 wind_comp_0.sg13g2_and2_2$1_0.VSS.n871 0.0045367
R6446 wind_comp_0.sg13g2_and2_2$1_0.VSS.n2325 wind_comp_0.sg13g2_and2_2$1_0.VSS.n221 0.00791956
R6447 wind_comp_0.sg13g2_and2_2$1_0.VSS.n2075 wind_comp_0.sg13g2_and2_2$1_0.VSS.n2074 0.00453141
R6448 wind_comp_0.sg13g2_and2_2$1_0.VSS.n2130 wind_comp_0.sg13g2_and2_2$1_0.VSS.n2129 0.00453141
R6449 wind_comp_0.sg13g2_and2_2$1_0.VSS.n1345 wind_comp_0.sg13g2_and2_2$1_0.VSS.n1337 0.00448285
R6450 wind_comp_0.sg13g2_and2_2$1_0.VSS.n2069 wind_comp_0.sg13g2_and2_2$1_0.VSS.n1971 0.00438743
R6451 wind_comp_0.sg13g2_and2_2$1_0.VSS.n1954 wind_comp_0.sg13g2_and2_2$1_0.VSS.n1930 0.00435753
R6452 wind_comp_0.sg13g2_and2_2$1_0.VSS.n1936 wind_comp_0.sg13g2_and2_2$1_0.VSS.n1935 0.00435753
R6453 wind_comp_0.sg13g2_and2_2$1_0.VSS.n1940 wind_comp_0.sg13g2_and2_2$1_0.VSS.n1939 0.00435753
R6454 wind_comp_0.sg13g2_and2_2$1_0.VSS.n1944 wind_comp_0.sg13g2_and2_2$1_0.VSS.n1943 0.00435753
R6455 wind_comp_0.sg13g2_and2_2$1_0.VSS.n1948 wind_comp_0.sg13g2_and2_2$1_0.VSS.n1947 0.00435753
R6456 wind_comp_0.sg13g2_and2_2$1_0.VSS.n1953 wind_comp_0.sg13g2_and2_2$1_0.VSS.n1952 0.00435753
R6457 wind_comp_0.sg13g2_and2_2$1_0.VSS.n1952 wind_comp_0.sg13g2_and2_2$1_0.VSS.n1931 0.00435753
R6458 wind_comp_0.sg13g2_and2_2$1_0.VSS.n1938 wind_comp_0.sg13g2_and2_2$1_0.VSS.n1937 0.00435753
R6459 wind_comp_0.sg13g2_and2_2$1_0.VSS.n1942 wind_comp_0.sg13g2_and2_2$1_0.VSS.n1941 0.00435753
R6460 wind_comp_0.sg13g2_and2_2$1_0.VSS.n1945 wind_comp_0.sg13g2_and2_2$1_0.VSS.n1942 0.00435753
R6461 wind_comp_0.sg13g2_and2_2$1_0.VSS.n1949 wind_comp_0.sg13g2_and2_2$1_0.VSS.n1946 0.00435753
R6462 wind_comp_0.sg13g2_and2_2$1_0.VSS.n1026 wind_comp_0.sg13g2_and2_2$1_0.VSS.n823 0.00433164
R6463 wind_comp_0.sg13g2_and2_2$1_0.VSS.n2141 wind_comp_0.sg13g2_and2_2$1_0.VSS.n1959 0.00424346
R6464 wind_comp_0.sg13g2_and2_2$1_0.VSS.n2425 wind_comp_0.sg13g2_and2_2$1_0.VSS.n931 0.00424346
R6465 wind_comp_0.sg13g2_and2_2$1_0.VSS.n2364 wind_comp_0.sg13g2_and2_2$1_0.VSS.n952 0.00424346
R6466 wind_comp_0.sg13g2_and2_2$1_0.VSS.n2018 wind_comp_0.sg13g2_and2_2$1_0.VSS.n772 0.00421308
R6467 wind_comp_0.sg13g2_and2_2$1_0.VSS.n1331 wind_comp_0.sg13g2_and2_2$1_0.VSS.n755 0.00413927
R6468 wind_comp_0.sg13g2_and2_2$1_0.VSS.n2431 wind_comp_0.sg13g2_and2_2$1_0.VSS.n928 0.00409948
R6469 wind_comp_0.sg13g2_and2_2$1_0.VSS.n2354 wind_comp_0.sg13g2_and2_2$1_0.VSS.n910 0.00409948
R6470 wind_comp_0.sg13g2_and2_2$1_0.VSS.n2364 wind_comp_0.sg13g2_and2_2$1_0.VSS.n915 0.00409948
R6471 wind_comp_0.sg13g2_and2_2$1_0.VSS.n2380 wind_comp_0.sg13g2_and2_2$1_0.VSS.n2379 0.00409948
R6472 wind_comp_0.sg13g2_and2_2$1_0.VSS.n1865 wind_comp_0.sg13g2_and2_2$1_0.VSS.n1736 0.00401852
R6473 wind_comp_0.sg13g2_and2_2$1_0.VSS.n1866 wind_comp_0.sg13g2_and2_2$1_0.VSS.n1737 0.00401852
R6474 wind_comp_0.sg13g2_and2_2$1_0.VSS.n94 wind_comp_0.sg13g2_and2_2$1_0.VSS.n93 0.00400466
R6475 wind_comp_0.sg13g2_and2_2$1_0.VSS.n2113 wind_comp_0.sg13g2_and2_2$1_0.VSS.n696 0.00396003
R6476 wind_comp_0.sg13g2_and2_2$1_0.VSS.n2593 wind_comp_0.sg13g2_and2_2$1_0.VSS.n689 0.00396003
R6477 wind_comp_0.sg13g2_and2_2$1_0.VSS.n525 wind_comp_0.sg13g2_and2_2$1_0.VSS.n527 0.00936032
R6478 wind_comp_0.sg13g2_and2_2$1_0.VSS.n738 wind_comp_0.sg13g2_and2_2$1_0.VSS.n733 0.00396003
R6479 wind_comp_0.sg13g2_and2_2$1_0.VSS.n2590 wind_comp_0.sg13g2_and2_2$1_0.VSS.n732 0.00396003
R6480 wind_comp_0.sg13g2_and2_2$1_0.VSS.n2313 wind_comp_0.sg13g2_and2_2$1_0.VSS.n1883 0.00396003
R6481 wind_comp_0.sg13g2_and2_2$1_0.VSS.n2299 wind_comp_0.sg13g2_and2_2$1_0.VSS.n868 0.00396003
R6482 wind_comp_0.sg13g2_and2_2$1_0.VSS.n2337 wind_comp_0.sg13g2_and2_2$1_0.VSS.n873 0.00396003
R6483 wind_comp_0.sg13g2_and2_2$1_0.VSS.n2326 wind_comp_0.sg13g2_and2_2$1_0.VSS.n874 0.00396003
R6484 wind_comp_0.sg13g2_and2_2$1_0.VSS.n1785 wind_comp_0.sg13g2_and2_2$1_0.VSS.n875 0.00396003
R6485 wind_comp_0.sg13g2_and2_2$1_0.VSS.n2063 wind_comp_0.sg13g2_and2_2$1_0.VSS.n2062 0.0039555
R6486 wind_comp_0.sg13g2_and2_2$1_0.VSS.n2035 wind_comp_0.sg13g2_and2_2$1_0.VSS.n2034 0.0039555
R6487 wind_comp_0.sg13g2_and2_2$1_0.VSS.n1818 wind_comp_0.sg13g2_and2_2$1_0.VSS.n1801 0.00389768
R6488 wind_comp_0.sg13g2_and2_2$1_0.VSS.n1019 wind_comp_0.sg13g2_and2_2$1_0.VSS.n807 0.00369303
R6489 wind_comp_0.sg13g2_and2_2$1_0.VSS.n1046 wind_comp_0.sg13g2_and2_2$1_0.VSS.n860 0.00369303
R6490 wind_comp_0.sg13g2_and2_2$1_0.VSS.n1045 wind_comp_0.sg13g2_and2_2$1_0.VSS.n861 0.00369303
R6491 wind_comp_0.sg13g2_and2_2$1_0.VSS.n1047 wind_comp_0.sg13g2_and2_2$1_0.VSS.n862 0.00369303
R6492 wind_comp_0.sg13g2_and2_2$1_0.VSS.n2129 wind_comp_0.sg13g2_and2_2$1_0.VSS.n2128 0.00366754
R6493 wind_comp_0.sg13g2_and2_2$1_0.VSS.n2152 wind_comp_0.sg13g2_and2_2$1_0.VSS.n396 0.00366754
R6494 wind_comp_0.sg13g2_and2_2$1_0.VSS.n2442 wind_comp_0.sg13g2_and2_2$1_0.VSS.n919 0.00366754
R6495 wind_comp_0.sg13g2_and2_2$1_0.VSS.n2374 wind_comp_0.sg13g2_and2_2$1_0.VSS.n526 0.00366754
R6496 wind_comp_0.sg13g2_and2_2$1_0.VSS.n1996 wind_comp_0.sg13g2_and2_2$1_0.VSS.n800 0.00359423
R6497 wind_comp_0.sg13g2_and2_2$1_0.VSS.n2012 wind_comp_0.sg13g2_and2_2$1_0.VSS.n768 0.00359423
R6498 wind_comp_0.sg13g2_and2_2$1_0.VSS.n2017 wind_comp_0.sg13g2_and2_2$1_0.VSS.n769 0.00359423
R6499 wind_comp_0.sg13g2_and2_2$1_0.VSS.n2016 wind_comp_0.sg13g2_and2_2$1_0.VSS.n770 0.00359423
R6500 wind_comp_0.sg13g2_and2_2$1_0.VSS.n2413 wind_comp_0.sg13g2_and2_2$1_0.VSS.n90 0.0111485
R6501 wind_comp_0.sg13g2_and2_2$1_0.VSS.n129 wind_comp_0.sg13g2_and2_2$1_0.VSS.n121 0.00973629
R6502 wind_comp_0.sg13g2_and2_2$1_0.VSS.n2117 wind_comp_0.sg13g2_and2_2$1_0.VSS.n38 0.0166636
R6503 wind_comp_0.sg13g2_and2_2$1_0.VSS.n2055 wind_comp_0.sg13g2_and2_2$1_0.VSS.n160 0.0227606
R6504 wind_comp_0.sg13g2_and2_2$1_0.VSS.n2057 wind_comp_0.sg13g2_and2_2$1_0.VSS.n219 0.00668625
R6505 wind_comp_0.sg13g2_and2_2$1_0.VSS.n2145 wind_comp_0.sg13g2_and2_2$1_0.VSS.n2144 0.00337958
R6506 wind_comp_0.sg13g2_and2_2$1_0.VSS.n2516 wind_comp_0.sg13g2_and2_2$1_0.VSS.n1197 0.00337958
R6507 wind_comp_0.sg13g2_and2_2$1_0.VSS.n2515 wind_comp_0.sg13g2_and2_2$1_0.VSS.n1194 0.00337958
R6508 wind_comp_0.sg13g2_and2_2$1_0.VSS.n2514 wind_comp_0.sg13g2_and2_2$1_0.VSS.n1193 0.00337958
R6509 wind_comp_0.sg13g2_and2_2$1_0.VSS.n2513 wind_comp_0.sg13g2_and2_2$1_0.VSS.n1190 0.00337958
R6510 wind_comp_0.sg13g2_and2_2$1_0.VSS.n2512 wind_comp_0.sg13g2_and2_2$1_0.VSS.n1189 0.00337958
R6511 wind_comp_0.sg13g2_and2_2$1_0.VSS.n2511 wind_comp_0.sg13g2_and2_2$1_0.VSS.n1186 0.00337958
R6512 wind_comp_0.sg13g2_and2_2$1_0.VSS.n2510 wind_comp_0.sg13g2_and2_2$1_0.VSS.n1185 0.00337958
R6513 wind_comp_0.sg13g2_and2_2$1_0.VSS.n2509 wind_comp_0.sg13g2_and2_2$1_0.VSS.n1182 0.00337958
R6514 wind_comp_0.sg13g2_and2_2$1_0.VSS.n2508 wind_comp_0.sg13g2_and2_2$1_0.VSS.n1181 0.00337958
R6515 wind_comp_0.sg13g2_and2_2$1_0.VSS.n2507 wind_comp_0.sg13g2_and2_2$1_0.VSS.n1178 0.00337958
R6516 wind_comp_0.sg13g2_and2_2$1_0.VSS.n2506 wind_comp_0.sg13g2_and2_2$1_0.VSS.n1177 0.00337958
R6517 wind_comp_0.sg13g2_and2_2$1_0.VSS.n2505 wind_comp_0.sg13g2_and2_2$1_0.VSS.n1174 0.00337958
R6518 wind_comp_0.sg13g2_and2_2$1_0.VSS.n2504 wind_comp_0.sg13g2_and2_2$1_0.VSS.n1173 0.00337958
R6519 wind_comp_0.sg13g2_and2_2$1_0.VSS.n2503 wind_comp_0.sg13g2_and2_2$1_0.VSS.n1170 0.00337958
R6520 wind_comp_0.sg13g2_and2_2$1_0.VSS.n2502 wind_comp_0.sg13g2_and2_2$1_0.VSS.n1169 0.00337958
R6521 wind_comp_0.sg13g2_and2_2$1_0.VSS.n2501 wind_comp_0.sg13g2_and2_2$1_0.VSS.n1166 0.00337958
R6522 wind_comp_0.sg13g2_and2_2$1_0.VSS.n2500 wind_comp_0.sg13g2_and2_2$1_0.VSS.n1165 0.00337958
R6523 wind_comp_0.sg13g2_and2_2$1_0.VSS.n2499 wind_comp_0.sg13g2_and2_2$1_0.VSS.n1162 0.00337958
R6524 wind_comp_0.sg13g2_and2_2$1_0.VSS.n2498 wind_comp_0.sg13g2_and2_2$1_0.VSS.n1161 0.00337958
R6525 wind_comp_0.sg13g2_and2_2$1_0.VSS.n2497 wind_comp_0.sg13g2_and2_2$1_0.VSS.n1158 0.00337958
R6526 wind_comp_0.sg13g2_and2_2$1_0.VSS.n2496 wind_comp_0.sg13g2_and2_2$1_0.VSS.n1157 0.00337958
R6527 wind_comp_0.sg13g2_and2_2$1_0.VSS.n2495 wind_comp_0.sg13g2_and2_2$1_0.VSS.n1154 0.00337958
R6528 wind_comp_0.sg13g2_and2_2$1_0.VSS.n2494 wind_comp_0.sg13g2_and2_2$1_0.VSS.n1153 0.00337958
R6529 wind_comp_0.sg13g2_and2_2$1_0.VSS.n2493 wind_comp_0.sg13g2_and2_2$1_0.VSS.n1150 0.00337958
R6530 wind_comp_0.sg13g2_and2_2$1_0.VSS.n2492 wind_comp_0.sg13g2_and2_2$1_0.VSS.n1149 0.00337958
R6531 wind_comp_0.sg13g2_and2_2$1_0.VSS.n2491 wind_comp_0.sg13g2_and2_2$1_0.VSS.n1146 0.00337958
R6532 wind_comp_0.sg13g2_and2_2$1_0.VSS.n2490 wind_comp_0.sg13g2_and2_2$1_0.VSS.n1145 0.00337958
R6533 wind_comp_0.sg13g2_and2_2$1_0.VSS.n2489 wind_comp_0.sg13g2_and2_2$1_0.VSS.n1142 0.00337958
R6534 wind_comp_0.sg13g2_and2_2$1_0.VSS.n2488 wind_comp_0.sg13g2_and2_2$1_0.VSS.n1141 0.00337958
R6535 wind_comp_0.sg13g2_and2_2$1_0.VSS.n2487 wind_comp_0.sg13g2_and2_2$1_0.VSS.n1139 0.00337958
R6536 wind_comp_0.sg13g2_and2_2$1_0.VSS.n2486 wind_comp_0.sg13g2_and2_2$1_0.VSS.n1137 0.00337958
R6537 wind_comp_0.sg13g2_and2_2$1_0.VSS.n2485 wind_comp_0.sg13g2_and2_2$1_0.VSS.n1134 0.00337958
R6538 wind_comp_0.sg13g2_and2_2$1_0.VSS.n2484 wind_comp_0.sg13g2_and2_2$1_0.VSS.n1133 0.00337958
R6539 wind_comp_0.sg13g2_and2_2$1_0.VSS.n2483 wind_comp_0.sg13g2_and2_2$1_0.VSS.n1130 0.00337958
R6540 wind_comp_0.sg13g2_and2_2$1_0.VSS.n2482 wind_comp_0.sg13g2_and2_2$1_0.VSS.n1129 0.00337958
R6541 wind_comp_0.sg13g2_and2_2$1_0.VSS.n2481 wind_comp_0.sg13g2_and2_2$1_0.VSS.n1126 0.00337958
R6542 wind_comp_0.sg13g2_and2_2$1_0.VSS.n2480 wind_comp_0.sg13g2_and2_2$1_0.VSS.n1125 0.00337958
R6543 wind_comp_0.sg13g2_and2_2$1_0.VSS.n2479 wind_comp_0.sg13g2_and2_2$1_0.VSS.n1122 0.00337958
R6544 wind_comp_0.sg13g2_and2_2$1_0.VSS.n1350 wind_comp_0.sg13g2_and2_2$1_0.VSS.n1340 0.00325
R6545 wind_comp_0.sg13g2_and2_2$1_0.VSS.n1345 wind_comp_0.sg13g2_and2_2$1_0.VSS.n1339 0.00325
R6546 wind_comp_0.sg13g2_and2_2$1_0.VSS.n1332 wind_comp_0.sg13g2_and2_2$1_0.VSS.n1320 0.00325
R6547 wind_comp_0.sg13g2_and2_2$1_0.VSS.n1326 wind_comp_0.sg13g2_and2_2$1_0.VSS.n1318 0.00325
R6548 wind_comp_0.sg13g2_and2_2$1_0.VSS.n2055 wind_comp_0.sg13g2_and2_2$1_0.VSS.n1973 0.0032356
R6549 wind_comp_0.sg13g2_and2_2$1_0.VSS.n666 wind_comp_0.sg13g2_and2_2$1_0.VSS.n665 0.0032356
R6550 wind_comp_0.sg13g2_and2_2$1_0.VSS.n654 wind_comp_0.sg13g2_and2_2$1_0.VSS.n1197 0.00309162
R6551 wind_comp_0.sg13g2_and2_2$1_0.VSS.n2440 wind_comp_0.sg13g2_and2_2$1_0.VSS.n2339 0.00309162
R6552 wind_comp_0.sg13g2_and2_2$1_0.VSS.n2440 wind_comp_0.sg13g2_and2_2$1_0.VSS.n923 0.00309162
R6553 wind_comp_0.sg13g2_and2_2$1_0.VSS.n2419 wind_comp_0.sg13g2_and2_2$1_0.VSS.n934 0.00309162
R6554 wind_comp_0.sg13g2_and2_2$1_0.VSS.n156 wind_comp_0.sg13g2_and2_2$1_0.VSS.n296 0.0112025
R6555 wind_comp_0.sg13g2_and2_2$1_0.VSS.n2049 wind_comp_0.sg13g2_and2_2$1_0.VSS.n1969 0.00294764
R6556 wind_comp_0.sg13g2_and2_2$1_0.VSS.n2432 wind_comp_0.sg13g2_and2_2$1_0.VSS.n2431 0.00294764
R6557 wind_comp_0.sg13g2_and2_2$1_0.VSS.n2405 wind_comp_0.sg13g2_and2_2$1_0.VSS.n661 0.00294764
R6558 wind_comp_0.sg13g2_and2_2$1_0.VSS.n952 wind_comp_0.sg13g2_and2_2$1_0.VSS.n663 0.00294764
R6559 wind_comp_0.sg13g2_and2_2$1_0.VSS.n955 wind_comp_0.sg13g2_and2_2$1_0.VSS.n915 0.00294764
R6560 wind_comp_0.sg13g2_and2_2$1_0.VSS.n958 wind_comp_0.sg13g2_and2_2$1_0.VSS.n916 0.00294764
R6561 wind_comp_0.sg13g2_and2_2$1_0.VSS.n959 wind_comp_0.sg13g2_and2_2$1_0.VSS.n917 0.00294764
R6562 wind_comp_0.sg13g2_and2_2$1_0.VSS.n962 wind_comp_0.sg13g2_and2_2$1_0.VSS.n918 0.00294764
R6563 wind_comp_0.sg13g2_and2_2$1_0.VSS.n290 wind_comp_0.sg13g2_and2_2$1_0.VSS.n43 0.0600033
R6564 wind_comp_0.sg13g2_and2_2$1_0.VSS.n291 wind_comp_0.sg13g2_and2_2$1_0.VSS.n526 0.00834152
R6565 wind_comp_0.sg13g2_and2_2$1_0.VSS.n1930 wind_comp_0.sg13g2_and2_2$1_0.VSS.n108 0.00291767
R6566 wind_comp_0.sg13g2_and2_2$1_0.VSS.n1936 wind_comp_0.sg13g2_and2_2$1_0.VSS.n109 0.00291767
R6567 wind_comp_0.sg13g2_and2_2$1_0.VSS.n1940 wind_comp_0.sg13g2_and2_2$1_0.VSS.n110 0.00291767
R6568 wind_comp_0.sg13g2_and2_2$1_0.VSS.n1944 wind_comp_0.sg13g2_and2_2$1_0.VSS.n111 0.00291767
R6569 wind_comp_0.sg13g2_and2_2$1_0.VSS.n107 wind_comp_0.sg13g2_and2_2$1_0.VSS.n1954 0.00291767
R6570 wind_comp_0.sg13g2_and2_2$1_0.VSS.n1935 wind_comp_0.sg13g2_and2_2$1_0.VSS.n108 0.00291767
R6571 wind_comp_0.sg13g2_and2_2$1_0.VSS.n1939 wind_comp_0.sg13g2_and2_2$1_0.VSS.n109 0.00291767
R6572 wind_comp_0.sg13g2_and2_2$1_0.VSS.n1943 wind_comp_0.sg13g2_and2_2$1_0.VSS.n110 0.00291767
R6573 wind_comp_0.sg13g2_and2_2$1_0.VSS.n1948 wind_comp_0.sg13g2_and2_2$1_0.VSS.n111 0.00291767
R6574 wind_comp_0.sg13g2_and2_2$1_0.VSS.n1947 wind_comp_0.sg13g2_and2_2$1_0.VSS.n112 0.00291767
R6575 wind_comp_0.sg13g2_and2_2$1_0.VSS.n1953 wind_comp_0.sg13g2_and2_2$1_0.VSS.n1929 0.00291767
R6576 wind_comp_0.sg13g2_and2_2$1_0.VSS.n1937 wind_comp_0.sg13g2_and2_2$1_0.VSS.n1933 0.00291767
R6577 wind_comp_0.sg13g2_and2_2$1_0.VSS.n1941 wind_comp_0.sg13g2_and2_2$1_0.VSS.n1934 0.00291767
R6578 wind_comp_0.sg13g2_and2_2$1_0.VSS.n1950 wind_comp_0.sg13g2_and2_2$1_0.VSS.n1949 0.00291767
R6579 wind_comp_0.sg13g2_and2_2$1_0.VSS.n1946 wind_comp_0.sg13g2_and2_2$1_0.VSS.n1932 0.00291767
R6580 wind_comp_0.sg13g2_and2_2$1_0.VSS.n1933 wind_comp_0.sg13g2_and2_2$1_0.VSS.n1931 0.00291767
R6581 wind_comp_0.sg13g2_and2_2$1_0.VSS.n1938 wind_comp_0.sg13g2_and2_2$1_0.VSS.n1934 0.00291767
R6582 wind_comp_0.sg13g2_and2_2$1_0.VSS.n1950 wind_comp_0.sg13g2_and2_2$1_0.VSS.n1945 0.00291767
R6583 wind_comp_0.sg13g2_and2_2$1_0.VSS.n2066 wind_comp_0.sg13g2_and2_2$1_0.VSS.n2065 0.00280367
R6584 wind_comp_0.sg13g2_and2_2$1_0.VSS.n2063 wind_comp_0.sg13g2_and2_2$1_0.VSS.n2031 0.00265969
R6585 wind_comp_0.sg13g2_and2_2$1_0.VSS.n1319 wind_comp_0.sg13g2_and2_2$1_0.VSS.n754 0.00261313
R6586 wind_comp_0.sg13g2_and2_2$1_0.VSS.n1254 wind_comp_0.sg13g2_and2_2$1_0.VSS.n721 0.00259524
R6587 wind_comp_0.sg13g2_and2_2$1_0.VSS.n1234 wind_comp_0.sg13g2_and2_2$1_0.VSS.n722 0.00259524
R6588 wind_comp_0.sg13g2_and2_2$1_0.VSS.n1255 wind_comp_0.sg13g2_and2_2$1_0.VSS.n723 0.00259524
R6589 wind_comp_0.sg13g2_and2_2$1_0.VSS.n1233 wind_comp_0.sg13g2_and2_2$1_0.VSS.n724 0.00259524
R6590 wind_comp_0.sg13g2_and2_2$1_0.VSS.n1256 wind_comp_0.sg13g2_and2_2$1_0.VSS.n725 0.00259524
R6591 wind_comp_0.sg13g2_and2_2$1_0.VSS.n1232 wind_comp_0.sg13g2_and2_2$1_0.VSS.n726 0.00259524
R6592 wind_comp_0.sg13g2_and2_2$1_0.VSS.n1257 wind_comp_0.sg13g2_and2_2$1_0.VSS.n727 0.00259524
R6593 wind_comp_0.sg13g2_and2_2$1_0.VSS.n1231 wind_comp_0.sg13g2_and2_2$1_0.VSS.n728 0.00259524
R6594 wind_comp_0.sg13g2_and2_2$1_0.VSS.n1258 wind_comp_0.sg13g2_and2_2$1_0.VSS.n729 0.00259524
R6595 wind_comp_0.sg13g2_and2_2$1_0.VSS.n1230 wind_comp_0.sg13g2_and2_2$1_0.VSS.n730 0.00259524
R6596 wind_comp_0.sg13g2_and2_2$1_0.VSS.n192 wind_comp_0.sg13g2_and2_2$1_0.VSS.n731 0.00259524
R6597 wind_comp_0.sg13g2_and2_2$1_0.VSS.n281 wind_comp_0.sg13g2_and2_2$1_0.VSS.n1815 0.0179236
R6598 wind_comp_0.sg13g2_and2_2$1_0.VSS.n1847 wind_comp_0.sg13g2_and2_2$1_0.VSS.n1753 0.00259524
R6599 wind_comp_0.sg13g2_and2_2$1_0.VSS.n1846 wind_comp_0.sg13g2_and2_2$1_0.VSS.n1814 0.00259524
R6600 wind_comp_0.sg13g2_and2_2$1_0.VSS.n1845 wind_comp_0.sg13g2_and2_2$1_0.VSS.n1754 0.00259524
R6601 wind_comp_0.sg13g2_and2_2$1_0.VSS.n1844 wind_comp_0.sg13g2_and2_2$1_0.VSS.n1813 0.00259524
R6602 wind_comp_0.sg13g2_and2_2$1_0.VSS.n1843 wind_comp_0.sg13g2_and2_2$1_0.VSS.n1755 0.00259524
R6603 wind_comp_0.sg13g2_and2_2$1_0.VSS.n1842 wind_comp_0.sg13g2_and2_2$1_0.VSS.n1812 0.00259524
R6604 wind_comp_0.sg13g2_and2_2$1_0.VSS.n1841 wind_comp_0.sg13g2_and2_2$1_0.VSS.n1756 0.00259524
R6605 wind_comp_0.sg13g2_and2_2$1_0.VSS.n1840 wind_comp_0.sg13g2_and2_2$1_0.VSS.n1811 0.00259524
R6606 wind_comp_0.sg13g2_and2_2$1_0.VSS.n1839 wind_comp_0.sg13g2_and2_2$1_0.VSS.n1757 0.00259524
R6607 wind_comp_0.sg13g2_and2_2$1_0.VSS.n1838 wind_comp_0.sg13g2_and2_2$1_0.VSS.n1810 0.00259524
R6608 wind_comp_0.sg13g2_and2_2$1_0.VSS.n2137 wind_comp_0.sg13g2_and2_2$1_0.VSS.n358 0.00251571
R6609 wind_comp_0.sg13g2_and2_2$1_0.VSS.n2399 wind_comp_0.sg13g2_and2_2$1_0.VSS.n958 0.00251571
R6610 wind_comp_0.sg13g2_and2_2$1_0.VSS.n1000 wind_comp_0.sg13g2_and2_2$1_0.VSS.n804 0.00241582
R6611 wind_comp_0.sg13g2_and2_2$1_0.VSS.n999 wind_comp_0.sg13g2_and2_2$1_0.VSS.n805 0.00241582
R6612 wind_comp_0.sg13g2_and2_2$1_0.VSS.n1018 wind_comp_0.sg13g2_and2_2$1_0.VSS.n806 0.00241582
R6613 wind_comp_0.sg13g2_and2_2$1_0.VSS.n1017 wind_comp_0.sg13g2_and2_2$1_0.VSS.n807 0.00241582
R6614 wind_comp_0.sg13g2_and2_2$1_0.VSS.n1002 wind_comp_0.sg13g2_and2_2$1_0.VSS.n808 0.00241582
R6615 wind_comp_0.sg13g2_and2_2$1_0.VSS.n1001 wind_comp_0.sg13g2_and2_2$1_0.VSS.n809 0.00241582
R6616 wind_comp_0.sg13g2_and2_2$1_0.VSS.n1004 wind_comp_0.sg13g2_and2_2$1_0.VSS.n810 0.00241582
R6617 wind_comp_0.sg13g2_and2_2$1_0.VSS.n1003 wind_comp_0.sg13g2_and2_2$1_0.VSS.n811 0.00241582
R6618 wind_comp_0.sg13g2_and2_2$1_0.VSS.n1006 wind_comp_0.sg13g2_and2_2$1_0.VSS.n812 0.00241582
R6619 wind_comp_0.sg13g2_and2_2$1_0.VSS.n1005 wind_comp_0.sg13g2_and2_2$1_0.VSS.n813 0.00241582
R6620 wind_comp_0.sg13g2_and2_2$1_0.VSS.n1008 wind_comp_0.sg13g2_and2_2$1_0.VSS.n814 0.00241582
R6621 wind_comp_0.sg13g2_and2_2$1_0.VSS.n2066 wind_comp_0.sg13g2_and2_2$1_0.VSS.n1972 0.00237173
R6622 wind_comp_0.sg13g2_and2_2$1_0.VSS.n932 wind_comp_0.sg13g2_and2_2$1_0.VSS.n658 0.00237173
R6623 wind_comp_0.sg13g2_and2_2$1_0.VSS.n933 wind_comp_0.sg13g2_and2_2$1_0.VSS.n910 0.00237173
R6624 wind_comp_0.sg13g2_and2_2$1_0.VSS.n934 wind_comp_0.sg13g2_and2_2$1_0.VSS.n911 0.00237173
R6625 wind_comp_0.sg13g2_and2_2$1_0.VSS.n937 wind_comp_0.sg13g2_and2_2$1_0.VSS.n912 0.00237173
R6626 wind_comp_0.sg13g2_and2_2$1_0.VSS.n287 wind_comp_0.sg13g2_and2_2$1_0.VSS.n913 0.00682931
R6627 wind_comp_0.sg13g2_and2_2$1_0.VSS.n940 wind_comp_0.sg13g2_and2_2$1_0.VSS.n288 0.00776561
R6628 wind_comp_0.sg13g2_and2_2$1_0.VSS.n947 wind_comp_0.sg13g2_and2_2$1_0.VSS.n354 0.00683023
R6629 wind_comp_0.sg13g2_and2_2$1_0.VSS.n950 wind_comp_0.sg13g2_and2_2$1_0.VSS.n914 0.00237173
R6630 wind_comp_0.sg13g2_and2_2$1_0.VSS.n662 wind_comp_0.sg13g2_and2_2$1_0.VSS.n661 0.00762038
R6631 wind_comp_0.sg13g2_and2_2$1_0.VSS.n626 wind_comp_0.sg13g2_and2_2$1_0.VSS.n625 0.00618863
R6632 wind_comp_0.sg13g2_and2_2$1_0.VSS.n622 wind_comp_0.sg13g2_and2_2$1_0.VSS.n621 0.00618863
R6633 wind_comp_0.sg13g2_and2_2$1_0.VSS.n251 wind_comp_0.sg13g2_and2_2$1_0.VSS.n166 0.00841426
R6634 wind_comp_0.sg13g2_and2_2$1_0.VSS.n657 wind_comp_0.sg13g2_and2_2$1_0.VSS.n238 0.00848612
R6635 wind_comp_0.sg13g2_and2_2$1_0.VSS.n656 wind_comp_0.sg13g2_and2_2$1_0.VSS.n655 0.00510733
R6636 wind_comp_0.sg13g2_and2_2$1_0.VSS.n241 wind_comp_0.sg13g2_and2_2$1_0.VSS.n240 0.00841399
R6637 wind_comp_0.sg13g2_and2_2$1_0.VSS.n615 wind_comp_0.sg13g2_and2_2$1_0.VSS.n614 0.00294764
R6638 wind_comp_0.sg13g2_and2_2$1_0.VSS.n660 wind_comp_0.sg13g2_and2_2$1_0.VSS.n659 0.00265969
R6639 wind_comp_0.sg13g2_and2_2$1_0.VSS.n127 wind_comp_0.sg13g2_and2_2$1_0.VSS.n2379 0.00237173
R6640 wind_comp_0.sg13g2_and2_2$1_0.VSS.n613 wind_comp_0.sg13g2_and2_2$1_0.VSS.n612 0.00237173
R6641 wind_comp_0.sg13g2_and2_2$1_0.VSS.n1974 wind_comp_0.sg13g2_and2_2$1_0.VSS.n803 0.00235654
R6642 wind_comp_0.sg13g2_and2_2$1_0.VSS.n1976 wind_comp_0.sg13g2_and2_2$1_0.VSS.n802 0.00235654
R6643 wind_comp_0.sg13g2_and2_2$1_0.VSS.n1995 wind_comp_0.sg13g2_and2_2$1_0.VSS.n801 0.00235654
R6644 wind_comp_0.sg13g2_and2_2$1_0.VSS.n2000 wind_comp_0.sg13g2_and2_2$1_0.VSS.n800 0.00235654
R6645 wind_comp_0.sg13g2_and2_2$1_0.VSS.n2001 wind_comp_0.sg13g2_and2_2$1_0.VSS.n799 0.00235654
R6646 wind_comp_0.sg13g2_and2_2$1_0.VSS.n1999 wind_comp_0.sg13g2_and2_2$1_0.VSS.n798 0.00235654
R6647 wind_comp_0.sg13g2_and2_2$1_0.VSS.n2092 wind_comp_0.sg13g2_and2_2$1_0.VSS.n694 0.00223001
R6648 wind_comp_0.sg13g2_and2_2$1_0.VSS.n2116 wind_comp_0.sg13g2_and2_2$1_0.VSS.n693 0.00223001
R6649 wind_comp_0.sg13g2_and2_2$1_0.VSS.n2094 wind_comp_0.sg13g2_and2_2$1_0.VSS.n695 0.00223001
R6650 wind_comp_0.sg13g2_and2_2$1_0.VSS.n2115 wind_comp_0.sg13g2_and2_2$1_0.VSS.n2114 0.00223001
R6651 wind_comp_0.sg13g2_and2_2$1_0.VSS.n2093 wind_comp_0.sg13g2_and2_2$1_0.VSS.n696 0.00223001
R6652 wind_comp_0.sg13g2_and2_2$1_0.VSS.n692 wind_comp_0.sg13g2_and2_2$1_0.VSS.n352 0.00223001
R6653 wind_comp_0.sg13g2_and2_2$1_0.VSS.n2593 wind_comp_0.sg13g2_and2_2$1_0.VSS.n2592 0.00223001
R6654 wind_comp_0.sg13g2_and2_2$1_0.VSS.n691 wind_comp_0.sg13g2_and2_2$1_0.VSS.n690 0.00223001
R6655 wind_comp_0.sg13g2_and2_2$1_0.VSS.n1885 wind_comp_0.sg13g2_and2_2$1_0.VSS.n863 0.00223001
R6656 wind_comp_0.sg13g2_and2_2$1_0.VSS.n1884 wind_comp_0.sg13g2_and2_2$1_0.VSS.n864 0.00223001
R6657 wind_comp_0.sg13g2_and2_2$1_0.VSS.n1886 wind_comp_0.sg13g2_and2_2$1_0.VSS.n865 0.00223001
R6658 wind_comp_0.sg13g2_and2_2$1_0.VSS.n1883 wind_comp_0.sg13g2_and2_2$1_0.VSS.n866 0.00223001
R6659 wind_comp_0.sg13g2_and2_2$1_0.VSS.n2226 wind_comp_0.sg13g2_and2_2$1_0.VSS.n867 0.00223001
R6660 wind_comp_0.sg13g2_and2_2$1_0.VSS.n2225 wind_comp_0.sg13g2_and2_2$1_0.VSS.n868 0.00223001
R6661 wind_comp_0.sg13g2_and2_2$1_0.VSS.n2300 wind_comp_0.sg13g2_and2_2$1_0.VSS.n2227 0.00223001
R6662 wind_comp_0.sg13g2_and2_2$1_0.VSS.n2069 wind_comp_0.sg13g2_and2_2$1_0.VSS.n2068 0.00222775
R6663 wind_comp_0.sg13g2_and2_2$1_0.VSS.n117 wind_comp_0.sg13g2_and2_2$1_0.VSS.n106 0.00827066
R6664 wind_comp_0.sg13g2_and2_2$1_0.VSS.n149 wind_comp_0.sg13g2_and2_2$1_0.VSS.n299 0.0205873
R6665 wind_comp_0.sg13g2_and2_2$1_0.VSS.n194 wind_comp_0.sg13g2_and2_2$1_0.VSS.n295 0.0096082
R6666 wind_comp_0.sg13g2_and2_2$1_0.VSS.n2075 wind_comp_0.sg13g2_and2_2$1_0.VSS.n86 0.00983726
R6667 wind_comp_0.sg13g2_and2_2$1_0.VSS.n2035 wind_comp_0.sg13g2_and2_2$1_0.VSS.n1967 0.00208377
R6668 wind_comp_0.sg13g2_and2_2$1_0.VSS.n359 wind_comp_0.sg13g2_and2_2$1_0.VSS.n358 0.00661313
R6669 wind_comp_0.sg13g2_and2_2$1_0.VSS.n2140 wind_comp_0.sg13g2_and2_2$1_0.VSS.n361 0.00733367
R6670 wind_comp_0.sg13g2_and2_2$1_0.VSS.n627 wind_comp_0.sg13g2_and2_2$1_0.VSS.n1959 0.00193979
R6671 wind_comp_0.sg13g2_and2_2$1_0.VSS.n2144 wind_comp_0.sg13g2_and2_2$1_0.VSS.n1960 0.00193979
R6672 wind_comp_0.sg13g2_and2_2$1_0.VSS.n2147 wind_comp_0.sg13g2_and2_2$1_0.VSS.n1961 0.00193979
R6673 wind_comp_0.sg13g2_and2_2$1_0.VSS.n2148 wind_comp_0.sg13g2_and2_2$1_0.VSS.n282 0.00193979
R6674 wind_comp_0.sg13g2_and2_2$1_0.VSS.n283 wind_comp_0.sg13g2_and2_2$1_0.VSS.n282 0.00661313
R6675 wind_comp_0.sg13g2_and2_2$1_0.VSS.n2151 wind_comp_0.sg13g2_and2_2$1_0.VSS.n285 0.00733367
R6676 wind_comp_0.sg13g2_and2_2$1_0.VSS.n397 wind_comp_0.sg13g2_and2_2$1_0.VSS.n396 0.00661313
R6677 wind_comp_0.sg13g2_and2_2$1_0.VSS.n2155 wind_comp_0.sg13g2_and2_2$1_0.VSS.n399 0.00733367
R6678 wind_comp_0.sg13g2_and2_2$1_0.VSS.n2157 wind_comp_0.sg13g2_and2_2$1_0.VSS.n2156 0.00193979
R6679 wind_comp_0.sg13g2_and2_2$1_0.VSS.n2159 wind_comp_0.sg13g2_and2_2$1_0.VSS.n2158 0.00193979
R6680 wind_comp_0.sg13g2_and2_2$1_0.VSS.n2161 wind_comp_0.sg13g2_and2_2$1_0.VSS.n2160 0.00193979
R6681 wind_comp_0.sg13g2_and2_2$1_0.VSS.n2163 wind_comp_0.sg13g2_and2_2$1_0.VSS.n2162 0.00193979
R6682 wind_comp_0.sg13g2_and2_2$1_0.VSS.n2165 wind_comp_0.sg13g2_and2_2$1_0.VSS.n2164 0.00193979
R6683 wind_comp_0.sg13g2_and2_2$1_0.VSS.n2167 wind_comp_0.sg13g2_and2_2$1_0.VSS.n2166 0.00193979
R6684 wind_comp_0.sg13g2_and2_2$1_0.VSS.n2169 wind_comp_0.sg13g2_and2_2$1_0.VSS.n2168 0.00193979
R6685 wind_comp_0.sg13g2_and2_2$1_0.VSS.n2171 wind_comp_0.sg13g2_and2_2$1_0.VSS.n2170 0.00193979
R6686 wind_comp_0.sg13g2_and2_2$1_0.VSS.n2173 wind_comp_0.sg13g2_and2_2$1_0.VSS.n2172 0.00193979
R6687 wind_comp_0.sg13g2_and2_2$1_0.VSS.n2175 wind_comp_0.sg13g2_and2_2$1_0.VSS.n2174 0.00193979
R6688 wind_comp_0.sg13g2_and2_2$1_0.VSS.n2177 wind_comp_0.sg13g2_and2_2$1_0.VSS.n2176 0.00193979
R6689 wind_comp_0.sg13g2_and2_2$1_0.VSS.n2179 wind_comp_0.sg13g2_and2_2$1_0.VSS.n2178 0.00193979
R6690 wind_comp_0.sg13g2_and2_2$1_0.VSS.n2181 wind_comp_0.sg13g2_and2_2$1_0.VSS.n2180 0.00193979
R6691 wind_comp_0.sg13g2_and2_2$1_0.VSS.n2183 wind_comp_0.sg13g2_and2_2$1_0.VSS.n2182 0.00193979
R6692 wind_comp_0.sg13g2_and2_2$1_0.VSS.n2185 wind_comp_0.sg13g2_and2_2$1_0.VSS.n2184 0.00193979
R6693 wind_comp_0.sg13g2_and2_2$1_0.VSS.n2187 wind_comp_0.sg13g2_and2_2$1_0.VSS.n2186 0.00193979
R6694 wind_comp_0.sg13g2_and2_2$1_0.VSS.n2189 wind_comp_0.sg13g2_and2_2$1_0.VSS.n2188 0.00193979
R6695 wind_comp_0.sg13g2_and2_2$1_0.VSS.n2191 wind_comp_0.sg13g2_and2_2$1_0.VSS.n2190 0.00193979
R6696 wind_comp_0.sg13g2_and2_2$1_0.VSS.n2193 wind_comp_0.sg13g2_and2_2$1_0.VSS.n2192 0.00193979
R6697 wind_comp_0.sg13g2_and2_2$1_0.VSS.n2195 wind_comp_0.sg13g2_and2_2$1_0.VSS.n2194 0.00193979
R6698 wind_comp_0.sg13g2_and2_2$1_0.VSS.n2197 wind_comp_0.sg13g2_and2_2$1_0.VSS.n2196 0.00193979
R6699 wind_comp_0.sg13g2_and2_2$1_0.VSS.n2199 wind_comp_0.sg13g2_and2_2$1_0.VSS.n2198 0.00193979
R6700 wind_comp_0.sg13g2_and2_2$1_0.VSS.n2201 wind_comp_0.sg13g2_and2_2$1_0.VSS.n2200 0.00193979
R6701 wind_comp_0.sg13g2_and2_2$1_0.VSS.n2203 wind_comp_0.sg13g2_and2_2$1_0.VSS.n2202 0.00193979
R6702 wind_comp_0.sg13g2_and2_2$1_0.VSS.n2205 wind_comp_0.sg13g2_and2_2$1_0.VSS.n2204 0.00193979
R6703 wind_comp_0.sg13g2_and2_2$1_0.VSS.n2442 wind_comp_0.sg13g2_and2_2$1_0.VSS.n2223 0.00193979
R6704 wind_comp_0.sg13g2_and2_2$1_0.VSS.n2346 wind_comp_0.sg13g2_and2_2$1_0.VSS.n924 0.00193979
R6705 wind_comp_0.sg13g2_and2_2$1_0.VSS.n2407 wind_comp_0.sg13g2_and2_2$1_0.VSS.n947 0.00193979
R6706 wind_comp_0.sg13g2_and2_2$1_0.VSS.n629 wind_comp_0.sg13g2_and2_2$1_0.VSS.n628 0.00193979
R6707 wind_comp_0.sg13g2_and2_2$1_0.VSS.n2057 wind_comp_0.sg13g2_and2_2$1_0.VSS.n2029 0.00179581
R6708 wind_comp_0.sg13g2_and2_2$1_0.VSS.n2417 wind_comp_0.sg13g2_and2_2$1_0.VSS.n913 0.00179581
R6709 wind_comp_0.sg13g2_and2_2$1_0.VSS.n2397 wind_comp_0.sg13g2_and2_2$1_0.VSS.n918 0.00179581
R6710 wind_comp_0.sg13g2_and2_2$1_0.VSS.n121 wind_comp_0.sg13g2_and2_2$1_0.VSS.n1229 2689.93
R6711 wind_comp_0.sg13g2_and2_2$1_0.VSS.n1007 wind_comp_0.sg13g2_and2_2$1_0.VSS.n816 0.00177721
R6712 wind_comp_0.sg13g2_and2_2$1_0.VSS.n1010 wind_comp_0.sg13g2_and2_2$1_0.VSS.n817 0.00177721
R6713 wind_comp_0.sg13g2_and2_2$1_0.VSS.n1009 wind_comp_0.sg13g2_and2_2$1_0.VSS.n818 0.00177721
R6714 wind_comp_0.sg13g2_and2_2$1_0.VSS.n1012 wind_comp_0.sg13g2_and2_2$1_0.VSS.n819 0.00177721
R6715 wind_comp_0.sg13g2_and2_2$1_0.VSS.n1011 wind_comp_0.sg13g2_and2_2$1_0.VSS.n820 0.00177721
R6716 wind_comp_0.sg13g2_and2_2$1_0.VSS.n1014 wind_comp_0.sg13g2_and2_2$1_0.VSS.n821 0.00177721
R6717 wind_comp_0.sg13g2_and2_2$1_0.VSS.n1013 wind_comp_0.sg13g2_and2_2$1_0.VSS.n822 0.00177721
R6718 wind_comp_0.sg13g2_and2_2$1_0.VSS.n1028 wind_comp_0.sg13g2_and2_2$1_0.VSS.n823 0.00177721
R6719 wind_comp_0.sg13g2_and2_2$1_0.VSS.n1027 wind_comp_0.sg13g2_and2_2$1_0.VSS.n824 0.00177721
R6720 wind_comp_0.sg13g2_and2_2$1_0.VSS.n909 wind_comp_0.sg13g2_and2_2$1_0.VSS.n825 0.00177721
R6721 wind_comp_0.sg13g2_and2_2$1_0.VSS.n908 wind_comp_0.sg13g2_and2_2$1_0.VSS.n826 0.00177721
R6722 wind_comp_0.sg13g2_and2_2$1_0.VSS.n907 wind_comp_0.sg13g2_and2_2$1_0.VSS.n827 0.00177721
R6723 wind_comp_0.sg13g2_and2_2$1_0.VSS.n987 wind_comp_0.sg13g2_and2_2$1_0.VSS.n828 0.00177721
R6724 wind_comp_0.sg13g2_and2_2$1_0.VSS.n986 wind_comp_0.sg13g2_and2_2$1_0.VSS.n829 0.00177721
R6725 wind_comp_0.sg13g2_and2_2$1_0.VSS.n998 wind_comp_0.sg13g2_and2_2$1_0.VSS.n830 0.00177721
R6726 wind_comp_0.sg13g2_and2_2$1_0.VSS.n997 wind_comp_0.sg13g2_and2_2$1_0.VSS.n831 0.00177721
R6727 wind_comp_0.sg13g2_and2_2$1_0.VSS.n1031 wind_comp_0.sg13g2_and2_2$1_0.VSS.n832 0.00177721
R6728 wind_comp_0.sg13g2_and2_2$1_0.VSS.n1029 wind_comp_0.sg13g2_and2_2$1_0.VSS.n833 0.00177721
R6729 wind_comp_0.sg13g2_and2_2$1_0.VSS.n1030 wind_comp_0.sg13g2_and2_2$1_0.VSS.n834 0.00177721
R6730 wind_comp_0.sg13g2_and2_2$1_0.VSS.n1033 wind_comp_0.sg13g2_and2_2$1_0.VSS.n835 0.00177721
R6731 wind_comp_0.sg13g2_and2_2$1_0.VSS.n1032 wind_comp_0.sg13g2_and2_2$1_0.VSS.n836 0.00177721
R6732 wind_comp_0.sg13g2_and2_2$1_0.VSS.n1036 wind_comp_0.sg13g2_and2_2$1_0.VSS.n837 0.00177721
R6733 wind_comp_0.sg13g2_and2_2$1_0.VSS.n1052 wind_comp_0.sg13g2_and2_2$1_0.VSS.n851 0.00177721
R6734 wind_comp_0.sg13g2_and2_2$1_0.VSS.n362 wind_comp_0.sg13g2_and2_2$1_0.VSS.n83 1.36364
R6735 wind_comp_0.sg13g2_and2_2$1_0.VSS.n124 wind_comp_0.sg13g2_and2_2$1_0.VSS.n122 0.467842
R6736 wind_comp_0.sg13g2_and2_2$1_0.VSS.n79 wind_comp_0.sg13g2_and2_2$1_0.VSS.n75 0.195464
R6737 wind_comp_0.sg13g2_and2_2$1_0.VSS.n35 wind_comp_0.sg13g2_and2_2$1_0.VSS.n2002 0.0962252
R6738 wind_comp_0.sg13g2_and2_2$1_0.VSS.n52 wind_comp_0.sg13g2_and2_2$1_0.VSS.n135 0.0427587
R6739 wind_comp_0.sg13g2_and2_2$1_0.VSS.n69 wind_comp_0.sg13g2_and2_2$1_0.VSS.n68 0.0263215
R6740 wind_comp_0.sg13g2_and2_2$1_0.VSS.n85 wind_comp_0.sg13g2_and2_2$1_0.VSS.n84 0.0152571
R6741 wind_comp_0.sg13g2_and2_2$1_0.VSS.n74 wind_comp_0.sg13g2_and2_2$1_0.VSS.n72 0.0425842
R6742 wind_comp_0.sg13g2_and2_2$1_0.VSS.n90 wind_comp_0.sg13g2_and2_2$1_0.VSS.n355 0.0408709
R6743 wind_comp_0.sg13g2_and2_2$1_0.VSS.n1848 wind_comp_0.sg13g2_and2_2$1_0.VSS.n91 0.0396262
R6744 wind_comp_0.sg13g2_and2_2$1_0.VSS.n120 wind_comp_0.sg13g2_and2_2$1_0.VSS.n93 0.0395707
R6745 wind_comp_0.sg13g2_and2_2$1_0.VSS.n146 wind_comp_0.sg13g2_and2_2$1_0.VSS.n145 0.0393682
R6746 wind_comp_0.sg13g2_and2_2$1_0.VSS.n656 wind_comp_0.sg13g2_and2_2$1_0.VSS.n104 0.0317098
R6747 wind_comp_0.sg13g2_and2_2$1_0.VSS.n10 wind_comp_0.sg13g2_and2_2$1_0.VSS.n117 0.0163895
R6748 wind_comp_0.sg13g2_and2_2$1_0.VSS.n65 wind_comp_0.sg13g2_and2_2$1_0.VSS.n61 0.0345097
R6749 wind_comp_0.sg13g2_and2_2$1_0.VSS.n199 wind_comp_0.sg13g2_and2_2$1_0.VSS.n654 0.0332815
R6750 wind_comp_0.sg13g2_and2_2$1_0.VSS.n128 wind_comp_0.sg13g2_and2_2$1_0.VSS.n129 0.0324286
R6751 wind_comp_0.sg13g2_and2_2$1_0.VSS.n51 wind_comp_0.sg13g2_and2_2$1_0.VSS.n2563 88.0721
C336 vss_3v3 0 2.64815f
C337 vdd_3v3 0 9.2084f
C338 vdd1v2 0 31.3532f
C339 vss_1v2_uq0 0 0.16793p
C340 dig_out[0] 0 0.08388f
C341 dig_out[1] 0 0.02328f
C342 dig_out[2] 0 0.02328f
C343 dig_out[3] 0 0.02328f
C344 dig_out[4] 0 0.02328f
C345 dig_out[5] 0 0.02328f
C346 dig_out[6] 0 0.02328f
C347 dig_out[7] 0 0.02328f
C348 dig_out[8] 0 0.02328f
C349 dig_out[9] 0 0.02328f
C350 dig_out[10] 0 0.02328f
C351 dig_out[11] 0 0.03148f
C352 dig_in[0] 0 0.03148f
C353 dig_in[1] 0 0.02328f
C354 dig_in[2] 0 0.02328f
C355 dig_in[3] 0 0.02328f
C356 dig_in[4] 0 0.02328f
C357 dig_in[5] 0 0.02328f
C358 dig_in[6] 0 0.02328f
C359 dig_in[7] 0 0.02328f
C360 dig_in[8] 0 0.02328f
C361 dig_in[9] 0 0.02328f
C362 dig_in[10] 0 0.02328f
C363 dig_in[11] 0 0.02328f
C364 dig_in[12] 0 0.02328f
C365 dig_in[13] 0 0.02328f
C366 dig_in[14] 0 0.02328f
C367 dig_in[15] 0 0.02328f
C368 dig_in[16] 0 0.02328f
C369 dig_in[17] 0 0.02328f
C370 dig_in[18] 0 0.02328f
C371 dig_in[19] 0 0.02328f
C372 dig_in[20] 0 0.02328f
C373 dig_in[21] 0 0.02328f
C374 dig_in[22] 0 0.02328f
C375 dig_in[23] 0 0.02328f
C376 reset 0 0.02338f
C377 clk 0 0.04958f
C378 vbias 0 0.17988f
C379 ibias1 0 0.17988f
C380 analog_bus3 0 0.17988f
C381 s4_an_0_esd 0 0.15384f
C382 vss_1v2 0 6.4351f
C383 analog_bus0 0 19.7113f
C384 s4_an 0 32.7615f
C385 analog_bus2 0 16.9261f
C386 ibias 0 16.8484f
C387 analog_bus1 0 8.36941f
C388 enable 0 31.40264f
C389 m5_21908_34934# 0 42.7631f
C390 m4_58962_27032# 0 0.33136f
C391 m4_58437_27032# 0 0.18532f
C392 m4_57912_27032# 0 0.2432f
C393 m4_57537_27032# 0 0.1321f
C394 m4_57012_27032# 0 0.27188f
C395 m4_56527_27032# 0 0.27577f
C396 m4_56152_27032# 0 0.14165f
C397 m4_55627_27032r# 0 0.25322f
C398 m4_55102_27032# 0 0.20983f
C399 m4_54577_27032# 0 0.27758f
C400 m4_48706_27032# 0 0.27758f
C401 m4_48181_27032# 0 0.20983f
C402 m4_47656_27032# 0 0.25322f
C403 m4_47281_27032# 0 0.14165f
C404 m4_46756_27032# 0 0.27577f
C405 m4_46271_27032# 0 0.27188f
C406 m4_45896_27032# 0 0.1321f
C407 m4_45371_27032r# 0 0.2432f
C408 m4_44846_27032# 0 0.18532f
C409 m4_44321_27032# 0 0.33136f
C410 m4_21542_3976# 0 49.4227f
C411 m3_0_18723# 0 0.05419f
C412 m3_0_19311# 0 0.02904f
C413 m3_0_19899# 0 0.02904f
C414 m3_0_20487# 0 0.02904f
C415 m3_0_21075# 0 0.02904f
C416 m3_0_21663# 0 0.02904f
C417 m3_0_22251# 0 0.02904f
C418 m3_0_22839# 0 0.08849f
C419 wind_comp_0.comparator_1.dynamic_pcell$2_0.O_DRN 0 2.70316f ; **FLOATING
C420 wind_comp_0.comparator_0.dynamic_pcell$2_0.O_DRN 0 2.70316f ; **FLOATING
C421 wind_comp_0.comparator_1.sg13cmos5l_inv_16_0.A 0 2.36382f ; **FLOATING
C422 wind_comp_0.comparator_1.nmos_0.Gate 0 1.16908f ; **FLOATING
C423 a_51539_28086# 0 0.22926f ; **FLOATING
C424 wind_comp_0.sg13g2_and2_2$1_0.B 0 1.78563f ; **FLOATING
C425 wind_comp_0.comparator_0.nmos_0.Gate 0 1.16552f ; **FLOATING
C426 wind_comp_0.sg13g2_and2_2$1_0.A 0 2.04302f ; **FLOATING
C427 wind_comp_0.comparator_0.sg13cmos5l_inv_16_0.A 0 2.36382f ; **FLOATING
C428 wind_comp_0.comparator_1.nmos$2_0.Drain 0 28.2177f ; **FLOATING
C429 wind_comp_0.comparator_0.nmos$2_0.Drain 0 28.2183f ; **FLOATING
C430 wind_comp_0.comparator_1.dynamic_pcell$2_0.DRN_NET_LM_GATE_KL 0 7.01239f ; **FLOATING
C431 wind_comp_0.comparator_1.dynamic_pcell_0.DRN_NET_GJ_GATE_GH 0 6.48344f ; **FLOATING
C432 wind_comp_0.comparator_1.dynamic_pcell_0.SRC_NET_IJ 0 0.12861f ; **FLOATING
C433 wind_comp_0.comparator_1.dynamic_pcell_0.DRN_NET_IH 0 3.25607f ; **FLOATING
C434 wind_comp_0.comparator_1.dynamic_pcell$1_0.DRN_NET_PQ_GATE_Q 0 15.5169f ; **FLOATING
C435 wind_comp_0.comparator_1.dynamic_pcell$1_0.P_GATE 0 16.0055f ; **FLOATING
C436 wind_comp_0.comparator_1.dynamic_pcell$7_0.DRN_NET_BE_GATE_AB 0 1.29999f ; **FLOATING
C437 wind_comp_0.comparator_1.dynamic_pcell$7_0.DRN_NET_CF_GATE_CD 0 1.16596f ; **FLOATING
C438 wind_comp_0.comparator_0.dynamic_pcell$7_0.DRN_NET_CF_GATE_CD 0 1.17044f ; **FLOATING
C439 wind_comp_0.comparator_0.dynamic_pcell$7_0.DRN_NET_BE_GATE_AB 0 1.30534f ; **FLOATING
C440 wind_comp_0.comparator_0.dynamic_pcell_0.DRN_NET_IH 0 3.25608f ; **FLOATING
C441 wind_comp_0.comparator_0.dynamic_pcell_0.DRN_NET_GJ_GATE_GH 0 6.48352f ; **FLOATING
C442 wind_comp_0.comparator_0.dynamic_pcell$1_0.DRN_NET_PQ_GATE_Q 0 15.8304f ; **FLOATING
C443 wind_comp_0.comparator_0.dynamic_pcell$1_0.P_GATE 0 16.0413f ; **FLOATING
C444 wind_comp_0.comparator_0.dynamic_pcell_0.SRC_NET_IJ 0 0.14047f ; **FLOATING
C445 wind_comp_0.comparator_0.dynamic_pcell$2_0.DRN_NET_LM_GATE_KL 0 7.11009f ; **FLOATING
C446 wind_comp_0.sg13g2_and2_2$1_0.VDD.n0 0 0.87647f ; **FLOATING
C447 wind_comp_0.sg13g2_and2_2$1_0.VDD.n1 0 0.10721f ; **FLOATING
C448 wind_comp_0.sg13g2_and2_2$1_0.VDD.n2 0 0.0167f ; **FLOATING
C449 wind_comp_0.sg13g2_and2_2$1_0.VDD.n4 0 1.91757f ; **FLOATING
C450 wind_comp_0.sg13g2_and2_2$1_0.VDD.n5 0 0.12704f ; **FLOATING
C451 wind_comp_0.sg13g2_and2_2$1_0.VDD.n6 0 0.02262f ; **FLOATING
C452 wind_comp_0.sg13g2_and2_2$1_0.VDD.n7 0 0.01491f ; **FLOATING
C453 wind_comp_0.sg13g2_and2_2$1_0.VDD.n9 0 0.01611f ; **FLOATING
C454 wind_comp_0.sg13g2_and2_2$1_0.VDD.n10 0 0.2794f ; **FLOATING
C455 wind_comp_0.sg13g2_and2_2$1_0.VDD.n11 0 0.07458f ; **FLOATING
C456 wind_comp_0.sg13g2_and2_2$1_0.VDD.n12 0 0.08801f ; **FLOATING
C457 wind_comp_0.sg13g2_and2_2$1_0.VDD.n13 0 0.88302f ; **FLOATING
C458 wind_comp_0.sg13g2_and2_2$1_0.VDD.n14 0 0.08431f ; **FLOATING
C459 wind_comp_0.sg13g2_and2_2$1_0.VDD.n15 0 0.06504f ; **FLOATING
C460 wind_comp_0.sg13g2_and2_2$1_0.VDD.n17 0 0.60601f ; **FLOATING
C461 wind_comp_0.sg13g2_and2_2$1_0.VDD.n18 0 0.04366f ; **FLOATING
C462 wind_comp_0.sg13g2_and2_2$1_0.VDD.n19 0 0.28378f ; **FLOATING
C463 wind_comp_0.sg13g2_and2_2$1_0.VDD.n20 0 0.03726f ; **FLOATING
C464 wind_comp_0.sg13g2_and2_2$1_0.VDD.n21 0 0.02447f ; **FLOATING
C465 wind_comp_0.sg13g2_and2_2$1_0.VDD.n22 0 0.04314f ; **FLOATING
C466 wind_comp_0.sg13g2_and2_2$1_0.VDD.n23 0 0.03617f ; **FLOATING
C467 wind_comp_0.sg13g2_and2_2$1_0.VDD.n24 0 0.04267f ; **FLOATING
C468 wind_comp_0.sg13g2_and2_2$1_0.VDD.n26 0 0.08138f ; **FLOATING
C469 wind_comp_0.sg13g2_and2_2$1_0.VDD.t23 0 0.01859f ; **FLOATING
C470 wind_comp_0.sg13g2_and2_2$1_0.VDD.n27 0 0.03358f ; **FLOATING
C471 wind_comp_0.sg13g2_and2_2$1_0.VDD.n28 0 0.02103f ; **FLOATING
C472 wind_comp_0.sg13g2_and2_2$1_0.VDD.t13 0 0.01859f ; **FLOATING
C473 wind_comp_0.sg13g2_and2_2$1_0.VDD.n29 0 0.05435f ; **FLOATING
C474 wind_comp_0.sg13g2_and2_2$1_0.VDD.n30 0 0.03177f ; **FLOATING
C475 wind_comp_0.sg13g2_and2_2$1_0.VDD.t11 0 0.02489f ; **FLOATING
C476 wind_comp_0.sg13g2_and2_2$1_0.VDD.t10 0 0.02901f ; **FLOATING
C477 wind_comp_0.sg13g2_and2_2$1_0.VDD.n31 0 0.05261f ; **FLOATING
C478 wind_comp_0.sg13g2_and2_2$1_0.VDD.n32 0 0.02082f ; **FLOATING
C479 wind_comp_0.sg13g2_and2_2$1_0.VDD.t15 0 0.01859f ; **FLOATING
C480 wind_comp_0.sg13g2_and2_2$1_0.VDD.n33 0 0.03346f ; **FLOATING
C481 wind_comp_0.sg13g2_and2_2$1_0.VDD.n34 0 0.01182f ; **FLOATING
C482 wind_comp_0.sg13g2_and2_2$1_0.VDD.t17 0 0.01859f ; **FLOATING
C483 wind_comp_0.sg13g2_and2_2$1_0.VDD.n36 0 0.04617f ; **FLOATING
C484 wind_comp_0.sg13g2_and2_2$1_0.VDD.n37 0 0.02092f ; **FLOATING
C485 wind_comp_0.sg13g2_and2_2$1_0.VDD.t19 0 0.01859f ; **FLOATING
C486 wind_comp_0.sg13g2_and2_2$1_0.VDD.n38 0 0.04531f ; **FLOATING
C487 wind_comp_0.sg13g2_and2_2$1_0.VDD.n39 0 0.02145f ; **FLOATING
C488 wind_comp_0.sg13g2_and2_2$1_0.VDD.t21 0 0.01859f ; **FLOATING
C489 wind_comp_0.sg13g2_and2_2$1_0.VDD.n40 0 0.04483f ; **FLOATING
C490 wind_comp_0.sg13g2_and2_2$1_0.VDD.n41 0 0.02174f ; **FLOATING
C491 wind_comp_0.sg13g2_and2_2$1_0.VDD.t61 0 0.01858f ; **FLOATING
C492 wind_comp_0.sg13g2_and2_2$1_0.VDD.n43 0 0.01857f ; **FLOATING
C493 wind_comp_0.sg13g2_and2_2$1_0.VDD.n44 0 0.02152f ; **FLOATING
C494 wind_comp_0.sg13g2_and2_2$1_0.VDD.t63 0 0.01859f ; **FLOATING
C495 wind_comp_0.sg13g2_and2_2$1_0.VDD.n46 0 0.02259f ; **FLOATING
C496 wind_comp_0.sg13g2_and2_2$1_0.VDD.t65 0 0.01859f ; **FLOATING
C497 wind_comp_0.sg13g2_and2_2$1_0.VDD.n48 0 0.02598f ; **FLOATING
C498 wind_comp_0.sg13g2_and2_2$1_0.VDD.t67 0 0.01859f ; **FLOATING
C499 wind_comp_0.sg13g2_and2_2$1_0.VDD.n50 0 0.02604f ; **FLOATING
C500 wind_comp_0.sg13g2_and2_2$1_0.VDD.t69 0 0.01859f ; **FLOATING
C501 wind_comp_0.sg13g2_and2_2$1_0.VDD.n52 0 0.02263f ; **FLOATING
C502 wind_comp_0.sg13g2_and2_2$1_0.VDD.t71 0 0.01859f ; **FLOATING
C503 wind_comp_0.sg13g2_and2_2$1_0.VDD.n54 0 0.02246f ; **FLOATING
C504 wind_comp_0.sg13g2_and2_2$1_0.VDD.t75 0 0.01701f ; **FLOATING
C505 wind_comp_0.sg13g2_and2_2$1_0.VDD.n57 0 0.029f ; **FLOATING
C506 wind_comp_0.sg13g2_and2_2$1_0.VDD.t73 0 0.01859f ; **FLOATING
C507 wind_comp_0.sg13g2_and2_2$1_0.VDD.n58 0 0.02238f ; **FLOATING
C508 wind_comp_0.sg13g2_and2_2$1_0.VDD.n60 0 0.0661f ; **FLOATING
C509 wind_comp_0.sg13g2_and2_2$1_0.VDD.n61 0 0.04855f ; **FLOATING
C510 wind_comp_0.sg13g2_and2_2$1_0.VDD.n62 0 0.0255f ; **FLOATING
C511 wind_comp_0.sg13g2_and2_2$1_0.VDD.t94 0 0.01699f ; **FLOATING
C512 wind_comp_0.sg13g2_and2_2$1_0.VDD.n63 0 0.02534f ; **FLOATING
C513 wind_comp_0.sg13g2_and2_2$1_0.VDD.t60 0 0.01942f ; **FLOATING
C514 wind_comp_0.sg13g2_and2_2$1_0.VDD.n65 0 0.02157f ; **FLOATING
C515 wind_comp_0.sg13g2_and2_2$1_0.VDD.n68 0 0.59153f ; **FLOATING
C516 wind_comp_0.sg13g2_and2_2$1_0.VDD.n69 0 0.01673f ; **FLOATING
C517 wind_comp_0.sg13g2_and2_2$1_0.VDD.n70 0 0.036f ; **FLOATING
C518 wind_comp_0.sg13g2_and2_2$1_0.VDD.n71 0 0.24184f ; **FLOATING
C519 wind_comp_0.sg13g2_and2_2$1_0.VDD.n72 0 0.61971f ; **FLOATING
C520 wind_comp_0.sg13g2_and2_2$1_0.VDD.n73 0 0.15587f ; **FLOATING
C521 wind_comp_0.sg13g2_and2_2$1_0.VDD.n74 0 0.02878f ; **FLOATING
C522 wind_comp_0.sg13g2_and2_2$1_0.VDD.n75 0 0.01525f ; **FLOATING
C523 wind_comp_0.sg13g2_and2_2$1_0.VDD.n78 0 0.01191f ; **FLOATING
C524 wind_comp_0.sg13g2_and2_2$1_0.VDD.t124 0 0.03157f ; **FLOATING
C525 wind_comp_0.sg13g2_and2_2$1_0.VDD.n80 0 0.01191f ; **FLOATING
C526 wind_comp_0.sg13g2_and2_2$1_0.VDD.n84 0 0.01191f ; **FLOATING
C527 wind_comp_0.sg13g2_and2_2$1_0.VDD.t117 0 0.03157f ; **FLOATING
C528 wind_comp_0.sg13g2_and2_2$1_0.VDD.n86 0 0.01191f ; **FLOATING
C529 wind_comp_0.sg13g2_and2_2$1_0.VDD.t119 0 0.03147f ; **FLOATING
C530 wind_comp_0.sg13g2_and2_2$1_0.VDD.n93 0 0.01191f ; **FLOATING
C531 wind_comp_0.sg13g2_and2_2$1_0.VDD.t111 0 0.03157f ; **FLOATING
C532 wind_comp_0.sg13g2_and2_2$1_0.VDD.n94 0 0.01191f ; **FLOATING
C533 wind_comp_0.sg13g2_and2_2$1_0.VDD.t108 0 0.03147f ; **FLOATING
C534 wind_comp_0.sg13g2_and2_2$1_0.VDD.n96 0 0.01548f ; **FLOATING
C535 wind_comp_0.sg13g2_and2_2$1_0.VDD.n100 0 0.05419f ; **FLOATING
C536 wind_comp_0.sg13g2_and2_2$1_0.VDD.n101 0 0.08079f ; **FLOATING
C537 wind_comp_0.sg13g2_and2_2$1_0.VDD.n103 0 0.07419f ; **FLOATING
C538 wind_comp_0.sg13g2_and2_2$1_0.VDD.n104 0 0.01051f ; **FLOATING
C539 wind_comp_0.sg13g2_and2_2$1_0.VDD.t113 0 0.03157f ; **FLOATING
C540 wind_comp_0.sg13g2_and2_2$1_0.VDD.n106 0 0.01191f ; **FLOATING
C541 wind_comp_0.sg13g2_and2_2$1_0.VDD.t126 0 0.03147f ; **FLOATING
C542 wind_comp_0.sg13g2_and2_2$1_0.VDD.n110 0 0.01589f ; **FLOATING
C543 wind_comp_0.sg13g2_and2_2$1_0.VDD.n111 0 0.02822f ; **FLOATING
C544 wind_comp_0.sg13g2_and2_2$1_0.VDD.n112 0 0.0291f ; **FLOATING
C545 wind_comp_0.comparator_0.dynamic_pcell$2_0.SRC_NET_KL 0 0.19695f ; **FLOATING
C546 wind_comp_0.sg13g2_and2_2$1_0.VDD.n113 0 0.02496f ; **FLOATING
C547 wind_comp_0.sg13g2_and2_2$1_0.VDD.n116 0 0.01191f ; **FLOATING
C548 wind_comp_0.sg13g2_and2_2$1_0.VDD.t132 0 0.03157f ; **FLOATING
C549 wind_comp_0.sg13g2_and2_2$1_0.VDD.n118 0 0.01191f ; **FLOATING
C550 wind_comp_0.sg13g2_and2_2$1_0.VDD.n119 0 0.01536f ; **FLOATING
C551 wind_comp_0.sg13g2_and2_2$1_0.VDD.t129 0 0.03147f ; **FLOATING
C552 wind_comp_0.sg13g2_and2_2$1_0.VDD.n124 0 0.05736f ; **FLOATING
C553 wind_comp_0.sg13g2_and2_2$1_0.VDD.n125 0 0.10259f ; **FLOATING
C554 wind_comp_0.sg13g2_and2_2$1_0.VDD.n126 0 0.01332f ; **FLOATING
C555 wind_comp_0.sg13g2_and2_2$1_0.VDD.t195 0 0.04573f ; **FLOATING
C556 wind_comp_0.sg13g2_and2_2$1_0.VDD.n127 0 0.01022f ; **FLOATING
C557 wind_comp_0.sg13g2_and2_2$1_0.VDD.n128 0 0.01731f ; **FLOATING
C558 wind_comp_0.sg13g2_and2_2$1_0.VDD.n130 0 0.02617f ; **FLOATING
C559 wind_comp_0.sg13g2_and2_2$1_0.VDD.t140 0 0.04573f ; **FLOATING
C560 wind_comp_0.sg13g2_and2_2$1_0.VDD.n133 0 0.01022f ; **FLOATING
C561 wind_comp_0.sg13g2_and2_2$1_0.VDD.n134 0 0.01731f ; **FLOATING
C562 wind_comp_0.sg13g2_and2_2$1_0.VDD.n135 0 0.01732f ; **FLOATING
C563 wind_comp_0.sg13g2_and2_2$1_0.VDD.t135 0 0.05111f ; **FLOATING
C564 wind_comp_0.sg13g2_and2_2$1_0.VDD.n136 0 0.01023f ; **FLOATING
C565 wind_comp_0.sg13g2_and2_2$1_0.VDD.t137 0 0.08804f ; **FLOATING
C566 wind_comp_0.sg13g2_and2_2$1_0.VDD.n137 0 0.01731f ; **FLOATING
C567 wind_comp_0.sg13g2_and2_2$1_0.VDD.t134 0 0.08794f ; **FLOATING
C568 wind_comp_0.sg13g2_and2_2$1_0.VDD.t136 0 0.04573f ; **FLOATING
C569 wind_comp_0.sg13g2_and2_2$1_0.VDD.n140 0 0.01022f ; **FLOATING
C570 wind_comp_0.sg13g2_and2_2$1_0.VDD.n141 0 0.01265f ; **FLOATING
C571 wind_comp_0.sg13g2_and2_2$1_0.VDD.n142 0 0.24979f ; **FLOATING
C572 wind_comp_0.sg13g2_and2_2$1_0.VDD.n143 0 0.04597f ; **FLOATING
C573 wind_comp_0.sg13g2_and2_2$1_0.VDD.n144 0 0.04118f ; **FLOATING
C574 wind_comp_0.sg13g2_and2_2$1_0.VDD.n145 0 0.01265f ; **FLOATING
C575 wind_comp_0.sg13g2_and2_2$1_0.VDD.t102 0 0.08804f ; **FLOATING
C576 wind_comp_0.sg13g2_and2_2$1_0.VDD.t103 0 0.05111f ; **FLOATING
C577 wind_comp_0.sg13g2_and2_2$1_0.VDD.n146 0 0.01023f ; **FLOATING
C578 wind_comp_0.sg13g2_and2_2$1_0.VDD.n147 0 0.01732f ; **FLOATING
C579 wind_comp_0.sg13g2_and2_2$1_0.VDD.t139 0 0.08794f ; **FLOATING
C580 wind_comp_0.sg13g2_and2_2$1_0.VDD.n150 0 0.01361f ; **FLOATING
C581 wind_comp_0.sg13g2_and2_2$1_0.VDD.n151 0 0.01682f ; **FLOATING
C582 wind_comp_0.sg13g2_and2_2$1_0.VDD.n153 0 0.04848f ; **FLOATING
C583 wind_comp_0.sg13g2_and2_2$1_0.VDD.n155 0 0.16719f ; **FLOATING
C584 wind_comp_0.sg13g2_and2_2$1_0.VDD.n156 0 0.14174f ; **FLOATING
C585 wind_comp_0.sg13g2_and2_2$1_0.VDD.n157 0 0.14174f ; **FLOATING
C586 wind_comp_0.sg13g2_and2_2$1_0.VDD.n162 0 0.14174f ; **FLOATING
C587 wind_comp_0.sg13g2_and2_2$1_0.VDD.n163 0 0.14174f ; **FLOATING
C588 wind_comp_0.sg13g2_and2_2$1_0.VDD.n164 0 0.06171f ; **FLOATING
C589 wind_comp_0.sg13g2_and2_2$1_0.VDD.n167 0 0.07084f ; **FLOATING
C590 wind_comp_0.sg13g2_and2_2$1_0.VDD.n169 0 0.01165f ; **FLOATING
C591 wind_comp_0.sg13g2_and2_2$1_0.VDD.t153 0 0.02834f ; **FLOATING
C592 wind_comp_0.sg13g2_and2_2$1_0.VDD.n171 0 0.01165f ; **FLOATING
C593 wind_comp_0.sg13g2_and2_2$1_0.VDD.t150 0 0.02824f ; **FLOATING
C594 wind_comp_0.sg13g2_and2_2$1_0.VDD.n175 0 0.01433f ; **FLOATING
C595 wind_comp_0.sg13g2_and2_2$1_0.VDD.n176 0 0.02793f ; **FLOATING
C596 wind_comp_0.sg13g2_and2_2$1_0.VDD.n177 0 0.01359f ; **FLOATING
C597 wind_comp_0.sg13g2_and2_2$1_0.VDD.n181 0 0.01165f ; **FLOATING
C598 wind_comp_0.sg13g2_and2_2$1_0.VDD.t146 0 0.02834f ; **FLOATING
C599 wind_comp_0.sg13g2_and2_2$1_0.VDD.n183 0 0.01165f ; **FLOATING
C600 wind_comp_0.sg13g2_and2_2$1_0.VDD.t148 0 0.02824f ; **FLOATING
C601 wind_comp_0.sg13g2_and2_2$1_0.VDD.n188 0 0.01165f ; **FLOATING
C602 wind_comp_0.sg13g2_and2_2$1_0.VDD.t104 0 0.02834f ; **FLOATING
C603 wind_comp_0.sg13g2_and2_2$1_0.VDD.n190 0 0.01165f ; **FLOATING
C604 wind_comp_0.sg13g2_and2_2$1_0.VDD.t161 0 0.02824f ; **FLOATING
C605 wind_comp_0.sg13g2_and2_2$1_0.VDD.n194 0 0.11647f ; **FLOATING
C606 wind_comp_0.sg13g2_and2_2$1_0.VDD.n195 0 0.03314f ; **FLOATING
C607 wind_comp_0.sg13g2_and2_2$1_0.VDD.n197 0 0.08314f ; **FLOATING
C608 wind_comp_0.sg13g2_and2_2$1_0.VDD.n204 0 0.01645f ; **FLOATING
C609 wind_comp_0.sg13g2_and2_2$1_0.VDD.n205 0 0.01942f ; **FLOATING
C610 wind_comp_0.sg13g2_and2_2$1_0.VDD.n206 0 0.01364f ; **FLOATING
C611 wind_comp_0.sg13g2_and2_2$1_0.VDD.n207 0 0.01774f ; **FLOATING
C612 wind_comp_0.sg13g2_and2_2$1_0.VDD.n216 0 0.01121f ; **FLOATING
C613 wind_comp_0.sg13g2_and2_2$1_0.VDD.n225 0 0.01655f ; **FLOATING
C614 wind_comp_0.sg13g2_and2_2$1_0.VDD.n226 0 0.01792f ; **FLOATING
C615 wind_comp_0.sg13g2_and2_2$1_0.VDD.n227 0 0.01905f ; **FLOATING
C616 wind_comp_0.sg13g2_and2_2$1_0.VDD.n229 0 0.01485f ; **FLOATING
C617 wind_comp_0.sg13g2_and2_2$1_0.VDD.t5 0 0.01255f ; **FLOATING
C618 wind_comp_0.sg13g2_and2_2$1_0.VDD.n230 0 0.21058f ; **FLOATING
C619 wind_comp_0.sg13g2_and2_2$1_0.VDD.t52 0 0.01677f ; **FLOATING
C620 wind_comp_0.sg13g2_and2_2$1_0.VDD.n231 0 0.47624f ; **FLOATING
C621 wind_comp_0.sg13g2_and2_2$1_0.VDD.n235 0 0.01165f ; **FLOATING
C622 wind_comp_0.sg13g2_and2_2$1_0.VDD.t172 0 0.02834f ; **FLOATING
C623 wind_comp_0.sg13g2_and2_2$1_0.VDD.n237 0 0.01165f ; **FLOATING
C624 wind_comp_0.sg13g2_and2_2$1_0.VDD.t169 0 0.02824f ; **FLOATING
C625 wind_comp_0.sg13g2_and2_2$1_0.VDD.n242 0 0.01165f ; **FLOATING
C626 wind_comp_0.sg13g2_and2_2$1_0.VDD.t159 0 0.02834f ; **FLOATING
C627 wind_comp_0.sg13g2_and2_2$1_0.VDD.n244 0 0.01165f ; **FLOATING
C628 wind_comp_0.sg13g2_and2_2$1_0.VDD.t164 0 0.02824f ; **FLOATING
C629 wind_comp_0.sg13g2_and2_2$1_0.VDD.n248 0 0.19253f ; **FLOATING
C630 wind_comp_0.sg13g2_and2_2$1_0.VDD.n249 0 0.59153f ; **FLOATING
C631 wind_comp_0.sg13g2_and2_2$1_0.VDD.n250 0 0.036f ; **FLOATING
C632 wind_comp_0.sg13g2_and2_2$1_0.VDD.n257 0 0.01645f ; **FLOATING
C633 wind_comp_0.sg13g2_and2_2$1_0.VDD.n258 0 0.01942f ; **FLOATING
C634 wind_comp_0.sg13g2_and2_2$1_0.VDD.n259 0 0.01364f ; **FLOATING
C635 wind_comp_0.sg13g2_and2_2$1_0.VDD.n260 0 0.01774f ; **FLOATING
C636 wind_comp_0.sg13g2_and2_2$1_0.VDD.n269 0 0.01121f ; **FLOATING
C637 wind_comp_0.sg13g2_and2_2$1_0.VDD.n278 0 0.01655f ; **FLOATING
C638 wind_comp_0.sg13g2_and2_2$1_0.VDD.n279 0 0.01792f ; **FLOATING
C639 wind_comp_0.sg13g2_and2_2$1_0.VDD.n280 0 0.01905f ; **FLOATING
C640 wind_comp_0.sg13g2_and2_2$1_0.VDD.n282 0 0.01485f ; **FLOATING
C641 wind_comp_0.sg13g2_and2_2$1_0.VDD.n283 0 0.01673f ; **FLOATING
C642 wind_comp_0.sg13g2_and2_2$1_0.VDD.n284 0 0.03159f ; **FLOATING
C643 wind_comp_0.sg13g2_and2_2$1_0.VDD.n285 0 0.21746f ; **FLOATING
C644 wind_comp_0.sg13g2_and2_2$1_0.VDD.n286 0 0.17045f ; **FLOATING
C645 wind_comp_0.sg13g2_and2_2$1_0.VDD.n287 0 0.24805f ; **FLOATING
C646 wind_comp_0.sg13g2_and2_2$1_0.VDD.n288 0 0.07892f ; **FLOATING
C647 wind_comp_0.sg13g2_and2_2$1_0.VDD.n289 0 0.04855f ; **FLOATING
C648 wind_comp_0.sg13g2_and2_2$1_0.VDD.n290 0 0.0661f ; **FLOATING
C649 wind_comp_0.sg13g2_and2_2$1_0.VDD.n291 0 0.01165f ; **FLOATING
C650 wind_comp_0.sg13g2_and2_2$1_0.VDD.t51 0 0.02901f ; **FLOATING
C651 wind_comp_0.sg13g2_and2_2$1_0.VDD.t49 0 0.02489f ; **FLOATING
C652 wind_comp_0.sg13g2_and2_2$1_0.VDD.n293 0 0.01893f ; **FLOATING
C653 wind_comp_0.sg13g2_and2_2$1_0.VDD.n294 0 0.01967f ; **FLOATING
C654 wind_comp_0.sg13g2_and2_2$1_0.VDD.n296 0 0.02172f ; **FLOATING
C655 wind_comp_0.sg13g2_and2_2$1_0.VDD.n297 0 0.01645f ; **FLOATING
C656 wind_comp_0.sg13g2_and2_2$1_0.VDD.n298 0 0.01165f ; **FLOATING
C657 wind_comp_0.sg13g2_and2_2$1_0.VDD.t47 0 0.01859f ; **FLOATING
C658 wind_comp_0.sg13g2_and2_2$1_0.VDD.n299 0 0.01319f ; **FLOATING
C659 wind_comp_0.sg13g2_and2_2$1_0.VDD.n300 0 0.02044f ; **FLOATING
C660 wind_comp_0.sg13g2_and2_2$1_0.VDD.t45 0 0.01859f ; **FLOATING
C661 wind_comp_0.sg13g2_and2_2$1_0.VDD.n301 0 0.01525f ; **FLOATING
C662 wind_comp_0.sg13g2_and2_2$1_0.VDD.n302 0 0.02091f ; **FLOATING
C663 wind_comp_0.sg13g2_and2_2$1_0.VDD.n303 0 0.01334f ; **FLOATING
C664 wind_comp_0.sg13g2_and2_2$1_0.VDD.n305 0 0.02142f ; **FLOATING
C665 wind_comp_0.sg13g2_and2_2$1_0.VDD.n306 0 0.01645f ; **FLOATING
C666 wind_comp_0.sg13g2_and2_2$1_0.VDD.t43 0 0.01859f ; **FLOATING
C667 wind_comp_0.sg13g2_and2_2$1_0.VDD.n308 0 0.02458f ; **FLOATING
C668 wind_comp_0.sg13g2_and2_2$1_0.VDD.n310 0 0.0225f ; **FLOATING
C669 wind_comp_0.sg13g2_and2_2$1_0.VDD.n311 0 0.01645f ; **FLOATING
C670 wind_comp_0.sg13g2_and2_2$1_0.VDD.t41 0 0.01859f ; **FLOATING
C671 wind_comp_0.sg13g2_and2_2$1_0.VDD.n313 0 0.0168f ; **FLOATING
C672 wind_comp_0.sg13g2_and2_2$1_0.VDD.n314 0 0.01354f ; **FLOATING
C673 wind_comp_0.sg13g2_and2_2$1_0.VDD.n315 0 0.0225f ; **FLOATING
C674 wind_comp_0.sg13g2_and2_2$1_0.VDD.n317 0 0.01825f ; **FLOATING
C675 wind_comp_0.sg13g2_and2_2$1_0.VDD.t39 0 0.01859f ; **FLOATING
C676 wind_comp_0.sg13g2_and2_2$1_0.VDD.n318 0 0.01885f ; **FLOATING
C677 wind_comp_0.sg13g2_and2_2$1_0.VDD.n319 0 0.01148f ; **FLOATING
C678 wind_comp_0.sg13g2_and2_2$1_0.VDD.n320 0 0.02142f ; **FLOATING
C679 wind_comp_0.sg13g2_and2_2$1_0.VDD.n322 0 0.01591f ; **FLOATING
C680 wind_comp_0.sg13g2_and2_2$1_0.VDD.n323 0 0.01264f ; **FLOATING
C681 wind_comp_0.sg13g2_and2_2$1_0.VDD.n324 0 0.01732f ; **FLOATING
C682 wind_comp_0.sg13g2_and2_2$1_0.VDD.t197 0 0.05111f ; **FLOATING
C683 wind_comp_0.sg13g2_and2_2$1_0.VDD.n325 0 0.01023f ; **FLOATING
C684 wind_comp_0.sg13g2_and2_2$1_0.VDD.t199 0 0.08804f ; **FLOATING
C685 wind_comp_0.sg13g2_and2_2$1_0.VDD.n326 0 0.01731f ; **FLOATING
C686 wind_comp_0.sg13g2_and2_2$1_0.VDD.t196 0 0.08794f ; **FLOATING
C687 wind_comp_0.sg13g2_and2_2$1_0.VDD.t198 0 0.04573f ; **FLOATING
C688 wind_comp_0.sg13g2_and2_2$1_0.VDD.n329 0 0.01022f ; **FLOATING
C689 wind_comp_0.sg13g2_and2_2$1_0.VDD.n330 0 0.01265f ; **FLOATING
C690 wind_comp_0.sg13g2_and2_2$1_0.VDD.n331 0 0.03513f ; **FLOATING
C691 wind_comp_0.sg13g2_and2_2$1_0.VDD.n332 0 0.01264f ; **FLOATING
C692 wind_comp_0.sg13g2_and2_2$1_0.VDD.n333 0 0.01732f ; **FLOATING
C693 wind_comp_0.sg13g2_and2_2$1_0.VDD.t180 0 0.05111f ; **FLOATING
C694 wind_comp_0.sg13g2_and2_2$1_0.VDD.n334 0 0.01023f ; **FLOATING
C695 wind_comp_0.sg13g2_and2_2$1_0.VDD.t182 0 0.08804f ; **FLOATING
C696 wind_comp_0.sg13g2_and2_2$1_0.VDD.n335 0 0.01731f ; **FLOATING
C697 wind_comp_0.sg13g2_and2_2$1_0.VDD.t179 0 0.08794f ; **FLOATING
C698 wind_comp_0.sg13g2_and2_2$1_0.VDD.t181 0 0.04573f ; **FLOATING
C699 wind_comp_0.sg13g2_and2_2$1_0.VDD.n338 0 0.01022f ; **FLOATING
C700 wind_comp_0.sg13g2_and2_2$1_0.VDD.n339 0 0.01265f ; **FLOATING
C701 wind_comp_0.sg13g2_and2_2$1_0.VDD.n340 0 0.07987f ; **FLOATING
C702 wind_comp_0.sg13g2_and2_2$1_0.VDD.n341 0 0.0559f ; **FLOATING
C703 wind_comp_0.comparator_1.dynamic_pcell$2_0.SRC_NET_KL 0 0.19695f ; **FLOATING
C704 wind_comp_0.sg13g2_and2_2$1_0.VDD.n342 0 0.0257f ; **FLOATING
C705 wind_comp_0.sg13g2_and2_2$1_0.VDD.n344 0 0.01264f ; **FLOATING
C706 wind_comp_0.sg13g2_and2_2$1_0.VDD.n346 0 0.01191f ; **FLOATING
C707 wind_comp_0.sg13g2_and2_2$1_0.VDD.t217 0 0.03157f ; **FLOATING
C708 wind_comp_0.sg13g2_and2_2$1_0.VDD.n348 0 0.01191f ; **FLOATING
C709 wind_comp_0.sg13g2_and2_2$1_0.VDD.t214 0 0.03147f ; **FLOATING
C710 wind_comp_0.sg13g2_and2_2$1_0.VDD.n352 0 0.07189f ; **FLOATING
C711 wind_comp_0.sg13g2_and2_2$1_0.VDD.n353 0 0.01754f ; **FLOATING
C712 wind_comp_0.sg13g2_and2_2$1_0.VDD.t204 0 0.04573f ; **FLOATING
C713 wind_comp_0.sg13g2_and2_2$1_0.VDD.n354 0 0.01022f ; **FLOATING
C714 wind_comp_0.sg13g2_and2_2$1_0.VDD.n355 0 0.01732f ; **FLOATING
C715 wind_comp_0.sg13g2_and2_2$1_0.VDD.n357 0 0.01191f ; **FLOATING
C716 wind_comp_0.sg13g2_and2_2$1_0.VDD.t226 0 0.03157f ; **FLOATING
C717 wind_comp_0.sg13g2_and2_2$1_0.VDD.n359 0 0.01191f ; **FLOATING
C718 wind_comp_0.sg13g2_and2_2$1_0.VDD.t223 0 0.03147f ; **FLOATING
C719 wind_comp_0.sg13g2_and2_2$1_0.VDD.n364 0 0.03617f ; **FLOATING
C720 wind_comp_0.sg13g2_and2_2$1_0.VDD.n365 0 0.03726f ; **FLOATING
C721 wind_comp_0.sg13g2_and2_2$1_0.VDD.n366 0 0.01973f ; **FLOATING
C722 wind_comp_0.sg13g2_and2_2$1_0.VDD.n367 0 0.0327f ; **FLOATING
C723 wind_comp_0.sg13g2_and2_2$1_0.VDD.n368 0 0.0263f ; **FLOATING
C724 wind_comp_0.sg13g2_and2_2$1_0.VDD.n369 0 0.03726f ; **FLOATING
C725 wind_comp_0.sg13g2_and2_2$1_0.VDD.n370 0 0.06981f ; **FLOATING
C726 wind_comp_0.sg13g2_and2_2$1_0.VDD.n371 0 0.02697f ; **FLOATING
C727 wind_comp_0.sg13g2_and2_2$1_0.VDD.n372 0 0.05885f ; **FLOATING
C728 wind_comp_0.sg13g2_and2_2$1_0.VDD.n377 0 0.01191f ; **FLOATING
C729 wind_comp_0.sg13g2_and2_2$1_0.VDD.n380 0 0.01191f ; **FLOATING
C730 wind_comp_0.sg13g2_and2_2$1_0.VDD.n381 0 0.05502f ; **FLOATING
C731 wind_comp_0.sg13g2_and2_2$1_0.VDD.t208 0 0.03157f ; **FLOATING
C732 wind_comp_0.sg13g2_and2_2$1_0.VDD.n384 0 0.01191f ; **FLOATING
C733 wind_comp_0.sg13g2_and2_2$1_0.VDD.t212 0 0.03147f ; **FLOATING
C734 wind_comp_0.sg13g2_and2_2$1_0.VDD.n388 0 0.01641f ; **FLOATING
C735 wind_comp_0.sg13g2_and2_2$1_0.VDD.t186 0 0.04573f ; **FLOATING
C736 wind_comp_0.sg13g2_and2_2$1_0.VDD.n390 0 0.01022f ; **FLOATING
C737 wind_comp_0.sg13g2_and2_2$1_0.VDD.n391 0 0.01732f ; **FLOATING
C738 wind_comp_0.sg13g2_and2_2$1_0.VDD.t156 0 0.05111f ; **FLOATING
C739 wind_comp_0.sg13g2_and2_2$1_0.VDD.n392 0 0.01023f ; **FLOATING
C740 wind_comp_0.sg13g2_and2_2$1_0.VDD.t155 0 0.08804f ; **FLOATING
C741 wind_comp_0.sg13g2_and2_2$1_0.VDD.n393 0 0.01731f ; **FLOATING
C742 wind_comp_0.sg13g2_and2_2$1_0.VDD.t184 0 0.08794f ; **FLOATING
C743 wind_comp_0.sg13g2_and2_2$1_0.VDD.n396 0 0.01265f ; **FLOATING
C744 wind_comp_0.sg13g2_and2_2$1_0.VDD.n397 0 0.01191f ; **FLOATING
C745 wind_comp_0.sg13g2_and2_2$1_0.VDD.t210 0 0.03157f ; **FLOATING
C746 wind_comp_0.sg13g2_and2_2$1_0.VDD.n399 0 0.01191f ; **FLOATING
C747 wind_comp_0.sg13g2_and2_2$1_0.VDD.t205 0 0.03147f ; **FLOATING
C748 wind_comp_0.sg13g2_and2_2$1_0.VDD.n404 0 0.04438f ; **FLOATING
C749 wind_comp_0.sg13g2_and2_2$1_0.VDD.n405 0 0.0548f ; **FLOATING
C750 wind_comp_0.sg13g2_and2_2$1_0.VDD.n406 0 0.03726f ; **FLOATING
C751 wind_comp_0.sg13g2_and2_2$1_0.VDD.n407 0 0.0621f ; **FLOATING
C752 wind_comp_0.sg13g2_and2_2$1_0.VDD.n408 0 0.03726f ; **FLOATING
C753 wind_comp_0.sg13g2_and2_2$1_0.VDD.n409 0 0.03726f ; **FLOATING
C754 wind_comp_0.sg13g2_and2_2$1_0.VDD.n410 0 0.03726f ; **FLOATING
C755 wind_comp_0.sg13g2_and2_2$1_0.VDD.n411 0 0.03726f ; **FLOATING
C756 wind_comp_0.sg13g2_and2_2$1_0.VDD.n412 0 0.04384f ; **FLOATING
C757 wind_comp_0.sg13g2_and2_2$1_0.VDD.n413 0 0.03726f ; **FLOATING
C758 wind_comp_0.sg13g2_and2_2$1_0.VDD.n414 0 0.03726f ; **FLOATING
C759 wind_comp_0.sg13g2_and2_2$1_0.VDD.n415 0 0.03726f ; **FLOATING
C760 wind_comp_0.sg13g2_and2_2$1_0.VDD.n416 0 0.03726f ; **FLOATING
C761 wind_comp_0.sg13g2_and2_2$1_0.VDD.n417 0 0.07677f ; **FLOATING
C762 wind_comp_0.sg13g2_and2_2$1_0.VDD.n418 0 0.07189f ; **FLOATING
C763 wind_comp_0.sg13g2_and2_2$1_0.VDD.n419 0 0.05097f ; **FLOATING
C764 wind_comp_0.sg13g2_and2_2$1_0.VDD.n421 0 0.01537f ; **FLOATING
C765 wind_comp_0.sg13g2_and2_2$1_0.VDD.t219 0 0.03157f ; **FLOATING
C766 wind_comp_0.sg13g2_and2_2$1_0.VDD.n424 0 0.01191f ; **FLOATING
C767 wind_comp_0.sg13g2_and2_2$1_0.VDD.t221 0 0.03147f ; **FLOATING
C768 wind_comp_0.sg13g2_and2_2$1_0.VDD.n428 0 0.01549f ; **FLOATING
C769 wind_comp_0.sg13g2_and2_2$1_0.VDD.n430 0 0.05096f ; **FLOATING
C770 wind_comp_0.sg13g2_and2_2$1_0.VDD.n432 0 0.01629f ; **FLOATING
C771 wind_comp_0.sg13g2_and2_2$1_0.VDD.n434 0 0.01191f ; **FLOATING
C772 wind_comp_0.sg13g2_and2_2$1_0.VDD.t228 0 0.03157f ; **FLOATING
C773 wind_comp_0.sg13g2_and2_2$1_0.VDD.n435 0 0.01191f ; **FLOATING
C774 wind_comp_0.sg13g2_and2_2$1_0.VDD.t230 0 0.03147f ; **FLOATING
C775 wind_comp_0.sg13g2_and2_2$1_0.VDD.n440 0 0.05474f ; **FLOATING
C776 wind_comp_0.sg13g2_and2_2$1_0.VDD.n441 0 0.08033f ; **FLOATING
C777 wind_comp_0.sg13g2_and2_2$1_0.VDD.n442 0 0.11297f ; **FLOATING
C778 wind_comp_0.sg13g2_and2_2$1_0.VDD.n445 0 0.01056f ; **FLOATING
C779 wind_comp_0.sg13g2_and2_2$1_0.VDD.n446 0 0.01361f ; **FLOATING
C780 wind_comp_0.sg13g2_and2_2$1_0.VDD.t202 0 0.05111f ; **FLOATING
C781 wind_comp_0.sg13g2_and2_2$1_0.VDD.n447 0 0.01023f ; **FLOATING
C782 wind_comp_0.sg13g2_and2_2$1_0.VDD.t201 0 0.08804f ; **FLOATING
C783 wind_comp_0.sg13g2_and2_2$1_0.VDD.n448 0 0.01731f ; **FLOATING
C784 wind_comp_0.sg13g2_and2_2$1_0.VDD.t203 0 0.08794f ; **FLOATING
C785 wind_comp_0.sg13g2_and2_2$1_0.VDD.n451 0 0.01265f ; **FLOATING
C786 wind_comp_0.sg13g2_and2_2$1_0.VDD.n452 0 0.03141f ; **FLOATING
C787 wind_comp_0.sg13g2_and2_2$1_0.VDD.n453 0 0.0285f ; **FLOATING
C788 wind_comp_0.sg13g2_and2_2$1_0.VDD.n454 0 0.07677f ; **FLOATING
C789 wind_comp_0.sg13g2_and2_2$1_0.VDD.n455 0 0.03726f ; **FLOATING
C790 wind_comp_0.sg13g2_and2_2$1_0.VDD.n456 0 0.03726f ; **FLOATING
C791 wind_comp_0.sg13g2_and2_2$1_0.VDD.n457 0 0.03726f ; **FLOATING
C792 wind_comp_0.sg13g2_and2_2$1_0.VDD.n458 0 0.03726f ; **FLOATING
C793 wind_comp_0.sg13g2_and2_2$1_0.VDD.n459 0 0.06611f ; **FLOATING
C794 wind_comp_0.sg13g2_and2_2$1_0.VDD.n460 0 0.0285f ; **FLOATING
C795 wind_comp_0.sg13g2_and2_2$1_0.VDD.n461 0 0.0327f ; **FLOATING
C796 wind_comp_0.sg13g2_and2_2$1_0.VDD.n462 0 0.01754f ; **FLOATING
C797 wind_comp_0.sg13g2_and2_2$1_0.VDD.n463 0 0.03726f ; **FLOATING
C798 wind_comp_0.sg13g2_and2_2$1_0.VDD.n464 0 0.0548f ; **FLOATING
C799 wind_comp_0.sg13g2_and2_2$1_0.VDD.n465 0 0.03726f ; **FLOATING
C800 wind_comp_0.sg13g2_and2_2$1_0.VDD.n466 0 0.03069f ; **FLOATING
C801 wind_comp_0.sg13g2_and2_2$1_0.VDD.n467 0 0.02921f ; **FLOATING
C802 wind_comp_0.sg13g2_and2_2$1_0.VDD.n468 0 0.01754f ; **FLOATING
C803 wind_comp_0.sg13g2_and2_2$1_0.VDD.n469 0 0.01754f ; **FLOATING
C804 wind_comp_0.sg13g2_and2_2$1_0.VDD.n470 0 0.03051f ; **FLOATING
C805 wind_comp_0.sg13g2_and2_2$1_0.VDD.n471 0 0.03069f ; **FLOATING
C806 wind_comp_0.sg13g2_and2_2$1_0.VDD.n472 0 0.01755f ; **FLOATING
C807 wind_comp_0.sg13g2_and2_2$1_0.VDD.n473 0 0.06072f ; **FLOATING
C808 wind_comp_0.sg13g2_and2_2$1_0.VDD.n474 0 0.02544f ; **FLOATING
C809 wind_comp_0.sg13g2_and2_2$1_0.VDD.n476 0 0.07453f ; **FLOATING
C810 wind_comp_0.sg13g2_and2_2$1_0.VDD.n477 0 0.14384f ; **FLOATING
C811 wind_comp_0.sg13g2_and2_2$1_0.VDD.n478 0 0.04529f ; **FLOATING
C812 wind_comp_0.sg13g2_and2_2$1_0.VDD.n479 0 0.04794f ; **FLOATING
C813 wind_comp_0.sg13g2_and2_2$1_0.VDD.n480 0 0.01271f ; **FLOATING
C814 wind_comp_0.sg13g2_and2_2$1_0.VDD.n481 0 0.16719f ; **FLOATING
C815 wind_comp_0.sg13g2_and2_2$1_0.VDD.n482 0 0.09973f ; **FLOATING
C816 wind_comp_0.sg13g2_and2_2$1_0.VDD.n483 0 0.14174f ; **FLOATING
C817 wind_comp_0.sg13g2_and2_2$1_0.VDD.n484 0 0.14174f ; **FLOATING
C818 wind_comp_0.sg13g2_and2_2$1_0.VDD.n485 0 0.14174f ; **FLOATING
C819 wind_comp_0.sg13g2_and2_2$1_0.VDD.n486 0 0.16719f ; **FLOATING
C820 wind_comp_0.sg13g2_and2_2$1_0.VDD.n487 0 0.14174f ; **FLOATING
C821 wind_comp_0.sg13g2_and2_2$1_0.VDD.n488 0 0.14174f ; **FLOATING
C822 wind_comp_0.sg13g2_and2_2$1_0.VDD.n489 0 0.14174f ; **FLOATING
C823 wind_comp_0.sg13g2_and2_2$1_0.VDD.n490 0 0.14174f ; **FLOATING
C824 wind_comp_0.sg13g2_and2_2$1_0.VDD.n491 0 0.16719f ; **FLOATING
C825 wind_comp_0.sg13g2_and2_2$1_0.VDD.n492 0 0.14174f ; **FLOATING
C826 wind_comp_0.sg13g2_and2_2$1_0.VDD.n493 0 0.14174f ; **FLOATING
C827 wind_comp_0.sg13g2_and2_2$1_0.VDD.n494 0 0.14174f ; **FLOATING
C828 wind_comp_0.sg13g2_and2_2$1_0.VDD.n496 0 0.14174f ; **FLOATING
C829 wind_comp_0.sg13g2_and2_2$1_0.VDD.n499 0 0.14174f ; **FLOATING
C830 wind_comp_0.sg13g2_and2_2$1_0.VDD.n501 0 26.0552f ; **FLOATING
C831 wind_comp_0.sg13g2_and2_2$1_0.VDD.n502 0 0.1004f ; **FLOATING
C832 wind_comp_0.sg13g2_and2_2$1_0.VDD.n503 0 0.1004f ; **FLOATING
C833 wind_comp_0.sg13g2_and2_2$1_0.VDD.n507 0 0.01165f ; **FLOATING
C834 wind_comp_0.sg13g2_and2_2$1_0.VDD.t157 0 0.02834f ; **FLOATING
C835 wind_comp_0.sg13g2_and2_2$1_0.VDD.n509 0 0.01165f ; **FLOATING
C836 wind_comp_0.sg13g2_and2_2$1_0.VDD.t166 0 0.02824f ; **FLOATING
C837 wind_comp_0.sg13g2_and2_2$1_0.VDD.n514 0 0.01165f ; **FLOATING
C838 wind_comp_0.sg13g2_and2_2$1_0.VDD.t174 0 0.02834f ; **FLOATING
C839 wind_comp_0.sg13g2_and2_2$1_0.VDD.n516 0 0.01165f ; **FLOATING
C840 wind_comp_0.sg13g2_and2_2$1_0.VDD.t176 0 0.02824f ; **FLOATING
C841 wind_comp_0.sg13g2_and2_2$1_0.VDD.n521 0 0.08259f ; **FLOATING
C842 wind_comp_0.sg13g2_and2_2$1_0.VDD.n522 0 0.0708f ; **FLOATING
C843 wind_comp_0.sg13g2_and2_2$1_0.VDD.n523 0 0.01573f ; **FLOATING
C844 wind_comp_0.sg13g2_and2_2$1_0.VDD.n524 0 0.02793f ; **FLOATING
C845 wind_comp_0.sg13g2_and2_2$1_0.VDD.n525 0 0.01359f ; **FLOATING
C846 wind_comp_0.sg13g2_and2_2$1_0.VDD.n526 0 0.0157f ; **FLOATING
C847 wind_comp_0.sg13g2_and2_2$1_0.VDD.n527 0 0.0286f ; **FLOATING
C848 wind_comp_0.comparator_1.dynamic_pcell$7_0.SRC_NET_ABCD 0 0.04764f ; **FLOATING
C849 wind_comp_0.sg13g2_and2_2$1_0.VDD.n528 0 0.01359f ; **FLOATING
C850 wind_comp_0.sg13g2_and2_2$1_0.VDD.n529 0 0.02793f ; **FLOATING
C851 wind_comp_0.sg13g2_and2_2$1_0.VDD.n530 0 0.0286f ; **FLOATING
C852 wind_comp_0.sg13g2_and2_2$1_0.VDD.n531 0 0.01569f ; **FLOATING
C853 wind_comp_0.sg13g2_and2_2$1_0.VDD.n532 0 0.06142f ; **FLOATING
C854 wind_comp_0.sg13g2_and2_2$1_0.VDD.n533 0 0.1588f ; **FLOATING
C855 wind_comp_0.sg13g2_and2_2$1_0.VDD.n534 0 0.34483f ; **FLOATING
C856 wind_comp_0.sg13g2_and2_2$1_0.VDD.n535 0 0.4023f ; **FLOATING
C857 wind_comp_0.sg13g2_and2_2$1_0.VDD.n536 0 0.16719f ; **FLOATING
C858 wind_comp_0.sg13g2_and2_2$1_0.VDD.n537 0 0.14174f ; **FLOATING
C859 wind_comp_0.sg13g2_and2_2$1_0.VDD.n538 0 0.14174f ; **FLOATING
C860 wind_comp_0.sg13g2_and2_2$1_0.VDD.n539 0 0.14174f ; **FLOATING
C861 wind_comp_0.sg13g2_and2_2$1_0.VDD.n540 0 0.16719f ; **FLOATING
C862 wind_comp_0.sg13g2_and2_2$1_0.VDD.n541 0 0.16719f ; **FLOATING
C863 wind_comp_0.sg13g2_and2_2$1_0.VDD.n542 0 0.16719f ; **FLOATING
C864 wind_comp_0.sg13g2_and2_2$1_0.VDD.n543 0 0.14174f ; **FLOATING
C865 wind_comp_0.sg13g2_and2_2$1_0.VDD.n544 0 0.14174f ; **FLOATING
C866 wind_comp_0.sg13g2_and2_2$1_0.VDD.n545 0 0.14174f ; **FLOATING
C867 wind_comp_0.sg13g2_and2_2$1_0.VDD.n546 0 0.16719f ; **FLOATING
C868 wind_comp_0.sg13g2_and2_2$1_0.VDD.n547 0 0.16719f ; **FLOATING
C869 wind_comp_0.sg13g2_and2_2$1_0.VDD.n548 0 0.16719f ; **FLOATING
C870 wind_comp_0.sg13g2_and2_2$1_0.VDD.n549 0 0.14174f ; **FLOATING
C871 wind_comp_0.sg13g2_and2_2$1_0.VDD.n550 0 0.14174f ; **FLOATING
C872 wind_comp_0.sg13g2_and2_2$1_0.VDD.n551 0 0.10107f ; **FLOATING
C873 wind_comp_0.sg13g2_and2_2$1_0.VDD.n552 0 0.22466f ; **FLOATING
C874 wind_comp_0.sg13g2_and2_2$1_0.VDD.n553 0 0.1572f ; **FLOATING
C875 wind_comp_0.sg13g2_and2_2$1_0.VDD.n555 0 0.01146f ; **FLOATING
C876 wind_comp_0.sg13g2_and2_2$1_0.VDD.n557 0 0.03915f ; **FLOATING
C877 wind_comp_0.sg13g2_and2_2$1_0.VDD.n559 0 0.02314f ; **FLOATING
C878 wind_comp_0.sg13g2_and2_2$1_0.VDD.n560 0 0.01702f ; **FLOATING
C879 wind_comp_0.sg13g2_and2_2$1_0.VDD.n561 0 0.02467f ; **FLOATING
C880 wind_comp_0.sg13g2_and2_2$1_0.VDD.n563 0 0.06579f ; **FLOATING
C881 wind_comp_0.sg13g2_and2_2$1_0.VDD.t37 0 0.01838f ; **FLOATING
C882 wind_comp_0.sg13g2_and2_2$1_0.VDD.n566 0 0.01249f ; **FLOATING
C883 wind_comp_0.sg13g2_and2_2$1_0.VDD.t36 0 0.01701f ; **FLOATING
C884 wind_comp_0.sg13g2_and2_2$1_0.VDD.n568 0 0.02583f ; **FLOATING
C885 wind_comp_0.sg13g2_and2_2$1_0.VDD.t91 0 0.01942f ; **FLOATING
C886 wind_comp_0.sg13g2_and2_2$1_0.VDD.n570 0 0.08942f ; **FLOATING
C887 wind_comp_0.sg13g2_and2_2$1_0.VDD.n571 0 0.02157f ; **FLOATING
C888 wind_comp_0.sg13g2_and2_2$1_0.VDD.t89 0 0.01858f ; **FLOATING
C889 wind_comp_0.sg13g2_and2_2$1_0.VDD.n573 0 0.01857f ; **FLOATING
C890 wind_comp_0.sg13g2_and2_2$1_0.VDD.n574 0 0.07742f ; **FLOATING
C891 wind_comp_0.sg13g2_and2_2$1_0.VDD.t87 0 0.01859f ; **FLOATING
C892 wind_comp_0.sg13g2_and2_2$1_0.VDD.n576 0 0.02259f ; **FLOATING
C893 wind_comp_0.sg13g2_and2_2$1_0.VDD.t85 0 0.01859f ; **FLOATING
C894 wind_comp_0.sg13g2_and2_2$1_0.VDD.n578 0 0.02599f ; **FLOATING
C895 wind_comp_0.sg13g2_and2_2$1_0.VDD.t83 0 0.01859f ; **FLOATING
C896 wind_comp_0.sg13g2_and2_2$1_0.VDD.n580 0 0.02602f ; **FLOATING
C897 wind_comp_0.sg13g2_and2_2$1_0.VDD.t81 0 0.01859f ; **FLOATING
C898 wind_comp_0.sg13g2_and2_2$1_0.VDD.n582 0 0.02263f ; **FLOATING
C899 wind_comp_0.sg13g2_and2_2$1_0.VDD.t79 0 0.01859f ; **FLOATING
C900 wind_comp_0.sg13g2_and2_2$1_0.VDD.n584 0 0.02246f ; **FLOATING
C901 wind_comp_0.sg13g2_and2_2$1_0.VDD.t76 0 0.01701f ; **FLOATING
C902 wind_comp_0.sg13g2_and2_2$1_0.VDD.n587 0 0.029f ; **FLOATING
C903 wind_comp_0.sg13g2_and2_2$1_0.VDD.t77 0 0.01859f ; **FLOATING
C904 wind_comp_0.sg13g2_and2_2$1_0.VDD.n588 0 0.02238f ; **FLOATING
C905 wind_comp_0.sg13g2_and2_2$1_0.VDD.t101 0 0.01699f ; **FLOATING
C906 wind_comp_0.sg13g2_and2_2$1_0.VDD.n590 0 0.02534f ; **FLOATING
C907 wind_comp_0.sg13g2_and2_2$1_0.VDD.n592 0 0.01353f ; **FLOATING
C908 wind_comp_0.sg13g2_and2_2$1_0.VDD.n593 0 0.03318f ; **FLOATING
C909 wind_comp_0.sg13g2_and2_2$1_0.VDD.n594 0 0.0255f ; **FLOATING
C910 wind_comp_0.sg13g2_and2_2$1_0.VDD.n595 0 0.27313f ; **FLOATING
C911 wind_comp_0.comparator_1.dynamic_pcell$7_0.VDD 0 23.2833f ; **FLOATING
C912 wind_comp_0.sg13g2_and2_2$1_0.VDD.n596 0 0.24184f ; **FLOATING
C913 wind_comp_0.sg13g2_and2_2$1_0.VDD.n597 0 1.79322f ; **FLOATING
C914 wind_comp_0.sg13g2_and2_2$1_0.VDD.t53 0 0.01894f ; **FLOATING
C915 wind_comp_0.sg13g2_and2_2$1_0.VDD.n598 0 0.27625f ; **FLOATING
C916 wind_comp_0.sg13g2_and2_2$1_0.VDD.n599 0 1.81556f ; **FLOATING
C917 wind_comp_0.sg13g2_and2_2$1_0.VDD.t4 0 0.35052f ; **FLOATING
C918 wind_comp_0.sg13g2_and2_2$1_0.VDD.n600 0 0.03725f ; **FLOATING
C919 wind_comp_0.sg13g2_and2_2$1_0.VDD.n601 0 1.65322f ; **FLOATING
C920 wind_comp_0.sg13g2_and2_2$1_0.VDD.n602 0 0.03159f ; **FLOATING
C921 wind_comp_0.sg13g2_and2_2$1_0.VDD.n603 0 0.21484f ; **FLOATING
C922 wind_comp_0.sg13g2_and2_2$1_0.VDD.n604 0 0.16943f ; **FLOATING
C923 wind_comp_0.sg13g2_and2_2$1_0.VDD.n605 0 0.25156f ; **FLOATING
C924 wind_comp_0.sg13g2_and2_2$1_0.VDD.n606 0 0.0778f ; **FLOATING
C925 wind_comp_0.sg13g2_and2_2$1_0.VDD.n607 0 0.19369f ; **FLOATING
C926 wind_comp_0.sg13g2_and2_2$1_0.VDD.n608 0 0.0157f ; **FLOATING
C927 wind_comp_0.sg13g2_and2_2$1_0.VDD.n609 0 0.03002f ; **FLOATING
C928 wind_comp_0.comparator_0.dynamic_pcell$7_0.SRC_NET_ABCD 0 0.04764f ; **FLOATING
C929 wind_comp_0.sg13g2_and2_2$1_0.VDD.n610 0 0.01359f ; **FLOATING
C930 wind_comp_0.sg13g2_and2_2$1_0.VDD.n611 0 0.02793f ; **FLOATING
C931 wind_comp_0.sg13g2_and2_2$1_0.VDD.n612 0 0.02859f ; **FLOATING
C932 wind_comp_0.sg13g2_and2_2$1_0.VDD.n613 0 0.01706f ; **FLOATING
C933 wind_comp_0.sg13g2_and2_2$1_0.VDD.n615 0 0.01165f ; **FLOATING
C934 wind_comp_0.sg13g2_and2_2$1_0.VDD.t144 0 0.02834f ; **FLOATING
C935 wind_comp_0.sg13g2_and2_2$1_0.VDD.n617 0 0.01165f ; **FLOATING
C936 wind_comp_0.sg13g2_and2_2$1_0.VDD.t141 0 0.02824f ; **FLOATING
C937 wind_comp_0.sg13g2_and2_2$1_0.VDD.n621 0 0.15665f ; **FLOATING
C938 wind_comp_0.sg13g2_and2_2$1_0.VDD.n622 0 0.24382f ; **FLOATING
C939 wind_comp_0.sg13g2_and2_2$1_0.VDD.n623 0 0.16719f ; **FLOATING
C940 wind_comp_0.sg13g2_and2_2$1_0.VDD.n624 0 0.14174f ; **FLOATING
C941 wind_comp_0.sg13g2_and2_2$1_0.VDD.n625 0 0.14174f ; **FLOATING
C942 wind_comp_0.sg13g2_and2_2$1_0.VDD.n626 0 0.14174f ; **FLOATING
C943 wind_comp_0.sg13g2_and2_2$1_0.VDD.n627 0 0.14174f ; **FLOATING
C944 wind_comp_0.sg13g2_and2_2$1_0.VDD.n628 0 0.16719f ; **FLOATING
C945 wind_comp_0.sg13g2_and2_2$1_0.VDD.n629 0 0.14174f ; **FLOATING
C946 wind_comp_0.sg13g2_and2_2$1_0.VDD.n630 0 0.14174f ; **FLOATING
C947 wind_comp_0.sg13g2_and2_2$1_0.VDD.n631 0 0.14174f ; **FLOATING
C948 wind_comp_0.sg13g2_and2_2$1_0.VDD.n632 0 0.14174f ; **FLOATING
C949 wind_comp_0.sg13g2_and2_2$1_0.VDD.n633 0 0.14174f ; **FLOATING
C950 wind_comp_0.sg13g2_and2_2$1_0.VDD.n634 0 0.14174f ; **FLOATING
C951 wind_comp_0.sg13g2_and2_2$1_0.VDD.n635 0 0.16719f ; **FLOATING
C952 wind_comp_0.sg13g2_and2_2$1_0.VDD.n636 0 0.16719f ; **FLOATING
C953 wind_comp_0.sg13g2_and2_2$1_0.VDD.n637 0 0.14174f ; **FLOATING
C954 wind_comp_0.sg13g2_and2_2$1_0.VDD.n638 0 0.14174f ; **FLOATING
C955 wind_comp_0.sg13g2_and2_2$1_0.VDD.n639 0 0.14174f ; **FLOATING
C956 wind_comp_0.sg13g2_and2_2$1_0.VDD.n640 0 0.16719f ; **FLOATING
C957 wind_comp_0.sg13g2_and2_2$1_0.VDD.n641 0 0.16719f ; **FLOATING
C958 wind_comp_0.sg13g2_and2_2$1_0.VDD.n642 0 0.16719f ; **FLOATING
C959 wind_comp_0.sg13g2_and2_2$1_0.VDD.n643 0 0.14174f ; **FLOATING
C960 wind_comp_0.sg13g2_and2_2$1_0.VDD.n644 0 0.14174f ; **FLOATING
C961 wind_comp_0.sg13g2_and2_2$1_0.VDD.n645 0 0.14174f ; **FLOATING
C962 wind_comp_0.sg13g2_and2_2$1_0.VDD.n646 0 0.16719f ; **FLOATING
C963 wind_comp_0.sg13g2_and2_2$1_0.VDD.n647 0 0.16719f ; **FLOATING
C964 wind_comp_0.sg13g2_and2_2$1_0.VDD.n648 0 0.30129f ; **FLOATING
C965 wind_comp_0.sg13g2_and2_2$1_0.VDD.n649 0 0.10107f ; **FLOATING
C966 wind_comp_0.sg13g2_and2_2$1_0.VDD.n650 0 0.09973f ; **FLOATING
C967 wind_comp_0.sg13g2_and2_2$1_0.VDD.n651 0 26.0552f ; **FLOATING
C968 wind_comp_0.sg13g2_and2_2$1_0.VDD.n652 0 0.09973f ; **FLOATING
C969 wind_comp_0.sg13g2_and2_2$1_0.VDD.n653 0 0.10107f ; **FLOATING
C970 wind_comp_0.sg13g2_and2_2$1_0.VDD.n654 0 0.32567f ; **FLOATING
C971 wind_comp_0.sg13g2_and2_2$1_0.VDD.n655 0 0.31059f ; **FLOATING
C972 wind_comp_0.sg13g2_and2_2$1_0.VDD.n658 0 0.01362f ; **FLOATING
C973 wind_comp_0.sg13g2_and2_2$1_0.VDD.t192 0 0.08804f ; **FLOATING
C974 wind_comp_0.sg13g2_and2_2$1_0.VDD.t193 0 0.05111f ; **FLOATING
C975 wind_comp_0.sg13g2_and2_2$1_0.VDD.n659 0 0.01023f ; **FLOATING
C976 wind_comp_0.sg13g2_and2_2$1_0.VDD.n660 0 0.01732f ; **FLOATING
C977 wind_comp_0.sg13g2_and2_2$1_0.VDD.t194 0 0.08794f ; **FLOATING
C978 wind_comp_0.sg13g2_and2_2$1_0.VDD.n663 0 0.01361f ; **FLOATING
C979 wind_comp_0.sg13g2_and2_2$1_0.VDD.n664 0 0.03924f ; **FLOATING
C980 wind_comp_0.sg13g2_and2_2$1_0.VDD.n665 0 0.02256f ; **FLOATING
C981 wind_comp_0.sg13g2_and2_2$1_0.VDD.n666 0 0.06481f ; **FLOATING
C982 wind_comp_0.sg13g2_and2_2$1_0.VDD.n667 0 0.02126f ; **FLOATING
C983 wind_comp_0.sg13g2_and2_2$1_0.VDD.t189 0 0.04573f ; **FLOATING
C984 wind_comp_0.sg13g2_and2_2$1_0.VDD.n668 0 0.01022f ; **FLOATING
C985 wind_comp_0.sg13g2_and2_2$1_0.VDD.n669 0 0.01731f ; **FLOATING
C986 wind_comp_0.sg13g2_and2_2$1_0.VDD.t188 0 0.05111f ; **FLOATING
C987 wind_comp_0.sg13g2_and2_2$1_0.VDD.n670 0 0.01023f ; **FLOATING
C988 wind_comp_0.sg13g2_and2_2$1_0.VDD.t190 0 0.08804f ; **FLOATING
C989 wind_comp_0.sg13g2_and2_2$1_0.VDD.n671 0 0.01592f ; **FLOATING
C990 wind_comp_0.sg13g2_and2_2$1_0.VDD.n672 0 0.02076f ; **FLOATING
C991 wind_comp_0.sg13g2_and2_2$1_0.VDD.t187 0 0.08794f ; **FLOATING
C992 wind_comp_0.sg13g2_and2_2$1_0.VDD.n675 0 0.01361f ; **FLOATING
C993 wind_comp_0.sg13g2_and2_2$1_0.VDD.n676 0 0.0448f ; **FLOATING
C994 wind_comp_0.sg13g2_and2_2$1_0.VDD.n679 0 0.01191f ; **FLOATING
C995 wind_comp_0.sg13g2_and2_2$1_0.VDD.t106 0 0.03157f ; **FLOATING
C996 wind_comp_0.sg13g2_and2_2$1_0.VDD.n681 0 0.01191f ; **FLOATING
C997 wind_comp_0.sg13g2_and2_2$1_0.VDD.t115 0 0.03147f ; **FLOATING
C998 wind_comp_0.sg13g2_and2_2$1_0.VDD.n684 0 0.02496f ; **FLOATING
C999 wind_comp_0.sg13g2_and2_2$1_0.VDD.n685 0 0.68224f ; **FLOATING
C1000 wind_comp_0.sg13g2_and2_2$1_0.VDD.n686 0 0.04196f ; **FLOATING
C1001 wind_comp_0.sg13g2_and2_2$1_0.VDD.n687 0 0.02447f ; **FLOATING
C1002 wind_comp_0.sg13g2_and2_2$1_0.VDD.n688 0 0.0257f ; **FLOATING
C1003 wind_comp_0.sg13g2_and2_2$1_0.VDD.n689 0 0.01755f ; **FLOATING
C1004 wind_comp_0.sg13g2_and2_2$1_0.VDD.n690 0 0.06072f ; **FLOATING
C1005 wind_comp_0.sg13g2_and2_2$1_0.VDD.n691 0 0.02544f ; **FLOATING
C1006 wind_comp_0.sg13g2_and2_2$1_0.VDD.n692 0 0.71838f ; **FLOATING
C1007 wind_comp_0.sg13g2_and2_2$1_0.VDD.n693 0 0.12546f ; **FLOATING
C1008 wind_comp_0.sg13g2_and2_2$1_0.VDD.n694 0 0.07245f ; **FLOATING
C1009 wind_comp_0.sg13g2_and2_2$1_0.VDD.n695 0 0.05046f ; **FLOATING
C1010 wind_comp_0.sg13g2_and2_2$1_0.VDD.n697 0 0.01629f ; **FLOATING
C1011 wind_comp_0.sg13g2_and2_2$1_0.VDD.t121 0 0.03147f ; **FLOATING
C1012 wind_comp_0.sg13g2_and2_2$1_0.VDD.n702 0 0.04352f ; **FLOATING
C1013 wind_comp_0.sg13g2_and2_2$1_0.VDD.n703 0 0.04523f ; **FLOATING
C1014 wind_comp_0.sg13g2_and2_2$1_0.VDD.n704 0 0.06375f ; **FLOATING
C1015 wind_comp_0.comparator_0.dynamic_pcell_0.VDD 0 23.2834f ; **FLOATING
C1016 wind_comp_0.sg13g2_and2_2$1_0.VDD.n705 0 0.27313f ; **FLOATING
C1017 wind_comp_0.sg13g2_and2_2$1_0.VDD.t25 0 0.01701f ; **FLOATING
C1018 wind_comp_0.sg13g2_and2_2$1_0.VDD.n706 0 0.02583f ; **FLOATING
C1019 wind_comp_0.sg13g2_and2_2$1_0.VDD.n708 0 0.08588f ; **FLOATING
C1020 enable.n0 0 1.02469f ; **FLOATING
C1021 enable.n1 0 0.32799f ; **FLOATING
C1022 enable.n2 0 0.07245f ; **FLOATING
C1023 enable.n3 0 0.49647f ; **FLOATING
C1024 enable.t0 0 0.43438f ; **FLOATING
C1025 enable.t2 0 0.15259f ; **FLOATING
C1026 enable.t6 0 0.4351f ; **FLOATING
C1027 enable.t3 0 0.20876f ; **FLOATING
C1028 enable.n4 0 0.33038f ; **FLOATING
C1029 enable.n5 0 0.08677f ; **FLOATING
C1030 enable.n6 0 1.01649f ; **FLOATING
C1031 enable.t8 0 0.05338f ; **FLOATING
C1032 enable.t9 0 0.05311f ; **FLOATING
C1033 enable.t10 0 0.0653f ; **FLOATING
C1034 enable.t1 0 0.43437f ; **FLOATING
C1035 enable.t7 0 0.4351f ; **FLOATING
C1036 enable.t4 0 0.20908f ; **FLOATING
C1037 enable.n7 0 0.33006f ; **FLOATING
C1038 enable.t5 0 0.15259f ; **FLOATING
C1039 enable.n8 0 0.08677f ; **FLOATING
C1040 enable.n9 0 1.01649f ; **FLOATING
C1041 enable.t11 0 0.0653f ; **FLOATING
C1042 enable.t12 0 0.05311f ; **FLOATING
C1043 enable.n10 0 0.25554f ; **FLOATING
C1044 enable.t13 0 0.05338f ; **FLOATING
C1045 enable.n11 0 12.6003f ; **FLOATING
.ends
