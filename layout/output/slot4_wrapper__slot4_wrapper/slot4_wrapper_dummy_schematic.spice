.subckt slot4_wrapper VDD VSS
.ends
.end
