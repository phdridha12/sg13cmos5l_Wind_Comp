* PEX produced on Wed Aug 26 06:31:19 PM CEST 2026 using /foss/tools/sak/sak-pex.sh with m=3 and s=1 (extresist threshold=10000 mOhm, minres=1000 mOhm, mindelay=1 ps)
* NGSPICE file created from inverter_pex.ext - technology: ihp-sg13cmos5l

.subckt inverter_pex VDD vin vout VSS
X0 vout vin VDD VDD sg13_lv_pmos ad=1.14p pd=6.38u as=1.14p ps=6.38u w=6u l=1u
X1 VDD vin vout VDD sg13_lv_pmos ad=1.14p pd=6.38u as=1.14p ps=6.38u w=6u l=1u
X2 vout vin VDD VDD sg13_lv_pmos ad=1.14p pd=6.38u as=1.14p ps=6.38u w=6u l=1u
X3 vout vin VSS.t3 VSS.t12 sg13_lv_nmos ad=0.19p pd=1.38u as=0.19p ps=1.38u w=1u l=1u
X4 vout vin VSS.t1 VSS.t0 sg13_lv_nmos ad=0.19p pd=1.38u as=0.19p ps=1.38u w=1u l=1u
X5 VSS.t27 VSS.t25 VSS.t1 VSS.t26 sg13_lv_nmos ad=0.34p pd=2.68u as=0 ps=0 w=1u l=1u
X6 VSS.t14 vin vout VSS.t19 sg13_lv_nmos ad=0.19p pd=1.38u as=0.19p ps=1.38u w=1u l=1u
X7 vout vin VDD VDD sg13_lv_pmos ad=1.14p pd=6.38u as=1.14p ps=6.38u w=6u l=1u
X8 VDD vin vout VDD sg13_lv_pmos ad=1.14p pd=6.38u as=1.14p ps=6.38u w=6u l=1u
X9 vout vin VSS.t17 VSS.t18 sg13_lv_nmos ad=0.19p pd=1.38u as=0.19p ps=1.38u w=1u l=1u
X10 vout vin VDD VDD sg13_lv_pmos ad=1.14p pd=6.38u as=1.14p ps=6.38u w=6u l=1u
X11 VSS.t3 vin vout VSS.t7 sg13_lv_nmos ad=0.19p pd=1.38u as=0.19p ps=1.38u w=1u l=1u
X12 VSS.t24 vin vout VSS.t23 sg13_lv_nmos ad=0.19p pd=1.38u as=0.19p ps=1.38u w=1u l=1u
X13 VDD vin vout VDD sg13_lv_pmos ad=1.14p pd=6.38u as=1.14p ps=6.38u w=6u l=1u
X14 vout vin VDD VDD sg13_lv_pmos ad=1.14p pd=6.38u as=1.14p ps=6.38u w=6u l=1u
X15 VDD vin vout VDD sg13_lv_pmos ad=1.14p pd=6.38u as=1.14p ps=6.38u w=6u l=1u
X16 vout vin VDD VDD sg13_lv_pmos ad=1.14p pd=6.38u as=1.14p ps=6.38u w=6u l=1u
X17 vout vin VSS.t17 VSS.t22 sg13_lv_nmos ad=0.19p pd=1.38u as=0.19p ps=1.38u w=1u l=1u
X18 VSS.t3 vin vout VSS.t11 sg13_lv_nmos ad=0.19p pd=1.38u as=0.19p ps=1.38u w=1u l=1u
X19 VDD vin vout VDD sg13_lv_pmos ad=1.14p pd=6.38u as=1.14p ps=6.38u w=6u l=1u
X20 vout vin VDD VDD sg13_lv_pmos ad=1.14p pd=6.38u as=1.14p ps=6.38u w=6u l=1u
X21 VDD VDD VDD VDD sg13_lv_pmos ad=2.04p pd=12.68u as=0.14199n ps=0.28418m w=6u l=1u
X22 vout vin VSS.t3 VSS.t6 sg13_lv_nmos ad=0.19p pd=1.38u as=0.19p ps=1.38u w=1u l=1u
X23 VSS.t17 vin vout VSS.t16 sg13_lv_nmos ad=0.19p pd=1.38u as=0.19p ps=1.38u w=1u l=1u
X24 VDD vin vout VDD sg13_lv_pmos ad=1.14p pd=6.38u as=1.14p ps=6.38u w=6u l=1u
X25 VDD vin vout VDD sg13_lv_pmos ad=1.14p pd=6.38u as=1.14p ps=6.38u w=6u l=1u
X26 VSS.t3 vin vout VSS.t5 sg13_lv_nmos ad=0.19p pd=1.38u as=0.19p ps=1.38u w=1u l=1u
X27 vout vin VDD VDD sg13_lv_pmos ad=1.14p pd=6.38u as=1.14p ps=6.38u w=6u l=1u
X28 VSS.t3 vin vout VSS.t2 sg13_lv_nmos ad=0.19p pd=1.38u as=0.19p ps=1.38u w=1u l=1u
X29 vout vin VSS.t3 VSS.t10 sg13_lv_nmos ad=0.19p pd=1.38u as=0.19p ps=1.38u w=1u l=1u
X30 VSS.t17 vin vout VSS.t21 sg13_lv_nmos ad=0.19p pd=1.38u as=0.19p ps=1.38u w=1u l=1u
X31 vout vin VSS.t3 VSS.t4 sg13_lv_nmos ad=0.19p pd=1.38u as=0.19p ps=1.38u w=1u l=1u
X32 VDD vin vout VDD sg13_lv_pmos ad=1.14p pd=6.38u as=1.14p ps=6.38u w=6u l=1u
X33 vout vin VSS.t14 VSS.t20 sg13_lv_nmos ad=0.19p pd=1.38u as=0.19p ps=1.38u w=1u l=1u
X34 vout vin VDD VDD sg13_lv_pmos ad=1.14p pd=6.38u as=1.14p ps=6.38u w=6u l=1u
X35 VSS.t3 vin vout VSS.t9 sg13_lv_nmos ad=0.19p pd=1.38u as=0.19p ps=1.38u w=1u l=1u
X36 VDD vin vout VDD sg13_lv_pmos ad=1.14p pd=6.38u as=1.14p ps=6.38u w=6u l=1u
X37 VDD VDD VDD VDD sg13_lv_pmos ad=1.14p pd=6.38u as=0 ps=0 w=6u l=1u
X38 VDD vin vout VDD sg13_lv_pmos ad=1.14p pd=6.38u as=1.14p ps=6.38u w=6u l=1u
X39 vout vin VSS.t3 VSS.t8 sg13_lv_nmos ad=0.19p pd=1.38u as=0.19p ps=1.38u w=1u l=1u
X40 vout vin VSS.t14 VSS.t15 sg13_lv_nmos ad=0.19p pd=1.38u as=0.19p ps=1.38u w=1u l=1u
X41 vout vin VDD VDD sg13_lv_pmos ad=1.14p pd=6.38u as=1.14p ps=6.38u w=6u l=1u
X42 VSS.t14 vin vout VSS.t13 sg13_lv_nmos ad=0.19p pd=1.38u as=0.19p ps=1.38u w=1u l=1u
X43 VSS.t24 VSS.t17 VSS.t29 VSS.t28 sg13_lv_nmos ad=0.19p pd=1.38u as=0 ps=0 w=1u l=1u
R0 VSS.t19 VSS.n0 43.8554
R1 VSS.t15 VSS.n0 51.0606
R2 VSS.t18 VSS.n0 47.4579
R3 VSS.t28 VSS.n0 7.82752
R4 VSS.t2 VSS.n0 25.8419
R5 VSS.t13 VSS.n0 51.0606
R6 VSS.t22 VSS.n0 25.8413
R7 VSS.t21 VSS.n0 33.0473
R8 VSS.t20 VSS.n0 39.0515
R9 VSS.t10 VSS.n0 51.0604
R10 VSS.t9 VSS.n0 51.0604
R11 VSS.n0 VSS.t8 49.8595
R12 VSS.t7 VSS.n0 47.4577
R13 VSS.t6 VSS.n0 43.8555
R14 VSS.t4 VSS.n0 33.0467
R15 VSS.n0 VSS.t17 0.174771
R16 VSS.t24 VSS.t17 5.66833
R17 VSS.t17 VSS.t29 5.66856
R18 VSS.t3 VSS.t25 0.223126
R19 VSS.t27 VSS.t25 5.66244
R20 VSS.t25 VSS.t1 5.66522
R21 VSS.t23 VSS.n0 17.4339
R22 VSS.n0 VSS.t5 39.0513
R23 VSS.n0 VSS.t11 49.8728
R24 VSS.n0 VSS.t12 49.8523
R25 VSS.n0 VSS.t16 49.8595
R26 VSS.t0 VSS.n0 17.4338
R27 VSS.n0 VSS.t3 0.150153
R28 VSS.t17 VSS.t14 0.241978
R29 VSS.t26 VSS.n0 7.82638
R30 VSS.t14 VSS.t3 1.02857
R31 VSS VSS.t3 0.0005
C0 vout vin 15.9308f
C1 vin VDD 26.3364f
C2 vout VDD 11.0395f
C3 vout VSS 10.12635f
.ends
