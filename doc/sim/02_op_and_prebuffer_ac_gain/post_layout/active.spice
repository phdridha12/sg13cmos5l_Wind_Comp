Vin vin 0 dc {vl} ac 1
.control
save all
op
ac dec 50 1 1G
let av_db = db(v(x1.wind_comp_0.comparator_1.sg13cmos5l_inv_16_0.a))
meas ac avdc_db FIND av_db AT=10
let av_3db = avdc_db - 3
meas ac f3db WHEN av_db=$&av_3db FALL=1
print avdc_db f3db
write @name\\.raw av_db
plot av_db title "02_op_and_prebuffer_ac_gain"
set hcopydevtype=svg
hardcopy ../plots/@name\\.svg av_db title "02_op_and_prebuffer_ac_gain"
.endc
