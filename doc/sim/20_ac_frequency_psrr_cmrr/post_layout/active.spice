Vin vin 0 dc {vl} ac 1
.control
save all
ac dec 50 1 100Meg
let adm = mag(v(x1.wind_comp_0.comparator_1.sg13cmos5l_inv_16_0.a))
set p_dm = $curplot
alter @vin[acmag] = 0
alter @vvl[acmag] = 0
alter @vdd[acmag] = 1
ac dec 50 1 100Meg
let avdd = mag(v(x1.wind_comp_0.comparator_1.sg13cmos5l_inv_16_0.a))
let psrr_f = 20 * log10({$p_dm}.adm / avdd)
set p_dd = $curplot
alter @vdd[acmag] = 0
alter @vin[acmag] = 1
alter @vvl[acmag] = 1
ac dec 50 1 100Meg
let acm = mag(v(x1.wind_comp_0.comparator_1.sg13cmos5l_inv_16_0.a))
let cmrr_f = 20 * log10({$p_dm}.adm / acm)
let psrr_db = {$p_dd}.psrr_f
meas ac psrr_1k FIND psrr_db AT=1k
meas ac psrr_1m FIND psrr_db AT=1Meg
meas ac cmrr_1k FIND cmrr_f AT=1k
meas ac cmrr_1m FIND cmrr_f AT=1Meg
print psrr_1k psrr_1m cmrr_1k cmrr_1m
write @name\\.raw psrr_db cmrr_f
plot psrr_db cmrr_f title "20_ac_frequency_psrr_cmrr"
set hcopydevtype=svg
hardcopy ../plots/@name\\.svg psrr_db cmrr_f title "20_ac_frequency_psrr_cmrr"
.endc
