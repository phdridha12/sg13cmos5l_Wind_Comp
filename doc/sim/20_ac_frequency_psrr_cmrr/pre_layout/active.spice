Vin vin 0 dc {vl} ac 1
.control
save all
ac dec 50 1 100Meg
let adm = mag(v(xcomp1.x2.vop))
set p_dm = $curplot
alter @vin[acmag] = 0
alterparam ac_vdd=1
reset
save all
ac dec 50 1 100Meg
let avdd = mag(v(xcomp1.x2.vop))
let psrr_f = 20 * log10({$p_dm}.adm / avdd)
set p_dd = $curplot
alterparam ac_vdd=0
reset
save all
alter @vin[acmag] = 1
alter @vvl[acmag] = 1
ac dec 50 1 100Meg
let acm = mag(v(xcomp1.x2.vop))
let cmrr_f = 20 * log10({$p_dm}.adm / acm)
let psrr_db = {$p_dd}.psrr_f
write @name\\.raw psrr_db cmrr_f
plot psrr_db cmrr_f title "20_ac_frequency_psrr_cmrr"
set hcopydevtype=svg
hardcopy ../plots/@name\\.svg psrr_db cmrr_f title "20_ac_frequency_psrr_cmrr"
.endc
