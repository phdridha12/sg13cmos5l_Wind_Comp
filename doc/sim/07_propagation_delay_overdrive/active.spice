Vin vin 0 pulse(0.29 0.31 50n 100p 100p 100n 200n)
.control
save all
tran 100p 250n
meas tran tplh TRIG v(vin) VAL=0.3 RISE=1 TARG v(vout) VAL=0.6 RISE=1
meas tran tphl TRIG v(vin) VAL=0.3 FALL=1 TARG v(vout) VAL=0.6 FALL=1
print tplh tphl
write @name\\.raw v(vin) v(vout)
plot v(vin) v(vout) title "07_propagation_delay_overdrive"
set hcopydevtype=svg
hardcopy ../plots/@name\\.svg v(vin) v(vout) title "07_propagation_delay_overdrive"
.endc
