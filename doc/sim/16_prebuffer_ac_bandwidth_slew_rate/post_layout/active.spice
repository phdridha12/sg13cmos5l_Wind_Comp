*Vin vin 0 dc {vl} ac 1 pulse(0.25 0.35 20n 100p 100p 100n 200n)
Vin vin 0 dc {vl} ac 1 pulse(0.25 0.35 1u 1n 1n 5u 10u)
.control
save all
ac dec 50 1 1G
*let av_db = db(v(xcomp1.x2.vop))
let av_db = db(v(x1.wind_comp_0.comparator_1.sg13cmos5l_inv_16_0.a))
meas ac ugbw WHEN av_db=0 FALL=1
set p_ac = $curplot
*tran 100p 200n
tran 1n 10u
*let sr_vec = deriv(v(xcomp1.x2.vop))
let sr_vec = deriv(v(x1.wind_comp_0.comparator_1.sg13cmos5l_inv_16_0.a))
*meas tran sr_pos MAX sr_vec FROM=15n TO=60n
meas tran sr_pos MAX sr_vec FROM=0.9u TO=4u
*meas tran sr_neg MIN sr_vec FROM=115n TO=160n
meas tran sr_neg MIN sr_vec FROM=5.9u TO=9u
print {$p_ac}.ugbw sr_pos sr_neg
*write @name\\.raw v(vin) v(xcomp1.x2.vop)
write @name\\.raw v(vin) v(x1.wind_comp_0.comparator_1.sg13cmos5l_inv_16_0.a)
*plot v(xcomp1.x2.vop) v(vin) title "16_prebuffer_ac_bandwidth_slew_rate"
plot v(x1.wind_comp_0.comparator_1.sg13cmos5l_inv_16_0.a) v(vin) title "16_prebuffer_ac_bandwidth_slew_rate"
set hcopydevtype=svg
*hardcopy ../plots/@name\\.svg v(xcomp1.x2.vop) v(vin) title "16_prebuffer_ac_bandwidth_slew_rate"
hardcopy ../plots/@name\\.svg v(x1.wind_comp_0.comparator_1.sg13cmos5l_inv_16_0.a) v(vin) title "16_prebuffer_ac_bandwidth_slew_rate"
.endc
