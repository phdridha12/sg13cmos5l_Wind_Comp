Vin vin 0 dc {vcm}
.control
save all
alter @ven[pulse] = [ 0 1.2 500n 1n 1n 2u 4u ]
tran 1n 4u
meas tran istby FIND -i(Vdd) AT=400n
meas tran twake TRIG v(en) VAL=0.6 RISE=1 TARG v(vout) VAL=0.6 RISE=1
meas tran tdis TRIG v(en) VAL=0.6 FALL=1 TARG v(vout) VAL=0.6 FALL=1
print istby twake tdis
write @name\\.raw v(en) v(vout)
plot v(en) v(vout) title "24_enable_disable_wakeup_leakage"
set hcopydevtype=svg
hardcopy ../plots/@name\\.svg v(en) v(vout) title "24_enable_disable_wakeup_leakage"
.endc
