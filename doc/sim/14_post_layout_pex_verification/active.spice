Vin vin 0 pulse(0.29 0.31 50n 100p 100p 100n 200n)
.control
save all
op
let pstat_pex = -i(Vdd) * v(vdd)
set p_op = $curplot
dc Vin 0 1.2 1m
meas dc vth_l_pex WHEN v(vout)=0.6 RISE=1
meas dc vth_h_pex WHEN v(vout)=0.6 FALL=1
set p_dc = $curplot
tran 100p 250n
meas tran tplh_pex TRIG v(vin) VAL=0.3 RISE=1 TARG v(vout) VAL=0.6 RISE=1
meas tran tphl_pex TRIG v(vin) VAL=0.3 FALL=1 TARG v(vout) VAL=0.6 FALL=1
meas tran tr_pex TRIG v(vout) VAL=0.12 RISE=1 TARG v(vout) VAL=1.08 RISE=1
meas tran tf_pex TRIG v(vout) VAL=1.08 FALL=1 TARG v(vout) VAL=0.12 FALL=1
print {$p_op}.pstat_pex {$p_dc}.vth_l_pex {$p_dc}.vth_h_pex tplh_pex tphl_pex tr_pex tf_pex
write @name\\.raw v(vin) v(vout)
plot v(vin) v(vout) title "14_post_layout_pex_verification"
set hcopydevtype=svg
hardcopy ../plots/@name\\.svg v(vin) v(vout) title "14_post_layout_pex_verification"
.endc
