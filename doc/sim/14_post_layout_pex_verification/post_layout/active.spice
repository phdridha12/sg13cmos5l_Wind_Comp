Vin vin 0 pulse(0.29 0.31 1u 1n 1n 5u 10u)
.control
save all
tran 2n 10u
meas tran tplh_pex TRIG v(vin) VAL=0.3 RISE=1 TARG v(vout) VAL=0.6 RISE=1
meas tran tphl_pex TRIG v(vin) VAL=0.3 FALL=1 TARG v(vout) VAL=0.6 FALL=1
meas tran tr_pex TRIG v(vout) VAL=0.12 RISE=1 TARG v(vout) VAL=1.08 RISE=1
meas tran tf_pex TRIG v(vout) VAL=1.08 FALL=1 TARG v(vout) VAL=0.12 FALL=1
set p_tr = $curplot
set filetype=ascii
write @name\\.raw v(vin) v(vout)
plot v(vin) v(vout) title "14_post_layout_pex_verification"
set hcopydevtype=svg
hardcopy ../plots/@name\\.svg v(vin) v(vout) title "14_post_layout_pex_verification"
dc Vin 0 1.2 2m
let pstat_vec = -i(Vdd) * v(vdd)
meas dc pstat_pex FIND pstat_vec AT=0.6
meas dc vth_l_pex WHEN v(vout)=0.6 RISE=1
meas dc vth_h_pex WHEN v(vout)=0.6 FALL=1
print pstat_pex vth_l_pex vth_h_pex {$p_tr}.tplh_pex {$p_tr}.tphl_pex {$p_tr}.tr_pex {$p_tr}.tf_pex
.endc
