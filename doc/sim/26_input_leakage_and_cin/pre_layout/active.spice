Vin vin 0 dc {vcm} ac 1
.control
save all
op
let ileak = abs(i(Vin))
set p_op = $curplot
ac dec 20 1k 10Meg
let cin = -imag(i(Vin)) / (2 * pi * frequency)
meas ac cin_1meg FIND cin AT=1Meg
print {$p_op}.ileak cin_1meg
write @name\\.raw cin
plot cin title "26_input_leakage_and_cin"
set hcopydevtype=svg
hardcopy ../plots/@name\\.svg cin title "26_input_leakage_and_cin"
.endc
