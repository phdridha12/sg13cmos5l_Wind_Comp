* PEX produced on Wed Aug 26 06:47:14 PM CEST 2026 using /foss/tools/sak/sak-pex.sh with m=3 and s=1 (extresist threshold=10000 mOhm, minres=1000 mOhm, mindelay=1 ps)
* NGSPICE file created from sg13cmos5l_chipalooza_analog_project_pex.ext - technology: ihp-sg13cmos5l

.subckt sg13cmos5l_chipalooza_analog_project_pex VPWR VAPWR VGND rst_n clk ena
+ uio_in[7] uio_in[6] uio_in[5] uio_in[4] uio_in[3] uio_in[2] uio_in[1]
+ uio_in[0] ui_in[7] ui_in[6] ui_in[5] ui_in[4] ui_in[3] ui_in[2] ui_in[1]
+ ui_in[0] uio_oe[7] uio_oe[6] uio_oe[5] uio_oe[4] uio_oe[3] uio_oe[2] uio_oe[1]
+ uio_oe[0] uio_out[7] uio_out[6] uio_out[5] uio_out[4] uio_out[3] uio_out[2]
+ uio_out[1] uio_out[0] uo_out[7] uo_out[6] uo_out[5] uo_out[4] uo_out[3]
+ uo_out[2] uo_out[1] uo_out[0] analog_2 analog_1 analog_0
X0 VAPWR VAPWR VAPWR VAPWR sg13_lv_pmos ad=1.14p pd=6.38u as=0.28875n ps=0.61464m w=6u l=1u
X1 VGND.t55 VGND.t53 VGND.t31 VGND.t54 sg13_lv_nmos ad=0.34p pd=2.68u as=0 ps=0 w=1u l=1u
X2 analog_1 analog_0 VGND.t1 VGND.t0 sg13_lv_nmos ad=0.19p pd=1.38u as=0.19p ps=1.38u w=1u l=1u
X3 analog_1 analog_0 VAPWR VAPWR sg13_lv_pmos ad=1.14p pd=6.38u as=1.14p ps=6.38u w=6u l=1u
X4 VAPWR ui_in[0].t1 analog_2 VAPWR sg13_lv_pmos ad=1.14p pd=6.38u as=1.14p ps=6.38u w=6u l=1u
X5 VAPWR analog_0 analog_1 VAPWR sg13_lv_pmos ad=1.14p pd=6.38u as=1.14p ps=6.38u w=6u l=1u
X6 analog_1 analog_0 VGND.t3 VGND.t4 sg13_lv_nmos ad=0.19p pd=1.38u as=0.19p ps=1.38u w=1u l=1u
X7 VAPWR analog_0 analog_1 VAPWR sg13_lv_pmos ad=1.14p pd=6.38u as=1.14p ps=6.38u w=6u l=1u
X8 VAPWR analog_0 analog_1 VAPWR sg13_lv_pmos ad=1.14p pd=6.38u as=1.14p ps=6.38u w=6u l=1u
X9 VGND.t9 analog_0 analog_1 VGND.t8 sg13_lv_nmos ad=0.19p pd=1.38u as=0.19p ps=1.38u w=1u l=1u
X10 VAPWR analog_0 analog_1 VAPWR sg13_lv_pmos ad=1.14p pd=6.38u as=1.14p ps=6.38u w=6u l=1u
X11 analog_1 analog_0 VAPWR VAPWR sg13_lv_pmos ad=1.14p pd=6.38u as=1.14p ps=6.38u w=6u l=1u
X12 analog_2 ui_in[0].t1 VAPWR VAPWR sg13_lv_pmos ad=1.14p pd=6.38u as=1.14p ps=6.38u w=6u l=1u
X13 VGND.t6 analog_0 analog_1 VGND.t5 sg13_lv_nmos ad=0.19p pd=1.38u as=0.19p ps=1.38u w=1u l=1u
X14 VGND.t12 analog_0 analog_1 VGND.t11 sg13_lv_nmos ad=0.19p pd=1.38u as=0.19p ps=1.38u w=1u l=1u
X15 analog_1 analog_0 VAPWR VAPWR sg13_lv_pmos ad=1.14p pd=6.38u as=1.14p ps=6.38u w=6u l=1u
X16 analog_2 ui_in[0].t1 VAPWR VAPWR sg13_lv_pmos ad=1.14p pd=6.38u as=1.14p ps=6.38u w=6u l=1u
X17 VAPWR analog_0 analog_1 VAPWR sg13_lv_pmos ad=1.14p pd=6.38u as=1.14p ps=6.38u w=6u l=1u
X18 VAPWR ui_in[0].t1 analog_2 VAPWR sg13_lv_pmos ad=1.14p pd=6.38u as=1.14p ps=6.38u w=6u l=1u
X19 VGND.t15 analog_0 analog_1 VGND.t14 sg13_lv_nmos ad=0.19p pd=1.38u as=0.19p ps=1.38u w=1u l=1u
X20 analog_1 analog_0 VGND.t21 VGND.t22 sg13_lv_nmos ad=0.19p pd=1.38u as=0.19p ps=1.38u w=1u l=1u
X21 analog_2 ui_in[0].t1 VAPWR VAPWR sg13_lv_pmos ad=1.14p pd=6.38u as=1.14p ps=6.38u w=6u l=1u
X22 VGND.t50 ui_in[0].t0 analog_2 VGND.t29 sg13_lv_nmos ad=0.19p pd=1.38u as=0.19p ps=1.38u w=1u l=1u
X23 analog_1 analog_0 VGND.t18 VGND.t19 sg13_lv_nmos ad=0.19p pd=1.38u as=0.19p ps=1.38u w=1u l=1u
X24 VAPWR analog_0 analog_1 VAPWR sg13_lv_pmos ad=1.14p pd=6.38u as=1.14p ps=6.38u w=6u l=1u
X25 VAPWR ui_in[0].t1 analog_2 VAPWR sg13_lv_pmos ad=1.14p pd=6.38u as=1.14p ps=6.38u w=6u l=1u
X26 analog_2 ui_in[0].t1 VAPWR VAPWR sg13_lv_pmos ad=1.14p pd=6.38u as=1.14p ps=6.38u w=6u l=1u
X27 analog_2 ui_in[0].t0 VGND.t31 VGND.t0 sg13_lv_nmos ad=0.19p pd=1.38u as=0.19p ps=1.38u w=1u l=1u
X28 VGND.t24 analog_0 analog_1 VGND.t23 sg13_lv_nmos ad=0.19p pd=1.38u as=0.19p ps=1.38u w=1u l=1u
X29 VAPWR VAPWR VAPWR VAPWR sg13_lv_pmos ad=1.14p pd=6.38u as=0 ps=0 w=6u l=1u
X30 analog_2 ui_in[0].t1 VAPWR VAPWR sg13_lv_pmos ad=1.14p pd=6.38u as=1.14p ps=6.38u w=6u l=1u
X31 analog_2 ui_in[0].t1 VAPWR VAPWR sg13_lv_pmos ad=1.14p pd=6.38u as=1.14p ps=6.38u w=6u l=1u
X32 VAPWR VAPWR VAPWR VAPWR sg13_lv_pmos ad=2.04p pd=12.68u as=0 ps=0 w=6u l=1u
X33 VGND.t27 analog_0 analog_1 VGND.t26 sg13_lv_nmos ad=0.19p pd=1.38u as=0.19p ps=1.38u w=1u l=1u
X34 VAPWR analog_0 analog_1 VAPWR sg13_lv_pmos ad=1.14p pd=6.38u as=1.14p ps=6.38u w=6u l=1u
X35 analog_2 ui_in[0].t0 VGND.t32 VGND.t4 sg13_lv_nmos ad=0.19p pd=1.38u as=0.19p ps=1.38u w=1u l=1u
X36 VGND.t30 VGND.t62 VGND.t63 VGND.t57 sg13_lv_nmos ad=0.19p pd=1.38u as=0 ps=0 w=1u l=1u
X37 VGND.t52 VPWR VGND.t52 VGND.t51 sg13_lv_pmos ad=3.4p pd=20.68u as=0 ps=0 w=10u l=10u
X38 VGND.t36 ui_in[0].t0 analog_2 VGND.t8 sg13_lv_nmos ad=0.19p pd=1.38u as=0.19p ps=1.38u w=1u l=1u
X39 VGND.t3 analog_0 analog_1 VGND.t2 sg13_lv_nmos ad=0.19p pd=1.38u as=0.19p ps=1.38u w=1u l=1u
X40 VGND.t34 ui_in[0].t0 analog_2 VGND.t5 sg13_lv_nmos ad=0.19p pd=1.38u as=0.19p ps=1.38u w=1u l=1u
X41 VGND.t38 ui_in[0].t0 analog_2 VGND.t11 sg13_lv_nmos ad=0.19p pd=1.38u as=0.19p ps=1.38u w=1u l=1u
X42 analog_1 analog_0 VAPWR VAPWR sg13_lv_pmos ad=1.14p pd=6.38u as=1.14p ps=6.38u w=6u l=1u
X43 analog_1 analog_0 VAPWR VAPWR sg13_lv_pmos ad=1.14p pd=6.38u as=1.14p ps=6.38u w=6u l=1u
X44 VGND.t40 ui_in[0].t0 analog_2 VGND.t14 sg13_lv_nmos ad=0.19p pd=1.38u as=0.19p ps=1.38u w=1u l=1u
X45 analog_2 ui_in[0].t0 VGND.t44 VGND.t22 sg13_lv_nmos ad=0.19p pd=1.38u as=0.19p ps=1.38u w=1u l=1u
X46 analog_1 analog_0 VGND.t9 VGND.t10 sg13_lv_nmos ad=0.19p pd=1.38u as=0.19p ps=1.38u w=1u l=1u
X47 VAPWR analog_0 analog_1 VAPWR sg13_lv_pmos ad=1.14p pd=6.38u as=1.14p ps=6.38u w=6u l=1u
X48 analog_2 ui_in[0].t0 VGND.t42 VGND.t19 sg13_lv_nmos ad=0.19p pd=1.38u as=0.19p ps=1.38u w=1u l=1u
X49 analog_1 analog_0 VAPWR VAPWR sg13_lv_pmos ad=1.14p pd=6.38u as=1.14p ps=6.38u w=6u l=1u
X50 VGND.t46 ui_in[0].t0 analog_2 VGND.t23 sg13_lv_nmos ad=0.19p pd=1.38u as=0.19p ps=1.38u w=1u l=1u
X51 analog_1 analog_0 VGND.t12 VGND.t13 sg13_lv_nmos ad=0.19p pd=1.38u as=0.19p ps=1.38u w=1u l=1u
X52 VAPWR analog_0 analog_1 VAPWR sg13_lv_pmos ad=1.14p pd=6.38u as=1.14p ps=6.38u w=6u l=1u
X53 analog_1 analog_0 VAPWR VAPWR sg13_lv_pmos ad=1.14p pd=6.38u as=1.14p ps=6.38u w=6u l=1u
X54 VAPWR ui_in[0].t1 analog_2 VAPWR sg13_lv_pmos ad=1.14p pd=6.38u as=1.14p ps=6.38u w=6u l=1u
X55 VGND.t18 analog_0 analog_1 VGND.t17 sg13_lv_nmos ad=0.19p pd=1.38u as=0.19p ps=1.38u w=1u l=1u
X56 analog_1 analog_0 VAPWR VAPWR sg13_lv_pmos ad=1.14p pd=6.38u as=1.14p ps=6.38u w=6u l=1u
X57 analog_1 analog_0 VAPWR VAPWR sg13_lv_pmos ad=1.14p pd=6.38u as=1.14p ps=6.38u w=6u l=1u
X58 analog_2 ui_in[0].t1 VAPWR VAPWR sg13_lv_pmos ad=1.14p pd=6.38u as=1.14p ps=6.38u w=6u l=1u
X59 VGND.t48 ui_in[0].t0 analog_2 VGND.t26 sg13_lv_nmos ad=0.19p pd=1.38u as=0.19p ps=1.38u w=1u l=1u
X60 analog_1 analog_0 VGND.t15 VGND.t16 sg13_lv_nmos ad=0.19p pd=1.38u as=0.19p ps=1.38u w=1u l=1u
X61 VAPWR VAPWR VAPWR VAPWR sg13_lv_pmos ad=2.04p pd=12.68u as=0 ps=0 w=6u l=1u
X62 VGND.t50 VGND.t56 VGND.t58 VGND.t57 sg13_lv_nmos ad=0.19p pd=1.38u as=0 ps=0 w=1u l=1u
X63 VGND.t21 analog_0 analog_1 VGND.t20 sg13_lv_nmos ad=0.19p pd=1.38u as=0.19p ps=1.38u w=1u l=1u
X64 analog_1 analog_0 VGND.t27 VGND.t28 sg13_lv_nmos ad=0.19p pd=1.38u as=0.19p ps=1.38u w=1u l=1u
X65 VGND.t61 VGND.t59 VGND.t1 VGND.t54 sg13_lv_nmos ad=0.34p pd=2.68u as=0 ps=0 w=1u l=1u
X66 analog_1 analog_0 VGND.t6 VGND.t7 sg13_lv_nmos ad=0.19p pd=1.38u as=0.19p ps=1.38u w=1u l=1u
X67 analog_1 analog_0 VGND.t24 VGND.t25 sg13_lv_nmos ad=0.19p pd=1.38u as=0.19p ps=1.38u w=1u l=1u
X68 analog_2 ui_in[0].t1 VAPWR VAPWR sg13_lv_pmos ad=1.14p pd=6.38u as=1.14p ps=6.38u w=6u l=1u
X69 VAPWR ui_in[0].t1 analog_2 VAPWR sg13_lv_pmos ad=1.14p pd=6.38u as=1.14p ps=6.38u w=6u l=1u
X70 VGND.t32 ui_in[0].t0 analog_2 VGND.t2 sg13_lv_nmos ad=0.19p pd=1.38u as=0.19p ps=1.38u w=1u l=1u
X71 VAPWR ui_in[0].t1 analog_2 VAPWR sg13_lv_pmos ad=1.14p pd=6.38u as=1.14p ps=6.38u w=6u l=1u
X72 VAPWR ui_in[0].t1 analog_2 VAPWR sg13_lv_pmos ad=1.14p pd=6.38u as=1.14p ps=6.38u w=6u l=1u
X73 analog_2 ui_in[0].t0 VGND.t36 VGND.t10 sg13_lv_nmos ad=0.19p pd=1.38u as=0.19p ps=1.38u w=1u l=1u
X74 VAPWR ui_in[0].t1 analog_2 VAPWR sg13_lv_pmos ad=1.14p pd=6.38u as=1.14p ps=6.38u w=6u l=1u
X75 analog_2 ui_in[0].t1 VAPWR VAPWR sg13_lv_pmos ad=1.14p pd=6.38u as=1.14p ps=6.38u w=6u l=1u
X76 analog_2 ui_in[0].t0 VGND.t38 VGND.t13 sg13_lv_nmos ad=0.19p pd=1.38u as=0.19p ps=1.38u w=1u l=1u
X77 analog_2 ui_in[0].t1 VAPWR VAPWR sg13_lv_pmos ad=1.14p pd=6.38u as=1.14p ps=6.38u w=6u l=1u
X78 VGND.t42 ui_in[0].t0 analog_2 VGND.t17 sg13_lv_nmos ad=0.19p pd=1.38u as=0.19p ps=1.38u w=1u l=1u
X79 VAPWR analog_0 analog_1 VAPWR sg13_lv_pmos ad=1.14p pd=6.38u as=1.14p ps=6.38u w=6u l=1u
X80 VAPWR ui_in[0].t1 analog_2 VAPWR sg13_lv_pmos ad=1.14p pd=6.38u as=1.14p ps=6.38u w=6u l=1u
X81 analog_2 ui_in[0].t0 VGND.t40 VGND.t16 sg13_lv_nmos ad=0.19p pd=1.38u as=0.19p ps=1.38u w=1u l=1u
X82 analog_1 analog_0 VAPWR VAPWR sg13_lv_pmos ad=1.14p pd=6.38u as=1.14p ps=6.38u w=6u l=1u
X83 VGND.t44 ui_in[0].t0 analog_2 VGND.t20 sg13_lv_nmos ad=0.19p pd=1.38u as=0.19p ps=1.38u w=1u l=1u
X84 analog_2 ui_in[0].t0 VGND.t48 VGND.t28 sg13_lv_nmos ad=0.19p pd=1.38u as=0.19p ps=1.38u w=1u l=1u
X85 VGND.t65 VAPWR VGND.t65 VGND.t64 sg13_lv_pmos ad=3.4p pd=20.68u as=0 ps=0 w=10u l=10u
X86 VAPWR ui_in[0].t1 analog_2 VAPWR sg13_lv_pmos ad=1.14p pd=6.38u as=1.14p ps=6.38u w=6u l=1u
X87 analog_2 ui_in[0].t0 VGND.t34 VGND.t7 sg13_lv_nmos ad=0.19p pd=1.38u as=0.19p ps=1.38u w=1u l=1u
X88 analog_2 ui_in[0].t0 VGND.t46 VGND.t25 sg13_lv_nmos ad=0.19p pd=1.38u as=0.19p ps=1.38u w=1u l=1u
X89 VGND.t30 analog_0 analog_1 VGND.t29 sg13_lv_nmos ad=0.19p pd=1.38u as=0.19p ps=1.38u w=1u l=1u
R0 ui_in[0].n15 ui_in[0].t1 0.994683
R1 ui_in[0].n17 ui_in[0].t0 0.994013
R2 ui_in[0].n9 ui_in[0].n1 0.748572
R3 ui_in[0].n10 ui_in[0].n9 0.578786
R4 ui_in[0].n11 ui_in[0].n10 0.578786
R5 ui_in[0].n12 ui_in[0].n11 0.578786
R6 ui_in[0].n13 ui_in[0].n12 0.578786
R7 ui_in[0].n14 ui_in[0].n13 0.578786
R8 ui_in[0].n15 ui_in[0].n14 0.578786
R9 ui_in[0].n0 ui_in[0].n24 0.755676
R10 ui_in[0].n24 ui_in[0].n23 0.578786
R11 ui_in[0].n23 ui_in[0].n22 0.578786
R12 ui_in[0].n22 ui_in[0].n21 0.578786
R13 ui_in[0].n21 ui_in[0].n20 0.578786
R14 ui_in[0].n20 ui_in[0].n19 0.578786
R15 ui_in[0].n19 ui_in[0].n18 0.578786
R16 ui_in[0].n18 ui_in[0].n17 0.578786
R17 ui_in[0].n14 ui_in[0].n8 0.254024
R18 ui_in[0].n13 ui_in[0].n7 0.254024
R19 ui_in[0].n12 ui_in[0].n6 0.254024
R20 ui_in[0].n11 ui_in[0].n5 0.254024
R21 ui_in[0].n10 ui_in[0].n4 0.254024
R22 ui_in[0].n9 ui_in[0].n3 0.254024
R23 ui_in[0].n1 ui_in[0].n2 0.0282822
R24 ui_in[0].n24 ui_in[0].n2 0.254024
R25 ui_in[0].n23 ui_in[0].n3 0.254024
R26 ui_in[0].n22 ui_in[0].n4 0.254024
R27 ui_in[0].n21 ui_in[0].n5 0.254024
R28 ui_in[0].n20 ui_in[0].n6 0.254024
R29 ui_in[0].n19 ui_in[0].n7 0.254024
R30 ui_in[0].n18 ui_in[0].n8 0.254024
R31 ui_in[0].n17 ui_in[0].n16 0.192615
R32 ui_in[0].n16 ui_in[0].n15 0.191641
R33 ui_in[0].n16 ui_in[0].n8 0.128842
R34 ui_in[0].n1 ui_in[0].n0 0.105962
R35 ui_in[0].n3 ui_in[0].n2 0.12194
R36 ui_in[0].n4 ui_in[0].n3 0.12194
R37 ui_in[0].n5 ui_in[0].n4 0.12194
R38 ui_in[0].n6 ui_in[0].n5 0.12194
R39 ui_in[0].n7 ui_in[0].n6 0.12194
R40 ui_in[0].n8 ui_in[0].n7 0.12194
R41 ui_in[0] ui_in[0].n0 40.295
R42 VGND.n118 VGND.t0 86.957
R43 VGND.t29 VGND.n99 86.957
R44 VGND.n119 VGND.t2 81.5222
R45 VGND.t28 VGND.n100 81.5222
R46 VGND.n120 VGND.t4 76.0875
R47 VGND.t26 VGND.n101 76.0875
R48 VGND.n121 VGND.t5 70.6527
R49 VGND.t25 VGND.n102 70.6527
R50 VGND.n122 VGND.t7 65.2179
R51 VGND.t23 VGND.n103 65.2179
R52 VGND.n123 VGND.t8 59.7831
R53 VGND.t22 VGND.n104 59.7831
R54 VGND.n124 VGND.t10 54.3483
R55 VGND.t14 VGND.n108 54.3483
R56 VGND.n127 VGND.t16 54.3483
R57 VGND.t20 VGND.n105 54.3483
R58 VGND.n125 VGND.t11 48.9135
R59 VGND.t13 VGND.n109 48.9135
R60 VGND.n128 VGND.t17 48.9135
R61 VGND.t19 VGND.n106 48.9135
R62 VGND.t11 VGND.n110 43.4788
R63 VGND.n126 VGND.t13 43.4788
R64 VGND.t17 VGND.n107 43.4788
R65 VGND.n129 VGND.t19 43.4788
R66 VGND.t10 VGND.n111 38.044
R67 VGND.t16 VGND.n2 40.0613
R68 VGND.n130 VGND.t20 38.044
R69 VGND.t8 VGND.n112 32.6092
R70 VGND.n131 VGND.t22 32.6092
R71 VGND.t7 VGND.n113 27.1744
R72 VGND.n132 VGND.t23 27.1744
R73 VGND.t5 VGND.n114 21.7396
R74 VGND.n133 VGND.t25 21.7396
R75 VGND.n0 VGND.n147 17.0005
R76 VGND.n0 VGND.n15 0.661826
R77 VGND.n0 VGND.n182 17.0005
R78 VGND.n15 VGND.n56 14.36
R79 VGND.n24 VGND.n80 14.3607
R80 VGND.n0 VGND.n149 17.0005
R81 VGND.n0 VGND.n136 8.49727
R82 VGND.n0 VGND.n99 8.49046
R83 VGND.n0 VGND.n33 0.661826
R84 VGND.n0 VGND.n180 17.0005
R85 VGND.n33 VGND.n81 14.3607
R86 VGND.n0 VGND.n135 8.49985
R87 VGND.n0 VGND.n100 8.49069
R88 VGND.n26 VGND.n83 14.3607
R89 VGND.n0 VGND.n38 2.4234
R90 VGND.n0 VGND.n134 8.49702
R91 VGND.n0 VGND.n101 8.49093
R92 VGND.n20 VGND.n84 14.36
R93 VGND.n0 VGND.n179 17.0005
R94 VGND.n0 VGND.n20 0.661826
R95 VGND.n0 VGND.n133 8.49945
R96 VGND.n0 VGND.n13 0.661826
R97 VGND.n13 VGND.n60 14.36
R98 VGND.n0 VGND.n36 2.4234
R99 VGND.n0 VGND.n132 8.49677
R100 VGND.n0 VGND.n103 8.49117
R101 VGND.n0 VGND.n16 0.661826
R102 VGND.n16 VGND.n85 14.3607
R103 VGND.n0 VGND.n131 8.49653
R104 VGND.n0 VGND.n32 0.661826
R105 VGND.n0 VGND.n178 17.0005
R106 VGND.n32 VGND.n63 14.36
R107 VGND.n0 VGND.n150 17.0005
R108 VGND.n0 VGND.n130 8.49628
R109 VGND.n0 VGND.n177 17.0005
R110 VGND.n0 VGND.n105 8.49141
R111 VGND.n29 VGND.n64 14.36
R112 VGND.n0 VGND.n29 0.661826
R113 VGND.n0 VGND.n129 8.49603
R114 VGND.n0 VGND.n31 0.661826
R115 VGND.n31 VGND.n65 14.36
R116 VGND.n0 VGND.n154 17.0005
R117 VGND.n0 VGND.n128 8.49924
R118 VGND.n0 VGND.n176 17.0005
R119 VGND.n0 VGND.n107 8.49165
R120 VGND.n25 VGND.n66 14.36
R121 VGND.n0 VGND.n25 0.661826
R122 VGND.n0 VGND.n156 17.0005
R123 VGND.n0 VGND.n127 8.49578
R124 VGND.n0 VGND.n43 4.24736
R125 VGND.n0 VGND.n175 17.0005
R126 VGND.n0 VGND.n108 8.49189
R127 VGND.n0 VGND.n18 0.661826
R128 VGND.n0 VGND.n126 8.49987
R129 VGND.n0 VGND.n109 8.49752
R130 VGND.n30 VGND.n89 14.36
R131 VGND.n0 VGND.n30 0.661826
R132 VGND.n0 VGND.n160 17.0005
R133 VGND.n0 VGND.n125 8.49554
R134 VGND.n0 VGND.n110 8.49213
R135 VGND.n23 VGND.n91 14.36
R136 VGND.n0 VGND.n23 0.661826
R137 VGND.n0 VGND.n124 8.49529
R138 VGND.n0 VGND.n111 8.49237
R139 VGND.n0 VGND.n27 0.661826
R140 VGND.n0 VGND.n171 17.0005
R141 VGND.n27 VGND.n71 14.36
R142 VGND.n0 VGND.n161 17.0005
R143 VGND.n0 VGND.n123 8.49505
R144 VGND.n0 VGND.n112 8.49261
R145 VGND.n12 VGND.n72 14.36
R146 VGND.n0 VGND.n12 0.661826
R147 VGND.n0 VGND.n122 8.50168
R148 VGND.n0 VGND.n113 8.49285
R149 VGND.n28 VGND.n92 14.36
R150 VGND.n0 VGND.n28 0.661826
R151 VGND.n41 VGND.n47 0.00714631
R152 VGND.n0 VGND.n121 8.4948
R153 VGND.n0 VGND.n114 8.49309
R154 VGND.n0 VGND.n17 0.661826
R155 VGND.n17 VGND.n75 14.36
R156 VGND.n0 VGND.n120 8.49456
R157 VGND.n0 VGND.n115 8.49334
R158 VGND.n0 VGND.n14 0.661826
R159 VGND.n14 VGND.n77 14.3607
R160 VGND.n0 VGND.n119 8.49431
R161 VGND.n0 VGND.n116 8.49358
R162 VGND.n19 VGND.n78 14.3607
R163 VGND.n0 VGND.n118 8.49407
R164 VGND.n0 VGND.n117 8.49382
R165 VGND.n22 VGND.n95 14.36
R166 VGND.n0 VGND.n22 0.661826
R167 VGND.n21 VGND.n79 14.36
R168 VGND.n0 VGND.n21 0.661826
R169 VGND.n55 VGND.n184 17.0005
R170 VGND.n55 VGND.n215 17.0005
R171 VGND.n55 VGND.n186 17.0005
R172 VGND.n55 VGND.n187 17.0005
R173 VGND.n55 VGND.n188 17.0005
R174 VGND.n55 VGND.n211 17.0005
R175 VGND.n55 VGND.n190 17.0005
R176 VGND.n55 VGND.n208 17.0005
R177 VGND.n55 VGND.n192 17.0005
R178 VGND.n55 VGND.n207 17.0005
R179 VGND.n55 VGND.n41 17.0005
R180 VGND.n55 VGND.n50 4.2472
R181 VGND.n55 VGND.n97 17.0005
R182 VGND.n0 VGND.n102 8.4996
R183 VGND.n0 VGND.n104 8.49899
R184 VGND.n0 VGND.n106 8.4992
R185 VGND.n0 VGND.n2 4.09605
R186 VGND.n0 VGND.n1 4.09588
R187 VGND.t4 VGND.n115 16.3048
R188 VGND.n134 VGND.t26 16.3048
R189 VGND.t53 VGND.n146 15.0005
R190 VGND.t62 VGND.n229 15.0005
R191 VGND.n219 VGND.t56 15.0005
R192 VGND.n237 VGND.t59 15.0005
R193 VGND.n15 VGND.t57 7.18094
R194 VGND.n26 VGND.n82 14.3607
R195 VGND.n19 VGND.n94 14.3607
R196 VGND.n21 VGND.t54 7.18094
R197 VGND.n22 VGND.n79 14.3614
R198 VGND.n28 VGND.n93 14.3614
R199 VGND.n12 VGND.n73 14.3614
R200 VGND.n23 VGND.n69 14.3614
R201 VGND.n30 VGND.n90 14.3614
R202 VGND.n18 VGND.n68 14.3614
R203 VGND.n25 VGND.n88 14.3614
R204 VGND.n29 VGND.n86 14.3614
R205 VGND.n20 VGND.n58 14.3607
R206 VGND.n0 VGND.n3 3.99255
R207 VGND.t2 VGND.n116 10.8701
R208 VGND.n135 VGND.t28 10.8701
R209 VGND.n45 VGND.n52 0.0165888
R210 VGND.t51 VGND.t52 0.65245
R211 VGND.n98 VGND.n55 0.00286578
R212 VGND.n0 VGND.n148 8.4984
R213 VGND.n0 VGND.n181 8.4984
R214 VGND.n38 VGND.n186 0.0205392
R215 VGND.n36 VGND.n187 0.0205392
R216 VGND.n0 VGND.n11 4.24652
R217 VGND.n0 VGND.n151 8.4984
R218 VGND.n0 VGND.n152 8.4984
R219 VGND.n0 VGND.n153 8.4984
R220 VGND.n0 VGND.n155 8.4984
R221 VGND.n43 VGND.n208 0.0123816
R222 VGND.n0 VGND.n157 8.4984
R223 VGND.n0 VGND.n158 8.4984
R224 VGND.n0 VGND.n159 8.4984
R225 VGND.n0 VGND.n174 8.4984
R226 VGND.n0 VGND.n173 8.4984
R227 VGND.n0 VGND.n172 8.4984
R228 VGND.n0 VGND.n169 8.4984
R229 VGND.n0 VGND.n168 8.4984
R230 VGND.n0 VGND.n167 8.4984
R231 VGND.n34 VGND.n41 0.0288738
R232 VGND.n0 VGND.n34 1.53452
R233 VGND.n35 VGND.n49 0.0362733
R234 VGND.n0 VGND.n162 8.4984
R235 VGND.n0 VGND.n163 8.4984
R236 VGND.n0 VGND.n164 8.4984
R237 VGND.n0 VGND.n165 8.4984
R238 VGND.n0 VGND.n166 8.4984
R239 VGND.n55 VGND.n183 8.4984
R240 VGND.n55 VGND.n185 8.4984
R241 VGND.n55 VGND.n214 8.4984
R242 VGND.n40 VGND.n39 0.0157515
R243 VGND.n55 VGND.n40 2.41741
R244 VGND.n11 VGND.n37 0.0231214
R245 VGND.n10 VGND.n11 0.0208968
R246 VGND.n55 VGND.n10 1.52474
R247 VGND.n55 VGND.n213 8.4984
R248 VGND.n55 VGND.n189 8.4984
R249 VGND.n55 VGND.n212 8.4984
R250 VGND.n55 VGND.n209 8.4984
R251 VGND.n55 VGND.n191 8.4984
R252 VGND.n44 VGND.t40 0.0145827
R253 VGND.n55 VGND.n44 4.24316
R254 VGND.n55 VGND.n193 8.4984
R255 VGND.n55 VGND.n194 8.4984
R256 VGND.n55 VGND.n195 8.4984
R257 VGND.n55 VGND.n196 8.4984
R258 VGND.n55 VGND.n205 8.4984
R259 VGND.n55 VGND.n204 8.4984
R260 VGND.n55 VGND.n203 8.4984
R261 VGND.n55 VGND.n202 8.4984
R262 VGND.n55 VGND.n197 8.4984
R263 VGND.n55 VGND.n48 4.24745
R264 VGND.n35 VGND.n34 0.0380956
R265 VGND.n55 VGND.n35 4.23825
R266 VGND.n55 VGND.n198 8.4984
R267 VGND.n55 VGND.n201 8.4984
R268 VGND.n55 VGND.n199 8.4984
R269 VGND.n55 VGND.n200 8.4984
R270 VGND.n46 VGND.n45 0.0185557
R271 VGND.n234 VGND.t53 7.49606
R272 VGND.n230 VGND.t62 7.49606
R273 VGND.t56 VGND.n216 7.49606
R274 VGND.t59 VGND.n145 7.49606
R275 VGND.n82 VGND.n100 7.18094
R276 VGND.n84 VGND.n101 7.18094
R277 VGND.n62 VGND.n104 7.18094
R278 VGND.n64 VGND.n105 7.18094
R279 VGND.n87 VGND.n106 7.18094
R280 VGND.n66 VGND.n107 7.18094
R281 VGND.n89 VGND.n109 7.18094
R282 VGND.n91 VGND.n110 7.18094
R283 VGND.n72 VGND.n112 7.18094
R284 VGND.n92 VGND.n113 7.18094
R285 VGND.n94 VGND.n116 7.18094
R286 VGND.n95 VGND.n117 7.18094
R287 VGND.n76 VGND.n14 14.3614
R288 VGND.n75 VGND.n120 7.18094
R289 VGND.n74 VGND.n17 14.3614
R290 VGND.n71 VGND.n123 7.18094
R291 VGND.n70 VGND.n27 14.3614
R292 VGND.n67 VGND.n18 14.3607
R293 VGND.n1 VGND.t14 40.0614
R294 VGND.n65 VGND.n128 7.18094
R295 VGND.n63 VGND.n130 7.18094
R296 VGND.n61 VGND.n16 14.3614
R297 VGND.n60 VGND.n132 7.18094
R298 VGND.n59 VGND.n13 14.3614
R299 VGND.n58 VGND.n133 7.18094
R300 VGND.n57 VGND.n33 14.3614
R301 VGND.n56 VGND.n24 14.3614
R302 VGND.n3 VGND.t57 7.65306
R303 VGND.n80 VGND.n136 7.18026
R304 VGND.n81 VGND.n135 7.18026
R305 VGND.n83 VGND.n134 7.18026
R306 VGND.n85 VGND.n131 7.18026
R307 VGND.n62 VGND.n32 14.3607
R308 VGND.n86 VGND.n129 7.18026
R309 VGND.n87 VGND.n31 14.3607
R310 VGND.n88 VGND.n127 7.18026
R311 VGND.n55 VGND.n2 4.12198
R312 VGND.n68 VGND.n126 7.18026
R313 VGND.n90 VGND.n125 7.18026
R314 VGND.n69 VGND.n124 7.18026
R315 VGND.n73 VGND.n122 7.18026
R316 VGND.n93 VGND.n121 7.18026
R317 VGND.n77 VGND.n119 7.18026
R318 VGND.n78 VGND.n118 7.18026
R319 VGND.n57 VGND.n99 7.18026
R320 VGND.n59 VGND.n102 7.18026
R321 VGND.n61 VGND.n103 7.18026
R322 VGND.n67 VGND.n108 7.18026
R323 VGND.n70 VGND.n111 7.18026
R324 VGND.n74 VGND.n114 7.18026
R325 VGND.n76 VGND.n115 7.18026
R326 VGND.n51 VGND.n52 0.014375
R327 VGND.t64 VGND.n45 0.112709
R328 VGND.t0 VGND.n117 5.43528
R329 VGND.n136 VGND.t29 5.43528
R330 VGND.t1 VGND.n144 4.5005
R331 VGND.n235 VGND.t31 4.5005
R332 VGND.t30 VGND.n228 4.5005
R333 VGND.t50 VGND.n218 4.5005
R334 VGND.n55 VGND.n96 4.25219
R335 VGND.n232 VGND.n55 4.25206
R336 VGND.n0 VGND.n232 4.25175
R337 VGND.n0 VGND.n96 4.25169
R338 VGND.n53 VGND.n52 0.406321
R339 VGND.n239 VGND.n238 3.0005
R340 VGND.n233 VGND.n143 3.0005
R341 VGND.n227 VGND.n217 3.0005
R342 VGND.n221 VGND.n220 3.0005
R343 VGND.n241 VGND.t3 2.48177
R344 VGND.n242 VGND.t6 2.48177
R345 VGND.n243 VGND.t9 2.48177
R346 VGND.n142 VGND.t12 2.48177
R347 VGND.t18 VGND.n141 2.48177
R348 VGND.n223 VGND.t21 2.48177
R349 VGND.n224 VGND.t24 2.48177
R350 VGND.n225 VGND.t27 2.48177
R351 VGND.n241 VGND.t32 2.48177
R352 VGND.n242 VGND.t34 2.48177
R353 VGND.n243 VGND.t36 2.48177
R354 VGND.n142 VGND.t38 2.48177
R355 VGND.t42 VGND.n141 2.48177
R356 VGND.n223 VGND.t44 2.48177
R357 VGND.n224 VGND.t46 2.48177
R358 VGND.n225 VGND.t48 2.48177
R359 VGND.n0 VGND.n26 0.661826
R360 VGND.n0 VGND.n19 0.661826
R361 VGND.n0 VGND.n4 1.12969
R362 VGND.t61 VGND.n144 2.2505
R363 VGND.t55 VGND.n235 2.2505
R364 VGND.n228 VGND.t63 2.2505
R365 VGND.n218 VGND.t58 2.2505
R366 VGND VGND.n244 1.88203
R367 VGND.n244 VGND.n42 1.49725
R368 VGND.n55 VGND.n3 0.169594
R369 VGND.n55 VGND.n56 0.661826
R370 VGND.n55 VGND.n57 0.661826
R371 VGND.n55 VGND.n58 0.661826
R372 VGND.n55 VGND.n59 0.661826
R373 VGND.n55 VGND.n60 0.661826
R374 VGND.n55 VGND.n61 0.661826
R375 VGND.n55 VGND.n62 0.661826
R376 VGND.n55 VGND.n63 0.661826
R377 VGND.n55 VGND.n64 0.661826
R378 VGND.n55 VGND.n65 0.661826
R379 VGND.n55 VGND.n66 0.661826
R380 VGND.n55 VGND.n1 4.12191
R381 VGND.n55 VGND.n67 0.661826
R382 VGND.n55 VGND.n68 0.661826
R383 VGND.n55 VGND.n69 0.661826
R384 VGND.n55 VGND.n70 0.661826
R385 VGND.n55 VGND.n71 0.661826
R386 VGND.n55 VGND.n72 0.661826
R387 VGND.n55 VGND.n73 0.661826
R388 VGND.n55 VGND.n74 0.661826
R389 VGND.n55 VGND.n75 0.661826
R390 VGND.n55 VGND.n76 0.661826
R391 VGND.n55 VGND.n77 0.661826
R392 VGND.n55 VGND.n78 0.661826
R393 VGND.n55 VGND.n79 0.661826
R394 VGND.n4 VGND.t54 7.7691
R395 VGND.n55 VGND.n4 0.048659
R396 VGND.n55 VGND.n80 0.661826
R397 VGND.n55 VGND.n81 0.661826
R398 VGND.n55 VGND.n82 0.661826
R399 VGND.n55 VGND.n83 0.661826
R400 VGND.n55 VGND.n84 0.661826
R401 VGND.n55 VGND.n85 0.661826
R402 VGND.n55 VGND.n86 0.661826
R403 VGND.n55 VGND.n87 0.661826
R404 VGND.n55 VGND.n88 0.661826
R405 VGND.n55 VGND.n89 0.661826
R406 VGND.n55 VGND.n90 0.661826
R407 VGND.n55 VGND.n91 0.661826
R408 VGND.n55 VGND.n92 0.661826
R409 VGND.n55 VGND.n93 0.661826
R410 VGND.n55 VGND.n94 0.661826
R411 VGND.n55 VGND.n95 0.661826
R412 VGND.n54 VGND.t65 0.412464
R413 VGND.n8 VGND.n5 0.209311
R414 VGND.n9 VGND.n8 0.109949
R415 VGND.n140 VGND.n5 0.00335118
R416 VGND.n9 VGND.n6 0.411619
R417 VGND.n139 VGND.n138 0.409591
R418 VGND.n140 VGND.n137 0.409591
R419 VGND.n5 VGND.n54 0.412459
R420 VGND.n46 VGND.n51 0.0304992
R421 VGND.n53 VGND.t65 0.532781
R422 VGND.n53 VGND.n46 2.52036
R423 VGND.n0 VGND.n24 1.51913
R424 VGND.n244 VGND.n8 1.46462
R425 VGND.n49 VGND.t32 0.200997
R426 VGND.n47 VGND.t34 0.200997
R427 VGND.n170 VGND.t36 0.200997
R428 VGND.n206 VGND.t38 0.200997
R429 VGND.n210 VGND.t42 0.200997
R430 VGND.t44 VGND.n222 0.200997
R431 VGND.t46 VGND.n37 0.200997
R432 VGND.t48 VGND.n39 0.200997
R433 VGND.n49 VGND.t3 0.200995
R434 VGND.n47 VGND.t6 0.200995
R435 VGND.n170 VGND.t9 0.200995
R436 VGND.n206 VGND.t12 0.200995
R437 VGND.n210 VGND.t18 0.200995
R438 VGND.n222 VGND.t21 0.200995
R439 VGND.n37 VGND.t24 0.200995
R440 VGND.n39 VGND.t27 0.200995
R441 VGND.t40 VGND.t15 0.185126
R442 VGND.n241 VGND.n240 0.117247
R443 VGND.n226 VGND.n225 0.1171
R444 VGND.t65 VGND.n51 1.34764
R445 VGND.n242 VGND.n241 0.08146
R446 VGND.n243 VGND.n242 0.08146
R447 VGND.n142 VGND.n243 0.08146
R448 VGND.n42 VGND.n142 0.08146
R449 VGND.n42 VGND.n141 0.08146
R450 VGND.n223 VGND.n141 0.08146
R451 VGND.n224 VGND.n223 0.08146
R452 VGND.n225 VGND.n224 0.08146
R453 VGND.t63 VGND.n98 1.03875
R454 VGND.t55 VGND.n0 1.05816
R455 VGND.n0 VGND.t58 1.02989
R456 VGND.t31 VGND.n234 0.031258
R457 VGND.n145 VGND.t1 0.031258
R458 VGND.n240 VGND.n239 0.0291125
R459 VGND.n240 VGND.n143 0.0291125
R460 VGND.n226 VGND.n221 0.0291125
R461 VGND.n227 VGND.n226 0.0291125
R462 VGND.n239 VGND.n144 0.0281144
R463 VGND.n235 VGND.n143 0.0281144
R464 VGND.n221 VGND.n218 0.0281144
R465 VGND.n228 VGND.n227 0.0281144
R466 VGND.n231 VGND.n230 0.0216549
R467 VGND.n231 VGND.n216 0.0216549
R468 VGND.n229 VGND.t30 0.0208704
R469 VGND.n219 VGND.t50 0.0208704
R470 VGND.n233 VGND.n146 0.0202884
R471 VGND.n229 VGND.n217 0.0202884
R472 VGND.n220 VGND.n219 0.0202884
R473 VGND.n238 VGND.n237 0.0202884
R474 VGND.t40 VGND.n42 0.0194533
R475 VGND.n232 VGND.n231 0.0162424
R476 VGND.n236 VGND.n96 0.0159649
R477 VGND.n185 VGND.n148 0.0118857
R478 VGND.n214 VGND.n181 0.0118857
R479 VGND.n39 VGND.n38 0.00653337
R480 VGND.n37 VGND.n36 0.00653337
R481 VGND.n189 VGND.n151 0.0118857
R482 VGND.n212 VGND.n153 0.0118857
R483 VGND.n191 VGND.n155 0.0118857
R484 VGND.t40 VGND.n43 0.00668938
R485 VGND.n193 VGND.n157 0.0118857
R486 VGND.n194 VGND.n158 0.0118857
R487 VGND.n195 VGND.n174 0.0118857
R488 VGND.n196 VGND.n173 0.0118857
R489 VGND.n205 VGND.n173 0.0118857
R490 VGND.n204 VGND.n172 0.0118857
R491 VGND.n202 VGND.n169 0.0118857
R492 VGND.n197 VGND.n167 0.0118857
R493 VGND.n48 VGND.n167 0.0173885
R494 VGND.n50 VGND.n49 0.00668917
R495 VGND.n198 VGND.n162 0.0118857
R496 VGND.n201 VGND.n164 0.0118857
R497 VGND.n199 VGND.n164 0.0118857
R498 VGND.n200 VGND.n166 0.0118857
R499 VGND.n200 VGND.n165 0.0118857
R500 VGND.n199 VGND.n165 0.0118857
R501 VGND.n201 VGND.n163 0.0118857
R502 VGND.n198 VGND.n163 0.0118857
R503 VGND.n50 VGND.n162 0.0180746
R504 VGND.n197 VGND.n168 0.0118857
R505 VGND.n202 VGND.n168 0.0118857
R506 VGND.n203 VGND.n169 0.0118857
R507 VGND.n205 VGND.n172 0.0118857
R508 VGND.n196 VGND.n174 0.0118857
R509 VGND.n194 VGND.n159 0.0118857
R510 VGND.n193 VGND.n158 0.0118857
R511 VGND.n212 VGND.n152 0.0118857
R512 VGND.n189 VGND.n152 0.0118857
R513 VGND.n236 VGND.n146 0.0115582
R514 VGND.n237 VGND.n236 0.0115582
R515 VGND.n192 VGND.n175 0.0108889
R516 VGND.n208 VGND.n156 0.0108889
R517 VGND.n190 VGND.n176 0.0108889
R518 VGND.n188 VGND.n177 0.0108889
R519 VGND.n187 VGND.n179 0.0108889
R520 VGND.n186 VGND.n180 0.0108889
R521 VGND.n215 VGND.n149 0.0108889
R522 VGND.n184 VGND.n182 0.0108889
R523 VGND.n234 VGND.n233 0.0108877
R524 VGND.n230 VGND.n217 0.0108877
R525 VGND.n220 VGND.n216 0.0108877
R526 VGND.n238 VGND.n145 0.0108877
R527 VGND.n231 VGND.t63 0.0101032
R528 VGND.n231 VGND.t58 0.0101032
R529 VGND.n236 VGND.t55 0.00981217
R530 VGND.n236 VGND.t61 0.00981217
R531 VGND.n171 VGND.n170 0.00691667
R532 VGND.n222 VGND.n150 0.00691667
R533 VGND.t52 VGND.n7 0.423503
R534 VGND.n7 VGND.n6 0.0160967
R535 VGND.n6 VGND.n138 0.00643258
R536 VGND.n138 VGND.n137 0.00643258
R537 VGND.n137 VGND.n54 0.00643258
R538 VGND.n236 VGND.n97 0.00630556
R539 VGND.n211 VGND.n153 0.00619286
R540 VGND.n207 VGND.n159 0.00619286
R541 VGND.n166 VGND.n97 0.00619286
R542 VGND.n183 VGND.n182 0.00619286
R543 VGND.n213 VGND.n150 0.00619286
R544 VGND.n209 VGND.n154 0.00619286
R545 VGND.n203 VGND.n161 0.00619286
R546 VGND.n48 VGND.n47 0.00600277
R547 VGND.n204 VGND.n171 0.00619286
R548 VGND.n195 VGND.n160 0.00619286
R549 VGND.n192 VGND.n157 0.00619286
R550 VGND.n44 VGND.n175 0.0202756
R551 VGND.n191 VGND.n156 0.00619286
R552 VGND.n190 VGND.n155 0.00619286
R553 VGND.n209 VGND.n176 0.00619286
R554 VGND.n188 VGND.n151 0.00619286
R555 VGND.n213 VGND.n177 0.00619286
R556 VGND.n10 VGND.n178 0.0635609
R557 VGND.n40 VGND.n179 0.0435933
R558 VGND.n214 VGND.n180 0.00619286
R559 VGND.n215 VGND.n181 0.00619286
R560 VGND.n185 VGND.n149 0.00619286
R561 VGND.n184 VGND.n148 0.00619286
R562 VGND.n183 VGND.n147 0.00619286
R563 VGND.n231 VGND.n147 0.00615278
R564 VGND.n206 VGND.n160 0.00569444
R565 VGND.n207 VGND.n206 0.00569444
R566 VGND.n210 VGND.n154 0.00569444
R567 VGND.n211 VGND.n210 0.00569444
R568 VGND.n8 VGND.n7 0.101515
R569 VGND.n139 VGND.n9 0.0051722
R570 VGND.n140 VGND.n139 0.00524607
R571 VGND.n170 VGND.n161 0.00447222
R572 VGND.n222 VGND.n178 0.00447222
R573 VGND.t61 VGND.n98 1.08146
C0 analog_1 analog_2 0.72158f
C1 VAPWR analog_0 26.7524f
C2 analog_0 ui_in[0] 0.12731f
C3 VAPWR analog_2 11.144f
C4 ui_in[0] analog_2 16.0232f
C5 VAPWR analog_1 11.1938f
C6 VPWR ui_in[0] 0.54099f
C7 VAPWR ui_in[0] 26.8581f
C8 analog_0 analog_1 16.6419f
C9 uo_out[0] VGND 0.04448f
C10 uo_out[1] VGND 0.03799f
C11 uo_out[2] VGND 0.03799f
C12 uo_out[3] VGND 0.03799f
C13 uo_out[4] VGND 0.03799f
C14 uo_out[5] VGND 0.03799f
C15 uo_out[6] VGND 0.03799f
C16 uo_out[7] VGND 0.03799f
C17 uio_out[0] VGND 0.03799f
C18 uio_out[1] VGND 0.03799f
C19 uio_out[2] VGND 0.03799f
C20 uio_out[3] VGND 0.03799f
C21 uio_out[4] VGND 0.03799f
C22 uio_out[5] VGND 0.03799f
C23 uio_out[6] VGND 0.03799f
C24 uio_out[7] VGND 0.03799f
C25 uio_oe[0] VGND 0.03799f
C26 uio_oe[1] VGND 0.03799f
C27 uio_oe[2] VGND 0.03799f
C28 uio_oe[3] VGND 0.03799f
C29 uio_oe[4] VGND 0.03799f
C30 uio_oe[5] VGND 0.03799f
C31 uio_oe[6] VGND 0.03799f
C32 uio_oe[7] VGND 0.03799f
C33 ui_in[1] VGND 0.03799f
C34 ui_in[2] VGND 0.03799f
C35 ui_in[3] VGND 0.03799f
C36 ui_in[4] VGND 0.03799f
C37 ui_in[5] VGND 0.03799f
C38 ui_in[6] VGND 0.03799f
C39 ui_in[7] VGND 0.03799f
C40 uio_in[0] VGND 0.03799f
C41 uio_in[1] VGND 0.03799f
C42 uio_in[2] VGND 0.03799f
C43 uio_in[3] VGND 0.03799f
C44 uio_in[4] VGND 0.03799f
C45 uio_in[5] VGND 0.03799f
C46 uio_in[6] VGND 0.03799f
C47 uio_in[7] VGND 0.03799f
C48 ena VGND 0.03799f
C49 clk VGND 0.03799f
C50 rst_n VGND 0.04448f
C51 analog_1 VGND 24.30245f
C52 analog_2 VGND 29.06621f
C53 ui_in[0] VGND 28.23714f
C54 VGND.t52 VGND 43.632f
C55 VGND.t1 VGND 11.71255f
C56 VGND.t50 VGND 3.09716f
C57 ui_in[0].n0 VGND 4.027f
C58 ui_in[0].n1 VGND 0.12143f
C59 ui_in[0].n2 VGND 0.23471f
C60 ui_in[0].n3 VGND 0.23471f
C61 ui_in[0].n4 VGND 0.23471f
C62 ui_in[0].n5 VGND 0.23471f
C63 ui_in[0].n6 VGND 0.23471f
C64 ui_in[0].n7 VGND 0.23471f
C65 ui_in[0].n8 VGND 0.24805f
C66 ui_in[0].n9 VGND 0.07136f
C67 ui_in[0].n10 VGND 0.05503f
C68 ui_in[0].n11 VGND 0.05503f
C69 ui_in[0].n12 VGND 0.05503f
C70 ui_in[0].n13 VGND 0.05503f
C71 ui_in[0].n14 VGND 0.05503f
C72 ui_in[0].n15 VGND 0.61403f
C73 ui_in[0].n16 VGND 2.46899f
C74 ui_in[0].n17 VGND 0.62395f
C75 ui_in[0].n18 VGND 0.05503f
C76 ui_in[0].n19 VGND 0.05503f
C77 ui_in[0].n20 VGND 0.05503f
C78 ui_in[0].n21 VGND 0.05503f
C79 ui_in[0].n22 VGND 0.05503f
C80 ui_in[0].n23 VGND 0.05503f
C81 ui_in[0].n24 VGND 0.0721f
.ends
