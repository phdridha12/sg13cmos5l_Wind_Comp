* NGSPICE file created from top_flat.ext - technology: ihp-sg13cmos5l

.subckt wind_comp_pex s4_an[0] s4_an_0_esd vbias dig_in[23] dig_in[22] dig_in[21] dig_in[20] dig_in[19] dig_in[18] dig_in[17] dig_in[16] dig_in[15] dig_in[14] dig_in[13] dig_in[12] dig_in[11] dig_in[10] dig_in[9] dig_in[8] dig_in[7] dig_in[6] dig_in[5] dig_in[4] dig_in[3] dig_in[2] dig_in[1] dig_in[0] dig_out[11] dig_out[10] dig_out[9] dig_out[8] dig_out[7] dig_out[6] dig_out[5] dig_out[4] dig_out[3] dig_out[2] dig_out[1] dig_out[0] ibias0 ibias1 analog_bus3 analog_bus2 analog_bus1 enable clk reset analog_bus0 vss_1v2 vdd_1v2 vss_3v3 vdd_3v3
X0 vdd_1v2 wind_comp_0.comparator_0.sg13cmos5l_inv_16_0.A wind_comp_0.comparator_0.vout_comp vdd_1v2 sg13_lv_pmos ad=0.2128p pd=1.5u as=0.2128p ps=1.5u w=1.12u l=0.13u
X1 wind_comp_0.comparator_0.dynamic_pcell_0.SRC_NET_IJ vdd_1v2 vdd_1v2 vdd_1v2 sg13_lv_pmos ad=95f pd=0.88u as=95f ps=0.88u w=0.5u l=0.5u
X2 vss_1v2.t157 vss_1v2.t155 vss_1v2.t156 vss_1v2.t145 sg13_lv_nmos ad=0.1082p pd=1.34u as=0 ps=0 w=0.26u l=0.5u
X3 wind_comp_0.comparator_0.sg13cmos5l_inv_16_0.A wind_comp_0.comparator_0.sg13cmos5l_inv_16_1.A vdd_1v2 vdd_1v2 sg13_lv_pmos ad=0.2128p pd=1.5u as=0.2128p ps=1.5u w=1.12u l=0.13u
X4 vss_1v2.t92 vss_1v2.t93 wind_comp_0.comparator_1.dynamic_pcell$7_0.DRN_NET_CF_GATE_CD vss_1v2.t94 sg13_lv_nmos ad=63.19999f pd=0.74u as=63.19999f ps=0.74u w=0.26u l=0.5u
X5 vss_1v2.t309 wind_comp_0.comparator_1.sg13cmos5l_inv_16_1.A wind_comp_0.comparator_1.sg13cmos5l_inv_16_0.A vss_1v2.t313 sg13_lv_nmos ad=0.1406p pd=1.12u as=0.1406p ps=1.12u w=0.74u l=0.13u
X6 vdd_1v2 wind_comp_0.comparator_0.sg13cmos5l_inv_16_1.A wind_comp_0.comparator_0.sg13cmos5l_inv_16_0.A vdd_1v2 sg13_lv_pmos ad=0.3808p pd=2.92u as=0.2128p ps=1.5u w=1.12u l=0.13u
X7 wind_comp_0.comparator_0.dynamic_pcell$7_0.SRC_NET_EF wind_comp_0.comparator_0.nmos$2_0.Drain vss_1v2.t44 vss_1v2.t327 sg13_lv_nmos ad=0.95p pd=5.38u as=0.95p ps=5.38u w=5u l=3u
X8 vss_1v2.t309 wind_comp_0.comparator_1.sg13cmos5l_inv_16_1.A wind_comp_0.comparator_1.sg13cmos5l_inv_16_0.A vss_1v2.t308 sg13_lv_nmos ad=0.1406p pd=1.12u as=0.1406p ps=1.12u w=0.74u l=0.13u
X9 wind_comp_0.comparator_0.nmos$2_0.Drain wind_comp_0.comparator_0.nmos$2_0.Drain vss_1v2.t328 vss_1v2.t325 sg13_lv_nmos ad=0.95p pd=5.38u as=0.95p ps=5.38u w=5u l=3u
X10 wind_comp_0.comparator_0.vout_comp wind_comp_0.comparator_0.sg13cmos5l_inv_16_0.A vss_1v2.t263 vss_1v2.t375 sg13_lv_nmos ad=0.1406p pd=1.12u as=0.1406p ps=1.12u w=0.74u l=0.13u
X11 vdd_1v2 wind_comp_0.comparator_0.sg13cmos5l_inv_16_1.A wind_comp_0.comparator_0.sg13cmos5l_inv_16_0.A vdd_1v2 sg13_lv_pmos ad=0.2128p pd=1.5u as=0.2128p ps=1.5u w=1.12u l=0.13u
X12 vdd_1v2 vdd_1v2 vdd_1v2 vdd_1v2 sg13_lv_pmos ad=66.49999f pd=0.73u as=0.67222n ps=1.23162m w=0.35u l=0.5u
X13 vdd_1v2 vdd_1v2 vdd_1v2 vdd_1v2 sg13_lv_pmos ad=95f pd=0.88u as=0 ps=0 w=0.5u l=0.5u
X14 vss_1v2.t240 wind_comp_0.comparator_1.sg13cmos5l_inv_16_1.A wind_comp_0.comparator_1.sg13cmos5l_inv_16_0.A vss_1v2.t304 sg13_lv_nmos ad=0.1406p pd=1.12u as=0.1406p ps=1.12u w=0.74u l=0.13u
X15 wind_comp_0.sg13g2_and2_2$1_0.B wind_comp_0.comparator_1.sg13cmos5l_inv_16_0.A vdd_1v2 vdd_1v2 sg13_lv_pmos ad=0.2128p pd=1.5u as=0.2128p ps=1.5u w=1.12u l=0.13u
X16 wind_comp_0.comparator_0.dynamic_pcell$7_0.A_DRN wind_comp_0.comparator_0.dynamic_pcell$7_0.A_DRN vss_1v2.t279 vss_1v2.t278 sg13_lv_nmos ad=63.19999f pd=0.74u as=63.19999f ps=0.74u w=0.26u l=10u
X17 vss_1v2.t237 wind_comp_0.comparator_1.nmos_0.Gate wind_comp_0.comparator_1.dynamic_pcell_0.DRN_NET_GJ_GATE_GH vss_1v2.t236 sg13_lv_nmos ad=55.5f pd=0.74u as=0.1005p ps=1.34u w=0.15u l=0.13u
X18 vss_1v2.t285 wind_comp_0.comparator_0.sg13cmos5l_inv_16_1.A wind_comp_0.comparator_0.sg13cmos5l_inv_16_0.A vss_1v2.t292 sg13_lv_nmos ad=0.1406p pd=1.12u as=0.1406p ps=1.12u w=0.74u l=0.13u
X19 vss_1v2.t338 wind_comp_0.comparator_1.dynamic_pcell$7_0.D_DRN wind_comp_0.comparator_1.dynamic_pcell$7_0.A_DRN vss_1v2.t335 sg13_lv_nmos ad=63.19999f pd=0.74u as=63.19999f ps=0.74u w=0.26u l=10u
X20 vss_1v2.t326 wind_comp_0.comparator_0.nmos$2_0.Drain wind_comp_0.comparator_0.nmos$2_0.Drain vss_1v2.t327 sg13_lv_nmos ad=0.95p pd=5.38u as=0.95p ps=5.38u w=5u l=3u
X21 wind_comp_0.comparator_1.dynamic_pcell_0.SRC_NET_IJ wind_comp_0.comparator_1.dynamic_pcell$2_0.DRN_NET_LM_GATE_KL vdd_1v2 vdd_1v2 sg13_lv_pmos ad=95f pd=0.88u as=95f ps=0.88u w=0.5u l=3u
X22 vss_1v2.t285 wind_comp_0.comparator_0.sg13cmos5l_inv_16_1.A wind_comp_0.comparator_0.sg13cmos5l_inv_16_0.A vss_1v2.t288 sg13_lv_nmos ad=0.1406p pd=1.12u as=0.1406p ps=1.12u w=0.74u l=0.13u
X23 vdd_1v2 wind_comp_0.comparator_0.dynamic_pcell$2_0.DRN_NET_LM_GATE_KL wind_comp_0.comparator_0.dynamic_pcell$2_0.DRN_NET_LM_GATE_KL vdd_1v2 sg13_lv_pmos ad=95f pd=0.88u as=95f ps=0.88u w=0.5u l=3u
X24 wind_comp_0.comparator_1.dynamic_pcell_0.DRN_NET_GJ_GATE_GH wind_comp_0.comparator_1.dynamic_pcell$7_0.D_DRN wind_comp_0.comparator_1.dynamic_pcell_0.SRC_NET_IJ vdd_1v2 sg13_lv_pmos ad=0.5928p pd=3.5u as=0.5928p ps=3.5u w=3.12u l=1u
X25 wind_comp_0.comparator_1.sg13cmos5l_inv_16_1.A wind_comp_0.comparator_1.dynamic_pcell$7_0.A_DRN wind_comp_0.comparator_1.dynamic_pcell_0.SRC_NET_IJ vdd_1v2 sg13_lv_pmos ad=0.5928p pd=3.5u as=0.5928p ps=3.5u w=3.12u l=1u
X26 vdd_1v2 vdd_1v2 vdd_1v2 vdd_1v2 sg13_lv_pmos ad=1.0608p pd=6.92u as=0 ps=0 w=3.12u l=0.5u
X27 vss_1v2.t181 vss_1v2.t182 vss_1v2.t181 vss_1v2.t154 sg13_lv_nmos ad=63.19999f pd=0.74u as=0 ps=0 w=0.26u l=0.5u
X28 wind_comp_0.comparator_1.dynamic_pcell$7_0.D_DRN vss_1v2.t206 vss_1v2.t169 vss_1v2.t187 sg13_lv_nmos ad=63.19999f pd=0.74u as=63.19999f ps=0.74u w=0.26u l=0.5u
X29 vdd_1v2 vdd_1v2 vdd_1v2 vdd_1v2 sg13_lv_pmos ad=1.0608p pd=6.92u as=0 ps=0 w=3.12u l=0.5u
X30 wind_comp_0.comparator_0.dynamic_pcell$7_0.DRN_NET_BE_GATE_AB vss_1v2.t88 vss_1v2.t83 vss_1v2.t76 sg13_lv_nmos ad=63.19999f pd=0.74u as=63.19999f ps=0.74u w=0.26u l=0.5u
X31 vss_1v2.t240 wind_comp_0.comparator_1.sg13cmos5l_inv_16_0.A wind_comp_0.sg13g2_and2_2$1_0.B vss_1v2.t253 sg13_lv_nmos ad=0.1406p pd=1.12u as=0.1406p ps=1.12u w=0.74u l=0.13u
X32 vss_1v2.t140 vss_1v2.t139 wind_comp_0.comparator_0.nmos$2_0.Drain vss_1v2.t12 sg13_lv_nmos ad=0.95p pd=5.38u as=0.95p ps=5.38u w=5u l=0.5u
X33 vdd_1v2 vdd_1v2 vdd_1v2 vdd_1v2 sg13_lv_pmos ad=95f pd=0.88u as=0 ps=0 w=0.5u l=0.5u
X34 vdd_1v2 wind_comp_0.sg13g2_and2_2$1_0.B a_51539_28086# vdd_1v2 sg13_lv_pmos ad=0.1918p pd=1.5u as=0.1596p ps=1.22u w=0.84u l=0.13u
X35 vdd_1v2 wind_comp_0.comparator_0.dynamic_pcell$7_0.DRN_NET_BE_GATE_AB wind_comp_0.comparator_0.dynamic_pcell$7_0.DRN_NET_BE_GATE_AB vdd_1v2 sg13_lv_pmos ad=66.49999f pd=0.73u as=0.119p ps=1.38u w=0.35u l=1u
X36 vss_1v2.t336 wind_comp_0.comparator_1.dynamic_pcell$7_0.D_DRN wind_comp_0.comparator_1.dynamic_pcell$7_0.D_DRN vss_1v2.t335 sg13_lv_nmos ad=63.19999f pd=0.74u as=63.19999f ps=0.74u w=0.26u l=10u
X37 vss_1v2.t263 wind_comp_0.comparator_0.sg13cmos5l_inv_16_0.A wind_comp_0.comparator_0.vout_comp vss_1v2.t376 sg13_lv_nmos ad=0.1406p pd=1.12u as=0.1406p ps=1.12u w=0.74u l=0.13u
X38 vdd_1v2 enable.t13 wind_comp_0.comparator_0.dynamic_pcell$2_0.DRN_NET_LM_GATE_KL vdd_1v2 sg13_lv_pmos ad=55.5f pd=0.74u as=0.1005p ps=1.34u w=0.15u l=0.13u
X39 wind_comp_0.comparator_0.dynamic_pcell_0.DRN_NET_GJ_GATE_GH wind_comp_0.comparator_0.nmos_0.Gate vss_1v2.t271 vss_1v2.t270 sg13_lv_nmos ad=0.1005p pd=1.34u as=55.5f ps=0.74u w=0.15u l=0.13u
X40 vdd_1v2 vdd_1v2 vdd_1v2 vdd_1v2 sg13_lv_pmos ad=95f pd=0.88u as=0 ps=0 w=0.5u l=0.5u
X41 vss_1v2.t263 wind_comp_0.comparator_0.sg13cmos5l_inv_16_0.A wind_comp_0.comparator_0.vout_comp vss_1v2.t372 sg13_lv_nmos ad=0.1406p pd=1.12u as=0.1406p ps=1.12u w=0.74u l=0.13u
X42 vss_1v2.t107 vss_1v2.t115 vss_1v2.t107 vss_1v2.t106 sg13_lv_nmos ad=0.1005p pd=1.34u as=0 ps=0 w=0.15u l=0.5u
X43 wind_comp_0.comparator_1.dynamic_pcell$7_0.A_DRN vdd_1v2 vdd_1v2 vdd_1v2 sg13_lv_pmos ad=66.49999f pd=0.73u as=66.49999f ps=0.73u w=0.35u l=0.5u
X44 wind_comp_0.comparator_1.sg13cmos5l_inv_16_0.A wind_comp_0.comparator_1.sg13cmos5l_inv_16_1.A vdd_1v2 vdd_1v2 sg13_lv_pmos ad=0.2128p pd=1.5u as=0.2128p ps=1.5u w=1.12u l=0.13u
X45 vss_1v2.t279 wind_comp_0.comparator_0.dynamic_pcell$7_0.D_DRN wind_comp_0.comparator_0.dynamic_pcell$7_0.D_DRN vss_1v2.t276 sg13_lv_nmos ad=63.19999f pd=0.74u as=63.19999f ps=0.74u w=0.26u l=10u
X46 vdd_1v2 vdd_1v2 vdd_1v2 vdd_1v2 sg13_lv_pmos ad=0.5928p pd=3.5u as=0 ps=0 w=3.12u l=0.5u
X47 vdd_1v2 vdd_1v2 vdd_1v2 vdd_1v2 sg13_lv_pmos ad=0.5928p pd=3.5u as=0 ps=0 w=3.12u l=0.5u
X48 wind_comp_0.comparator_1.sg13cmos5l_inv_16_0.A wind_comp_0.comparator_1.sg13cmos5l_inv_16_1.A vdd_1v2 vdd_1v2 sg13_lv_pmos ad=0.2128p pd=1.5u as=0.2128p ps=1.5u w=1.12u l=0.13u
X49 vss_1v2.t355 wind_comp_0.comparator_1.nmos$2_0.Drain wind_comp_0.comparator_1.nmos$2_0.Drain vss_1v2.t348 sg13_lv_nmos ad=0.95p pd=5.38u as=0.95p ps=5.38u w=5u l=3u
X50 wind_comp_0.comparator_0.sg13cmos5l_inv_16_0.A wind_comp_0.comparator_0.sg13cmos5l_inv_16_1.A vss_1v2.t285 vss_1v2.t284 sg13_lv_nmos ad=0.1406p pd=1.12u as=0.2516p ps=2.16u w=0.74u l=0.13u
X51 wind_comp_0.comparator_0.nmos$2_0.Drain enable.t1 ibias0 vss_1v2.t265 sg13_lv_nmos ad=55.5f pd=0.74u as=55.5f ps=0.74u w=0.15u l=0.13u
X52 wind_comp_0.comparator_0.sg13cmos5l_inv_16_0.A wind_comp_0.comparator_0.sg13cmos5l_inv_16_1.A vdd_1v2 vdd_1v2 sg13_lv_pmos ad=0.2128p pd=1.5u as=0.2128p ps=1.5u w=1.12u l=0.13u
X53 vdd_1v2 wind_comp_0.comparator_1.dynamic_pcell$2_0.DRN_NET_LM_GATE_KL wind_comp_0.comparator_1.dynamic_pcell_0.SRC_NET_IJ vdd_1v2 sg13_lv_pmos ad=95f pd=0.88u as=95f ps=0.88u w=0.5u l=3u
X54 vdd_1v2 vdd_1v2 vdd_1v2 vdd_1v2 sg13_lv_pmos ad=0.119p pd=1.38u as=0 ps=0 w=0.35u l=0.5u
X55 vdd_1v2 vdd_1v2 vdd_1v2 vdd_1v2 sg13_lv_pmos ad=95f pd=0.88u as=0 ps=0 w=0.5u l=0.5u
X56 wind_comp_0.sg13g2_and2_2$1_0.B wind_comp_0.comparator_1.sg13cmos5l_inv_16_0.A vdd_1v2 vdd_1v2 sg13_lv_pmos ad=0.2128p pd=1.5u as=0.2128p ps=1.5u w=1.12u l=0.13u
X57 vss_1v2.t213 vss_1v2.t212 vss_1v2.t213 vss_1v2.t192 sg13_lv_nmos ad=63.19999f pd=0.74u as=0 ps=0 w=0.26u l=0.5u
X58 vss_1v2.t35 wind_comp_0.comparator_0.nmos$2_0.Drain wind_comp_0.comparator_0.dynamic_pcell$7_0.SRC_NET_EF vss_1v2.t325 sg13_lv_nmos ad=0.95p pd=5.38u as=0.95p ps=5.38u w=5u l=3u
X59 wind_comp_0.sg13g2_and2_2$1_0.B wind_comp_0.comparator_1.sg13cmos5l_inv_16_0.A vdd_1v2 vdd_1v2 sg13_lv_pmos ad=0.2128p pd=1.5u as=0.2128p ps=1.5u w=1.12u l=0.13u
X60 vss_1v2.t112 vss_1v2.t113 vss_1v2.t112 vss_1v2.t114 sg13_lv_nmos ad=55.5f pd=0.74u as=0 ps=0 w=0.15u l=0.5u
X61 wind_comp_0.comparator_0.dynamic_pcell$7_0.DRN_NET_BE_GATE_AB enable.t11 vdd_1v2 vdd_1v2 sg13_lv_pmos ad=0.1005p pd=1.34u as=0.1005p ps=1.34u w=0.15u l=0.13u
X62 vss_1v2.t231 vss_1v2.t234 vss_1v2.t235 vss_1v2.t25 sg13_lv_nmos ad=0.95p pd=5.38u as=0 ps=0 w=5u l=0.5u
X63 wind_comp_0.comparator_0.vout_comp wind_comp_0.comparator_0.sg13cmos5l_inv_16_0.A vdd_1v2 vdd_1v2 sg13_lv_pmos ad=0.2128p pd=1.5u as=0.2128p ps=1.5u w=1.12u l=0.13u
X64 wind_comp_0.comparator_1.dynamic_pcell$7_0.DRN_NET_BE_GATE_AB vss_1v2.t95 vss_1v2.t10 vss_1v2.t96 sg13_lv_nmos ad=63.19999f pd=0.74u as=63.19999f ps=0.74u w=0.26u l=0.5u
X65 vdd_1v2 wind_comp_0.comparator_1.sg13cmos5l_inv_16_1.A wind_comp_0.comparator_1.sg13cmos5l_inv_16_0.A vdd_1v2 sg13_lv_pmos ad=0.2128p pd=1.5u as=0.2128p ps=1.5u w=1.12u l=0.13u
X66 wind_comp_0.comparator_0.vout_comp wind_comp_0.comparator_0.sg13cmos5l_inv_16_0.A vdd_1v2 vdd_1v2 sg13_lv_pmos ad=0.2128p pd=1.5u as=0.2128p ps=1.5u w=1.12u l=0.13u
X67 vss_1v2.t173 vss_1v2.t172 wind_comp_0.comparator_0.dynamic_pcell$7_0.D_DRN vss_1v2.t151 sg13_lv_nmos ad=63.19999f pd=0.74u as=63.19999f ps=0.74u w=0.26u l=0.5u
X68 vss_1v2.t136 vss_1v2.t134 vss_1v2.t135 vss_1v2.t1 sg13_lv_nmos ad=1.7p pd=10.68u as=0 ps=0 w=5u l=0.5u
X69 wind_comp_0.comparator_0.dynamic_pcell_0.DRN_NET_GJ_GATE_GH vss_1v2.t61 vss_1v2.t53 vss_1v2.t62 sg13_lv_nmos ad=55.5f pd=0.74u as=55.5f ps=0.74u w=0.15u l=0.5u
X70 vss_1v2.t319 wind_comp_0.comparator_0.dynamic_pcell_0.DRN_NET_GJ_GATE_GH wind_comp_0.comparator_0.sg13cmos5l_inv_16_1.A vss_1v2.t318 sg13_lv_nmos ad=55.5f pd=0.74u as=55.5f ps=0.74u w=0.15u l=3u
X71 vdd_1v2 wind_comp_0.comparator_0.sg13cmos5l_inv_16_1.A wind_comp_0.comparator_0.sg13cmos5l_inv_16_0.A vdd_1v2 sg13_lv_pmos ad=0.2128p pd=1.5u as=0.2128p ps=1.5u w=1.12u l=0.13u
X72 wind_comp_0.comparator_0.dynamic_pcell$7_0.D_DRN vss_1v2.t170 vss_1v2.t165 vss_1v2.t149 sg13_lv_nmos ad=63.19999f pd=0.74u as=63.19999f ps=0.74u w=0.26u l=0.5u
X73 vss_1v2.t240 wind_comp_0.comparator_1.sg13cmos5l_inv_16_0.A wind_comp_0.sg13g2_and2_2$1_0.B vss_1v2.t249 sg13_lv_nmos ad=0.1406p pd=1.12u as=0.1406p ps=1.12u w=0.74u l=0.13u
X74 wind_comp_0.comparator_0.sg13cmos5l_inv_16_0.A wind_comp_0.comparator_0.sg13cmos5l_inv_16_1.A vss_1v2.t285 vss_1v2.t299 sg13_lv_nmos ad=0.1406p pd=1.12u as=0.1406p ps=1.12u w=0.74u l=0.13u
X75 vss_1v2.t102 vss_1v2.t103 vss_1v2.t102 vss_1v2.t91 sg13_lv_nmos ad=63.19999f pd=0.74u as=0 ps=0 w=0.26u l=0.5u
X76 vdd_1v2 wind_comp_0.comparator_0.sg13cmos5l_inv_16_1.A wind_comp_0.comparator_0.sg13cmos5l_inv_16_0.A vdd_1v2 sg13_lv_pmos ad=0.2128p pd=1.5u as=0.2128p ps=1.5u w=1.12u l=0.13u
X77 vss_1v2.t35 vss_1v2.t33 vss_1v2.t34 vss_1v2.t12 sg13_lv_nmos ad=0.95p pd=5.38u as=0 ps=0 w=5u l=0.5u
X78 vss_1v2.t240 wind_comp_0.comparator_1.sg13cmos5l_inv_16_0.A wind_comp_0.sg13g2_and2_2$1_0.B vss_1v2.t245 sg13_lv_nmos ad=0.1406p pd=1.12u as=0.1406p ps=1.12u w=0.74u l=0.13u
X79 vss_1v2.t229 vss_1v2.t227 vss_1v2.t228 vss_1v2.t5 sg13_lv_nmos ad=1.7p pd=10.68u as=0 ps=0 w=5u l=0.5u
X80 wind_comp_0.comparator_0.dynamic_pcell$7_0.SRC_NET_EF analog_bus2 wind_comp_0.comparator_0.dynamic_pcell$7_0.DRN_NET_CF_GATE_CD vss_1v2.t283 sg13_lv_nmos ad=63.19999f pd=0.74u as=63.19999f ps=0.74u w=0.26u l=3u
X81 vss_1v2.t220 vss_1v2.t218 vss_1v2.t204 vss_1v2.t23 sg13_lv_nmos ad=0.95p pd=5.38u as=0 ps=0 w=5u l=0.5u
X82 wind_comp_0.comparator_1.sg13cmos5l_inv_16_0.A wind_comp_0.comparator_1.sg13cmos5l_inv_16_1.A vss_1v2.t309 vss_1v2.t314 sg13_lv_nmos ad=0.1406p pd=1.12u as=0.1406p ps=1.12u w=0.74u l=0.13u
X83 wind_comp_0.comparator_1.sg13cmos5l_inv_16_0.A wind_comp_0.comparator_1.sg13cmos5l_inv_16_1.A vss_1v2.t240 vss_1v2.t301 sg13_lv_nmos ad=0.1406p pd=1.12u as=0.2516p ps=2.16u w=0.74u l=0.13u
X84 vss_1v2.t263 wind_comp_0.comparator_0.sg13cmos5l_inv_16_0.A wind_comp_0.comparator_0.vout_comp vss_1v2.t368 sg13_lv_nmos ad=0.1406p pd=1.12u as=0.1406p ps=1.12u w=0.74u l=0.13u
X85 vdd_1v2 wind_comp_0.comparator_1.dynamic_pcell$7_0.DRN_NET_CF_GATE_CD wind_comp_0.comparator_1.dynamic_pcell$7_0.D_DRN vdd_1v2 sg13_lv_pmos ad=66.49999f pd=0.73u as=66.49999f ps=0.73u w=0.35u l=1u
X86 vss_1v2.t363 wind_comp_0.comparator_0.sg13cmos5l_inv_16_0.A wind_comp_0.comparator_0.vout_comp vss_1v2.t364 sg13_lv_nmos ad=0.1406p pd=1.12u as=0.1406p ps=1.12u w=0.74u l=0.13u
X87 wind_comp_0.comparator_1.dynamic_pcell$2_0.DRN_NET_LM_GATE_KL vss_1v2.t22 vss_1v2.t7 vss_1v2.t23 sg13_lv_nmos ad=0.95p pd=5.38u as=0.95p ps=5.38u w=5u l=0.5u
X88 ibias0 enable.t0 wind_comp_0.comparator_1.nmos$2_0.Drain vss_1v2.t268 sg13_lv_nmos ad=55.5f pd=0.74u as=55.5f ps=0.74u w=0.15u l=0.13u
X89 wind_comp_0.comparator_1.sg13cmos5l_inv_16_1.A vdd_1v2 vdd_1v2 vdd_1v2 sg13_lv_pmos ad=0.5928p pd=3.5u as=0.5928p ps=3.5u w=3.12u l=0.5u
X90 vdd_1v2 vdd_1v2 vdd_1v2 vdd_1v2 sg13_lv_pmos ad=95f pd=0.88u as=0 ps=0 w=0.5u l=0.5u
X91 wind_comp_0.comparator_1.dynamic_pcell_0.DRN_NET_GJ_GATE_GH vdd_1v2 vdd_1v2 vdd_1v2 sg13_lv_pmos ad=0.5928p pd=3.5u as=0.5928p ps=3.5u w=3.12u l=0.5u
X92 wind_comp_0.comparator_0.sg13cmos5l_inv_16_0.A wind_comp_0.comparator_0.sg13cmos5l_inv_16_1.A vss_1v2.t285 vss_1v2.t293 sg13_lv_nmos ad=0.1406p pd=1.12u as=0.1406p ps=1.12u w=0.74u l=0.13u
X93 wind_comp_0.comparator_1.dynamic_pcell_0.SRC_NET_IJ vdd_1v2 vdd_1v2 vdd_1v2 sg13_lv_pmos ad=95f pd=0.88u as=95f ps=0.88u w=0.5u l=0.5u
X94 wind_comp_0.comparator_1.dynamic_pcell$7_0.SRC_NET_EF wind_comp_0.comparator_1.nmos$2_0.Drain vss_1v2.t127 vss_1v2.t348 sg13_lv_nmos ad=0.95p pd=5.38u as=0.95p ps=5.38u w=5u l=3u
X95 wind_comp_0.comparator_0.dynamic_pcell$7_0.A_DRN wind_comp_0.comparator_0.dynamic_pcell$7_0.D_DRN vss_1v2.t277 vss_1v2.t278 sg13_lv_nmos ad=63.19999f pd=0.74u as=63.19999f ps=0.74u w=0.26u l=10u
X96 vss_1v2.t285 wind_comp_0.comparator_0.sg13cmos5l_inv_16_1.A wind_comp_0.comparator_0.sg13cmos5l_inv_16_0.A vss_1v2.t300 sg13_lv_nmos ad=0.2516p pd=2.16u as=0.1406p ps=1.12u w=0.74u l=0.13u
X97 vss_1v2.t223 vss_1v2.t221 vss_1v2.t222 vss_1v2.t29 sg13_lv_nmos ad=0.95p pd=5.38u as=0 ps=0 w=5u l=0.5u
X98 vss_1v2.t10 vss_1v2.t8 vss_1v2.t10 vss_1v2.t9 sg13_lv_nmos ad=0.1082p pd=1.34u as=0 ps=0 w=0.26u l=0.5u
X99 vss_1v2.t285 wind_comp_0.comparator_0.sg13cmos5l_inv_16_1.A wind_comp_0.comparator_0.sg13cmos5l_inv_16_0.A vss_1v2.t296 sg13_lv_nmos ad=0.1406p pd=1.12u as=0.1406p ps=1.12u w=0.74u l=0.13u
X100 wind_comp_0.comparator_0.dynamic_pcell$7_0.A_DRN vdd_1v2 vdd_1v2 vdd_1v2 sg13_lv_pmos ad=66.49999f pd=0.73u as=66.49999f ps=0.73u w=0.35u l=0.5u
X101 wind_comp_0.sg13g2_and2_2$1_0.B wind_comp_0.comparator_1.sg13cmos5l_inv_16_0.A vss_1v2.t240 vss_1v2.t242 sg13_lv_nmos ad=0.1406p pd=1.12u as=0.1406p ps=1.12u w=0.74u l=0.13u
X102 vss_1v2.t209 vss_1v2.t208 wind_comp_0.comparator_1.dynamic_pcell$7_0.D_DRN vss_1v2.t189 sg13_lv_nmos ad=63.19999f pd=0.74u as=63.19999f ps=0.74u w=0.26u l=0.5u
X103 vss_1v2.t44 vss_1v2.t42 vss_1v2.t40 vss_1v2.t15 sg13_lv_nmos ad=0.95p pd=5.38u as=0 ps=0 w=5u l=0.5u
X104 vss_1v2.t152 vss_1v2.t153 vss_1v2.t152 vss_1v2.t154 sg13_lv_nmos ad=63.19999f pd=0.74u as=0 ps=0 w=0.26u l=0.5u
X105 vss_1v2.t60 vss_1v2.t58 wind_comp_0.comparator_0.sg13cmos5l_inv_16_1.A vss_1v2.t59 sg13_lv_nmos ad=55.5f pd=0.74u as=55.5f ps=0.74u w=0.15u l=0.5u
X106 vss_1v2.t26 vss_1v2.t28 wind_comp_0.comparator_1.nmos$2_0.Drain vss_1v2.t29 sg13_lv_nmos ad=0.95p pd=5.38u as=0.95p ps=5.38u w=5u l=0.5u
X107 wind_comp_0.sg13g2_and2_2$1_0.B wind_comp_0.comparator_1.sg13cmos5l_inv_16_0.A vdd_1v2 vdd_1v2 sg13_lv_pmos ad=0.2128p pd=1.5u as=0.2128p ps=1.5u w=1.12u l=0.13u
X108 wind_comp_0.comparator_0.dynamic_pcell_0.DRN_NET_GJ_GATE_GH wind_comp_0.comparator_0.dynamic_pcell_0.DRN_NET_GJ_GATE_GH vss_1v2.t319 vss_1v2.t299 sg13_lv_nmos ad=55.5f pd=0.74u as=55.5f ps=0.74u w=0.15u l=3u
X109 wind_comp_0.comparator_0.dynamic_pcell$7_0.D_DRN wind_comp_0.comparator_0.dynamic_pcell$7_0.D_DRN vss_1v2.t280 vss_1v2.t278 sg13_lv_nmos ad=63.19999f pd=0.74u as=63.19999f ps=0.74u w=0.26u l=10u
X110 vdd_1v2 wind_comp_0.comparator_1.dynamic_pcell$7_0.DRN_NET_CF_GATE_CD wind_comp_0.comparator_1.dynamic_pcell$7_0.DRN_NET_CF_GATE_CD vdd_1v2 sg13_lv_pmos ad=66.49999f pd=0.73u as=0.119p ps=1.38u w=0.35u l=1u
X111 wind_comp_0.comparator_1.dynamic_pcell$7_0.A_DRN vss_1v2.t214 vss_1v2.t202 vss_1v2.t187 sg13_lv_nmos ad=63.19999f pd=0.74u as=63.19999f ps=0.74u w=0.26u l=0.5u
X112 vdd_1v2 vdd_1v2 wind_comp_0.comparator_1.dynamic_pcell$2_0.DRN_NET_LM_GATE_KL vdd_1v2 sg13_lv_pmos ad=95f pd=0.88u as=95f ps=0.88u w=0.5u l=0.5u
X113 vss_1v2.t133 vss_1v2.t131 vss_1v2.t130 vss_1v2.t25 sg13_lv_nmos ad=0.95p pd=5.38u as=0 ps=0 w=5u l=0.5u
X114 vdd_1v2 wind_comp_0.comparator_1.sg13cmos5l_inv_16_1.A wind_comp_0.comparator_1.sg13cmos5l_inv_16_0.A vdd_1v2 sg13_lv_pmos ad=0.2128p pd=1.5u as=0.2128p ps=1.5u w=1.12u l=0.13u
X115 vdd_1v2 wind_comp_0.comparator_1.sg13cmos5l_inv_16_1.A wind_comp_0.comparator_1.sg13cmos5l_inv_16_0.A vdd_1v2 sg13_lv_pmos ad=0.2128p pd=1.5u as=0.2128p ps=1.5u w=1.12u l=0.13u
X116 wind_comp_0.comparator_1.dynamic_pcell$7_0.DRN_NET_CF_GATE_CD wind_comp_0.comparator_1.dynamic_pcell$7_0.DRN_NET_CF_GATE_CD vdd_1v2 vdd_1v2 sg13_lv_pmos ad=0.119p pd=1.38u as=66.49999f ps=0.73u w=0.35u l=1u
X117 wind_comp_0.comparator_0.vout_comp wind_comp_0.comparator_0.sg13cmos5l_inv_16_0.A vdd_1v2 vdd_1v2 sg13_lv_pmos ad=0.2128p pd=1.5u as=0.2128p ps=1.5u w=1.12u l=0.13u
X118 wind_comp_0.comparator_0.nmos$2_0.Drain vss_1v2.t14 vss_1v2.t2 vss_1v2.t15 sg13_lv_nmos ad=0.95p pd=5.38u as=0.95p ps=5.38u w=5u l=0.5u
X119 wind_comp_0.comparator_0.dynamic_pcell$7_0.DRN_NET_BE_GATE_AB s4_an[0] wind_comp_0.comparator_0.dynamic_pcell$7_0.SRC_NET_EF vss_1v2.t282 sg13_lv_nmos ad=63.19999f pd=0.74u as=63.19999f ps=0.74u w=0.26u l=3u
X120 wind_comp_0.comparator_0.vout_comp wind_comp_0.comparator_0.sg13cmos5l_inv_16_0.A vdd_1v2 vdd_1v2 sg13_lv_pmos ad=0.2128p pd=1.5u as=0.2128p ps=1.5u w=1.12u l=0.13u
X121 wind_comp_0.comparator_0.dynamic_pcell$2_0.DRN_NET_LM_GATE_KL vdd_1v2 vdd_1v2 vdd_1v2 sg13_lv_pmos ad=95f pd=0.88u as=95f ps=0.88u w=0.5u l=0.5u
X122 vss_1v2.t32 vss_1v2.t30 vss_1v2.t20 vss_1v2.t1 sg13_lv_nmos ad=1.7p pd=10.68u as=0 ps=0 w=5u l=0.5u
X123 wind_comp_0.comparator_0.dynamic_pcell$7_0.DRN_NET_CF_GATE_CD enable.t12 vdd_1v2 vdd_1v2 sg13_lv_pmos ad=0.1005p pd=1.34u as=55.5f ps=0.74u w=0.15u l=0.13u
X124 vss_1v2.t161 vss_1v2.t162 vss_1v2.t161 vss_1v2.t154 sg13_lv_nmos ad=63.19999f pd=0.74u as=0 ps=0 w=0.26u l=0.5u
X125 wind_comp_0.comparator_0.dynamic_pcell_0.SRC_NET_IJ wind_comp_0.comparator_0.dynamic_pcell$7_0.D_DRN wind_comp_0.comparator_0.dynamic_pcell_0.DRN_NET_GJ_GATE_GH vdd_1v2 sg13_lv_pmos ad=0.5928p pd=3.5u as=0.5928p ps=3.5u w=3.12u l=1u
X126 wind_comp_0.comparator_1.dynamic_pcell$7_0.D_DRN wind_comp_0.comparator_1.dynamic_pcell$7_0.D_DRN vss_1v2.t337 vss_1v2.t304 sg13_lv_nmos ad=63.19999f pd=0.74u as=63.19999f ps=0.74u w=0.26u l=10u
X127 wind_comp_0.comparator_0.dynamic_pcell_0.SRC_NET_IJ wind_comp_0.comparator_0.dynamic_pcell$7_0.A_DRN wind_comp_0.comparator_0.sg13cmos5l_inv_16_1.A vdd_1v2 sg13_lv_pmos ad=0.5928p pd=3.5u as=0.5928p ps=3.5u w=3.12u l=1u
X128 vss_1v2.t357 wind_comp_0.comparator_1.dynamic_pcell_0.DRN_NET_GJ_GATE_GH wind_comp_0.comparator_1.sg13cmos5l_inv_16_1.A vss_1v2.t302 sg13_lv_nmos ad=55.5f pd=0.74u as=55.5f ps=0.74u w=0.15u l=3u
X129 wind_comp_0.comparator_1.dynamic_pcell$7_0.A_DRN wind_comp_0.comparator_1.dynamic_pcell$7_0.DRN_NET_BE_GATE_AB vdd_1v2 vdd_1v2 sg13_lv_pmos ad=66.49999f pd=0.73u as=66.49999f ps=0.73u w=0.35u l=1u
X130 vdd_1v2 wind_comp_0.comparator_0.sg13cmos5l_inv_16_1.A wind_comp_0.comparator_0.sg13cmos5l_inv_16_0.A vdd_1v2 sg13_lv_pmos ad=0.2128p pd=1.5u as=0.2128p ps=1.5u w=1.12u l=0.13u
X131 vss_1v2.t222 wind_comp_0.comparator_1.nmos$2_0.Drain wind_comp_0.comparator_1.dynamic_pcell$7_0.SRC_NET_EF vss_1v2.t351 sg13_lv_nmos ad=0.95p pd=5.38u as=0.95p ps=5.38u w=5u l=3u
X132 vss_1v2.t279 wind_comp_0.comparator_0.dynamic_pcell$7_0.D_DRN wind_comp_0.comparator_0.dynamic_pcell$7_0.A_DRN vss_1v2.t276 sg13_lv_nmos ad=63.19999f pd=0.74u as=63.19999f ps=0.74u w=0.26u l=10u
X133 vss_1v2.t125 vss_1v2.t123 vss_1v2.t124 vss_1v2.t5 sg13_lv_nmos ad=1.7p pd=10.68u as=0 ps=0 w=5u l=0.5u
X134 wind_comp_0.comparator_1.sg13cmos5l_inv_16_0.A wind_comp_0.comparator_1.sg13cmos5l_inv_16_1.A vss_1v2.t309 vss_1v2.t310 sg13_lv_nmos ad=0.1406p pd=1.12u as=0.1406p ps=1.12u w=0.74u l=0.13u
X135 vdd_1v2 wind_comp_0.comparator_1.sg13cmos5l_inv_16_0.A wind_comp_0.sg13g2_and2_2$1_0.B vdd_1v2 sg13_lv_pmos ad=0.2128p pd=1.5u as=0.2128p ps=1.5u w=1.12u l=0.13u
X136 analog_bus1 a_51539_28086# vdd_1v2 vdd_1v2 sg13_lv_pmos ad=0.2128p pd=1.5u as=0.1918p ps=1.5u w=1.12u l=0.13u
X137 vdd_1v2 enable.t10 wind_comp_0.comparator_1.dynamic_pcell$7_0.DRN_NET_BE_GATE_AB vdd_1v2 sg13_lv_pmos ad=0.1005p pd=1.34u as=0.1005p ps=1.34u w=0.15u l=0.13u
X138 vss_1v2.t85 vss_1v2.t86 wind_comp_0.comparator_0.dynamic_pcell$7_0.DRN_NET_CF_GATE_CD vss_1v2.t78 sg13_lv_nmos ad=63.19999f pd=0.74u as=63.19999f ps=0.74u w=0.26u l=0.5u
X139 wind_comp_0.comparator_0.sg13cmos5l_inv_16_0.A wind_comp_0.comparator_0.sg13cmos5l_inv_16_1.A vdd_1v2 vdd_1v2 sg13_lv_pmos ad=0.2128p pd=1.5u as=0.2128p ps=1.5u w=1.12u l=0.13u
X140 vdd_1v2 vdd_1v2 vdd_1v2 vdd_1v2 sg13_lv_pmos ad=66.49999f pd=0.73u as=0 ps=0 w=0.35u l=0.5u
X141 wind_comp_0.comparator_1.nmos$2_0.Drain wind_comp_0.comparator_1.nmos$2_0.Drain vss_1v2.t349 vss_1v2.t351 sg13_lv_nmos ad=0.95p pd=5.38u as=0.95p ps=5.38u w=5u l=3u
X142 wind_comp_0.comparator_1.sg13cmos5l_inv_16_0.A wind_comp_0.comparator_1.sg13cmos5l_inv_16_1.A vss_1v2.t240 vss_1v2.t305 sg13_lv_nmos ad=0.1406p pd=1.12u as=0.1406p ps=1.12u w=0.74u l=0.13u
X143 wind_comp_0.comparator_0.dynamic_pcell$2_0.DRN_NET_LM_GATE_KL wind_comp_0.comparator_0.dynamic_pcell$2_0.DRN_NET_LM_GATE_KL vdd_1v2 vdd_1v2 sg13_lv_pmos ad=95f pd=0.88u as=95f ps=0.88u w=0.5u l=3u
X144 vdd_1v2 wind_comp_0.comparator_1.sg13cmos5l_inv_16_0.A wind_comp_0.sg13g2_and2_2$1_0.B vdd_1v2 sg13_lv_pmos ad=0.2128p pd=1.5u as=0.2128p ps=1.5u w=1.12u l=0.13u
X145 ibias0 enable.t1 wind_comp_0.comparator_0.nmos$2_0.Drain vss_1v2.t266 sg13_lv_nmos ad=0.1005p pd=1.34u as=55.5f ps=0.74u w=0.15u l=0.13u
X146 wind_comp_0.comparator_1.dynamic_pcell$7_0.SRC_NET_EF s4_an[0] wind_comp_0.comparator_1.dynamic_pcell$7_0.DRN_NET_CF_GATE_CD vss_1v2.t274 sg13_lv_nmos ad=63.19999f pd=0.74u as=63.19999f ps=0.74u w=0.26u l=3u
X147 wind_comp_0.comparator_1.dynamic_pcell$2_0.DRN_NET_LM_GATE_KL wind_comp_0.comparator_1.dynamic_pcell$2_0.DRN_NET_LM_GATE_KL vdd_1v2 vdd_1v2 sg13_lv_pmos ad=95f pd=0.88u as=95f ps=0.88u w=0.5u l=3u
X148 vdd_1v2 vdd_1v2 wind_comp_0.comparator_1.dynamic_pcell$7_0.D_DRN vdd_1v2 sg13_lv_pmos ad=66.49999f pd=0.73u as=66.49999f ps=0.73u w=0.35u l=0.5u
X149 vdd_1v2 vdd_1v2 wind_comp_0.comparator_1.sg13cmos5l_inv_16_1.A vdd_1v2 sg13_lv_pmos ad=0.5928p pd=3.5u as=0.5928p ps=3.5u w=3.12u l=0.5u
X150 vdd_1v2 vdd_1v2 wind_comp_0.comparator_1.dynamic_pcell_0.DRN_NET_GJ_GATE_GH vdd_1v2 sg13_lv_pmos ad=0.5928p pd=3.5u as=0.5928p ps=3.5u w=3.12u l=0.5u
X151 wind_comp_0.comparator_0.sg13cmos5l_inv_16_0.A wind_comp_0.comparator_0.sg13cmos5l_inv_16_1.A vss_1v2.t285 vss_1v2.t289 sg13_lv_nmos ad=0.1406p pd=1.12u as=0.1406p ps=1.12u w=0.74u l=0.13u
X152 vdd_1v2 wind_comp_0.comparator_0.sg13cmos5l_inv_16_0.A wind_comp_0.comparator_0.vout_comp vdd_1v2 sg13_lv_pmos ad=0.2128p pd=1.5u as=0.2128p ps=1.5u w=1.12u l=0.13u
X153 vss_1v2.t190 vss_1v2.t191 vss_1v2.t190 vss_1v2.t192 sg13_lv_nmos ad=63.19999f pd=0.74u as=0 ps=0 w=0.26u l=0.5u
X154 wind_comp_0.sg13g2_and2_2$1_0.B wind_comp_0.comparator_1.sg13cmos5l_inv_16_0.A vss_1v2.t240 vss_1v2.t254 sg13_lv_nmos ad=0.1406p pd=1.12u as=0.1406p ps=1.12u w=0.74u l=0.13u
X155 vss_1v2.t79 vss_1v2.t80 vss_1v2.t79 vss_1v2.t81 sg13_lv_nmos ad=63.19999f pd=0.74u as=0 ps=0 w=0.26u l=0.5u
X156 wind_comp_0.sg13g2_and2_2$1_0.B wind_comp_0.comparator_1.sg13cmos5l_inv_16_0.A vss_1v2.t240 vss_1v2.t250 sg13_lv_nmos ad=0.1406p pd=1.12u as=0.1406p ps=1.12u w=0.74u l=0.13u
X157 vdd_1v2 vdd_1v2 wind_comp_0.comparator_0.dynamic_pcell$2_0.DRN_NET_LM_GATE_KL vdd_1v2 sg13_lv_pmos ad=95f pd=0.88u as=95f ps=0.88u w=0.5u l=0.5u
X158 vdd_1v2 wind_comp_0.comparator_0.dynamic_pcell$7_0.DRN_NET_CF_GATE_CD wind_comp_0.comparator_0.dynamic_pcell$7_0.D_DRN vdd_1v2 sg13_lv_pmos ad=66.49999f pd=0.73u as=66.49999f ps=0.73u w=0.35u l=1u
X159 wind_comp_0.comparator_0.vout_comp wind_comp_0.comparator_0.sg13cmos5l_inv_16_0.A vss_1v2.t263 vss_1v2.t377 sg13_lv_nmos ad=0.1406p pd=1.12u as=0.1406p ps=1.12u w=0.74u l=0.13u
X160 wind_comp_0.comparator_1.dynamic_pcell_0.SRC_NET_IJ wind_comp_0.comparator_1.dynamic_pcell$7_0.A_DRN wind_comp_0.comparator_1.sg13cmos5l_inv_16_1.A vdd_1v2 sg13_lv_pmos ad=0.5928p pd=3.5u as=0.5928p ps=3.5u w=3.12u l=1u
X161 wind_comp_0.comparator_1.dynamic_pcell_0.SRC_NET_IJ wind_comp_0.comparator_1.dynamic_pcell$7_0.D_DRN wind_comp_0.comparator_1.dynamic_pcell_0.DRN_NET_GJ_GATE_GH vdd_1v2 sg13_lv_pmos ad=0.5928p pd=3.5u as=0.5928p ps=3.5u w=3.12u l=1u
X162 vss_1v2.t169 vss_1v2.t167 vss_1v2.t169 vss_1v2.t168 sg13_lv_nmos ad=0.1082p pd=1.34u as=0 ps=0 w=0.26u l=0.5u
X163 vss_1v2.t181 vss_1v2.t180 wind_comp_0.comparator_0.dynamic_pcell$7_0.A_DRN vss_1v2.t151 sg13_lv_nmos ad=63.19999f pd=0.74u as=63.19999f ps=0.74u w=0.26u l=0.5u
X164 vss_1v2.t240 wind_comp_0.comparator_1.sg13cmos5l_inv_16_1.A wind_comp_0.comparator_1.sg13cmos5l_inv_16_0.A vss_1v2.t306 sg13_lv_nmos ad=0.1406p pd=1.12u as=0.1406p ps=1.12u w=0.74u l=0.13u
X165 wind_comp_0.comparator_1.sg13cmos5l_inv_16_1.A vss_1v2.t108 vss_1v2.t107 vss_1v2.t109 sg13_lv_nmos ad=55.5f pd=0.74u as=55.5f ps=0.74u w=0.15u l=0.5u
X166 vss_1v2.t198 vss_1v2.t199 vss_1v2.t198 vss_1v2.t192 sg13_lv_nmos ad=63.19999f pd=0.74u as=0 ps=0 w=0.26u l=0.5u
X167 wind_comp_0.comparator_0.vout_comp wind_comp_0.comparator_0.sg13cmos5l_inv_16_0.A vss_1v2.t263 vss_1v2.t373 sg13_lv_nmos ad=0.1406p pd=1.12u as=0.1406p ps=1.12u w=0.74u l=0.13u
X168 wind_comp_0.comparator_1.dynamic_pcell_0.DRN_NET_GJ_GATE_GH wind_comp_0.comparator_1.dynamic_pcell_0.DRN_NET_GJ_GATE_GH vss_1v2.t357 vss_1v2.t358 sg13_lv_nmos ad=55.5f pd=0.74u as=55.5f ps=0.74u w=0.15u l=3u
X169 vss_1v2.t83 vss_1v2.t82 vss_1v2.t83 vss_1v2.t73 sg13_lv_nmos ad=0.1082p pd=1.34u as=0 ps=0 w=0.26u l=0.5u
X170 vdd_1v2 wind_comp_0.comparator_1.sg13cmos5l_inv_16_1.A wind_comp_0.comparator_1.sg13cmos5l_inv_16_0.A vdd_1v2 sg13_lv_pmos ad=0.2128p pd=1.5u as=0.2128p ps=1.5u w=1.12u l=0.13u
X171 vss_1v2.t50 vss_1v2.t48 vss_1v2.t46 vss_1v2.t17 sg13_lv_nmos ad=0.95p pd=5.38u as=0 ps=0 w=5u l=0.5u
X172 wind_comp_0.comparator_0.dynamic_pcell$7_0.A_DRN vss_1v2.t178 vss_1v2.t177 vss_1v2.t149 sg13_lv_nmos ad=63.19999f pd=0.74u as=63.19999f ps=0.74u w=0.26u l=0.5u
X173 vss_1v2.t285 wind_comp_0.comparator_0.sg13cmos5l_inv_16_1.A wind_comp_0.comparator_0.sg13cmos5l_inv_16_0.A vss_1v2.t290 sg13_lv_nmos ad=0.1406p pd=1.12u as=0.1406p ps=1.12u w=0.74u l=0.13u
X174 vss_1v2.t285 wind_comp_0.comparator_0.sg13cmos5l_inv_16_1.A wind_comp_0.comparator_0.sg13cmos5l_inv_16_0.A vss_1v2.t286 sg13_lv_nmos ad=0.1406p pd=1.12u as=0.1406p ps=1.12u w=0.74u l=0.13u
X175 vdd_1v2 vdd_1v2 vdd_1v2 vdd_1v2 sg13_lv_pmos ad=0.5928p pd=3.5u as=0 ps=0 w=3.12u l=0.5u
X176 vss_1v2.t328 wind_comp_0.comparator_0.nmos$2_0.Drain wind_comp_0.comparator_0.dynamic_pcell$2_0.DRN_NET_LM_GATE_KL vss_1v2.t327 sg13_lv_nmos ad=0.95p pd=5.38u as=0.95p ps=5.38u w=5u l=3u
X177 vdd_1v2 vdd_1v2 vdd_1v2 vdd_1v2 sg13_lv_pmos ad=0.5928p pd=3.5u as=0 ps=0 w=3.12u l=0.5u
X178 vdd_1v2 wind_comp_0.comparator_1.dynamic_pcell$2_0.DRN_NET_LM_GATE_KL wind_comp_0.comparator_1.dynamic_pcell$2_0.DRN_NET_LM_GATE_KL vdd_1v2 sg13_lv_pmos ad=95f pd=0.88u as=95f ps=0.88u w=0.5u l=3u
X179 vdd_1v2 wind_comp_0.comparator_0.dynamic_pcell$2_0.DRN_NET_LM_GATE_KL wind_comp_0.comparator_0.dynamic_pcell_0.SRC_NET_IJ vdd_1v2 sg13_lv_pmos ad=95f pd=0.88u as=95f ps=0.88u w=0.5u l=3u
X180 wind_comp_0.sg13g2_and2_2$1_0.B wind_comp_0.comparator_1.sg13cmos5l_inv_16_0.A vdd_1v2 vdd_1v2 sg13_lv_pmos ad=0.2128p pd=1.5u as=0.3808p ps=2.92u w=1.12u l=0.13u
X181 vss_1v2.t13 vss_1v2.t16 vss_1v2.t18 vss_1v2.t17 sg13_lv_nmos ad=0.95p pd=5.38u as=0 ps=0 w=5u l=0.5u
X182 wind_comp_0.comparator_1.dynamic_pcell$7_0.DRN_NET_BE_GATE_AB analog_bus0 wind_comp_0.comparator_1.dynamic_pcell$7_0.SRC_NET_EF vss_1v2.t275 sg13_lv_nmos ad=63.19999f pd=0.74u as=63.19999f ps=0.74u w=0.26u l=3u
X183 vdd_1v2 vdd_1v2 vdd_1v2 vdd_1v2 sg13_lv_pmos ad=95f pd=0.88u as=0 ps=0 w=0.5u l=0.5u
X184 wind_comp_0.comparator_1.nmos$2_0.Drain enable.t0 ibias0 vss_1v2.t269 sg13_lv_nmos ad=0.1005p pd=1.34u as=55.5f ps=0.74u w=0.15u l=0.13u
X185 vdd_1v2 wind_comp_0.comparator_0.dynamic_pcell$7_0.DRN_NET_CF_GATE_CD wind_comp_0.comparator_0.dynamic_pcell$7_0.DRN_NET_CF_GATE_CD vdd_1v2 sg13_lv_pmos ad=66.49999f pd=0.73u as=0.119p ps=1.38u w=0.35u l=1u
X186 vdd_1v2 wind_comp_0.comparator_1.sg13cmos5l_inv_16_0.A wind_comp_0.sg13g2_and2_2$1_0.B vdd_1v2 sg13_lv_pmos ad=0.4368p pd=3.02u as=0.2128p ps=1.5u w=1.12u l=0.13u
X187 vdd_1v2 wind_comp_0.comparator_1.sg13cmos5l_inv_16_0.A wind_comp_0.sg13g2_and2_2$1_0.B vdd_1v2 sg13_lv_pmos ad=0.2128p pd=1.5u as=0.2128p ps=1.5u w=1.12u l=0.13u
X188 vdd_1v2 vdd_1v2 wind_comp_0.comparator_0.dynamic_pcell$7_0.A_DRN vdd_1v2 sg13_lv_pmos ad=66.49999f pd=0.73u as=66.49999f ps=0.73u w=0.35u l=0.5u
X189 wind_comp_0.comparator_1.dynamic_pcell$7_0.D_DRN vdd_1v2 vdd_1v2 vdd_1v2 sg13_lv_pmos ad=66.49999f pd=0.73u as=66.49999f ps=0.73u w=0.35u l=0.5u
X190 wind_comp_0.comparator_1.sg13cmos5l_inv_16_0.A wind_comp_0.comparator_1.sg13cmos5l_inv_16_1.A vdd_1v2 vdd_1v2 sg13_lv_pmos ad=0.2128p pd=1.5u as=0.2128p ps=1.5u w=1.12u l=0.13u
X191 vdd_1v2 wind_comp_0.comparator_0.sg13cmos5l_inv_16_0.A wind_comp_0.comparator_0.vout_comp vdd_1v2 sg13_lv_pmos ad=0.3808p pd=2.92u as=0.2128p ps=1.5u w=1.12u l=0.13u
X192 wind_comp_0.comparator_1.sg13cmos5l_inv_16_0.A wind_comp_0.comparator_1.sg13cmos5l_inv_16_1.A vdd_1v2 vdd_1v2 sg13_lv_pmos ad=0.2128p pd=1.5u as=0.2128p ps=1.5u w=1.12u l=0.13u
X193 vdd_1v2 vdd_1v2 vdd_1v2 vdd_1v2 sg13_lv_pmos ad=95f pd=0.88u as=0 ps=0 w=0.5u l=0.5u
X194 vdd_1v2 wind_comp_0.comparator_0.sg13cmos5l_inv_16_0.A wind_comp_0.comparator_0.vout_comp vdd_1v2 sg13_lv_pmos ad=0.2128p pd=1.5u as=0.2128p ps=1.5u w=1.12u l=0.13u
X195 vdd_1v2 vdd_1v2 vdd_1v2 vdd_1v2 sg13_lv_pmos ad=95f pd=0.88u as=0 ps=0 w=0.5u l=0.5u
X196 wind_comp_0.comparator_1.sg13cmos5l_inv_16_0.A wind_comp_0.comparator_1.sg13cmos5l_inv_16_1.A vdd_1v2 vdd_1v2 sg13_lv_pmos ad=0.2128p pd=1.5u as=0.2128p ps=1.5u w=1.12u l=0.13u
X197 wind_comp_0.comparator_0.dynamic_pcell$7_0.A_DRN wind_comp_0.comparator_0.dynamic_pcell$7_0.DRN_NET_BE_GATE_AB vdd_1v2 vdd_1v2 sg13_lv_pmos ad=66.49999f pd=0.73u as=66.49999f ps=0.73u w=0.35u l=1u
X198 vss_1v2.t213 vss_1v2.t216 wind_comp_0.comparator_1.dynamic_pcell$7_0.A_DRN vss_1v2.t189 sg13_lv_nmos ad=63.19999f pd=0.74u as=63.19999f ps=0.74u w=0.26u l=0.5u
X199 vdd_1v2 vdd_1v2 vdd_1v2 vdd_1v2 sg13_lv_pmos ad=0.17p pd=1.68u as=0 ps=0 w=0.5u l=0.5u
X200 vss_1v2.t112 vss_1v2.t110 wind_comp_0.comparator_1.dynamic_pcell_0.DRN_NET_GJ_GATE_GH vss_1v2.t111 sg13_lv_nmos ad=55.5f pd=0.74u as=55.5f ps=0.74u w=0.15u l=0.5u
X201 wind_comp_0.comparator_1.dynamic_pcell$7_0.A_DRN vss_1v2.t186 vss_1v2.t185 vss_1v2.t187 sg13_lv_nmos ad=63.19999f pd=0.74u as=63.19999f ps=0.74u w=0.26u l=0.5u
X202 wind_comp_0.comparator_0.sg13cmos5l_inv_16_0.A wind_comp_0.comparator_0.sg13cmos5l_inv_16_1.A vdd_1v2 vdd_1v2 sg13_lv_pmos ad=0.2128p pd=1.5u as=0.2128p ps=1.5u w=1.12u l=0.13u
X203 vss_1v2.t118 vss_1v2.t121 vss_1v2.t118 vss_1v2.t114 sg13_lv_nmos ad=55.5f pd=0.74u as=0 ps=0 w=0.15u l=0.5u
X204 wind_comp_0.comparator_1.nmos$2_0.Drain wind_comp_0.comparator_1.nmos_0.Gate vss_1v2.t237 vss_1v2.t238 sg13_lv_nmos ad=0.1005p pd=1.34u as=55.5f ps=0.74u w=0.15u l=0.13u
X205 wind_comp_0.comparator_0.sg13cmos5l_inv_16_0.A wind_comp_0.comparator_0.sg13cmos5l_inv_16_1.A vdd_1v2 vdd_1v2 sg13_lv_pmos ad=0.2128p pd=1.5u as=0.2128p ps=1.5u w=1.12u l=0.13u
X206 wind_comp_0.sg13g2_and2_2$1_0.B wind_comp_0.comparator_1.sg13cmos5l_inv_16_0.A vss_1v2.t240 vss_1v2.t246 sg13_lv_nmos ad=0.1406p pd=1.12u as=0.1406p ps=1.12u w=0.74u l=0.13u
X207 vdd_1v2 enable.t9 wind_comp_0.comparator_1.dynamic_pcell$7_0.DRN_NET_CF_GATE_CD vdd_1v2 sg13_lv_pmos ad=55.5f pd=0.74u as=0.1005p ps=1.34u w=0.15u l=0.13u
X208 vdd_1v2 vdd_1v2 vdd_1v2 vdd_1v2 sg13_lv_pmos ad=0.119p pd=1.38u as=0 ps=0 w=0.35u l=0.5u
X209 vss_1v2.t54 vss_1v2.t51 vss_1v2.t53 vss_1v2.t52 sg13_lv_nmos ad=0.1005p pd=1.34u as=0 ps=0 w=0.15u l=0.5u
X210 vdd_1v2 vdd_1v2 vdd_1v2 vdd_1v2 sg13_lv_pmos ad=0.17p pd=1.68u as=0 ps=0 w=0.5u l=0.5u
X211 vss_1v2.t309 wind_comp_0.comparator_1.sg13cmos5l_inv_16_1.A wind_comp_0.comparator_1.sg13cmos5l_inv_16_0.A vss_1v2.t315 sg13_lv_nmos ad=0.1406p pd=1.12u as=0.1406p ps=1.12u w=0.74u l=0.13u
X212 vss_1v2.t240 wind_comp_0.comparator_1.sg13cmos5l_inv_16_1.A wind_comp_0.comparator_1.sg13cmos5l_inv_16_0.A vss_1v2.t302 sg13_lv_nmos ad=0.1406p pd=1.12u as=0.1406p ps=1.12u w=0.74u l=0.13u
X213 wind_comp_0.comparator_0.vout_comp wind_comp_0.comparator_0.sg13cmos5l_inv_16_0.A vss_1v2.t263 vss_1v2.t369 sg13_lv_nmos ad=0.1406p pd=1.12u as=0.1406p ps=1.12u w=0.74u l=0.13u
X214 wind_comp_0.sg13g2_and2_2$1_0.B wind_comp_0.comparator_1.sg13cmos5l_inv_16_0.A vdd_1v2 vdd_1v2 sg13_lv_pmos ad=0.2128p pd=1.5u as=0.2128p ps=1.5u w=1.12u l=0.13u
X215 wind_comp_0.comparator_0.sg13cmos5l_inv_16_1.A vss_1v2.t68 vss_1v2.t66 vss_1v2.t62 sg13_lv_nmos ad=55.5f pd=0.74u as=55.5f ps=0.74u w=0.15u l=0.5u
X216 wind_comp_0.comparator_1.dynamic_pcell_0.SRC_NET_IJ wind_comp_0.comparator_1.dynamic_pcell$2_0.DRN_NET_LM_GATE_KL vdd_1v2 vdd_1v2 sg13_lv_pmos ad=95f pd=0.88u as=95f ps=0.88u w=0.5u l=3u
X217 vss_1v2.t166 vss_1v2.t164 vss_1v2.t165 vss_1v2.t145 sg13_lv_nmos ad=0.1082p pd=1.34u as=0 ps=0 w=0.26u l=0.5u
X218 wind_comp_0.comparator_0.vout_comp wind_comp_0.comparator_0.sg13cmos5l_inv_16_0.A vss_1v2.t363 vss_1v2.t365 sg13_lv_nmos ad=0.1406p pd=1.12u as=0.1406p ps=1.12u w=0.74u l=0.13u
X219 wind_comp_0.comparator_1.dynamic_pcell$7_0.D_DRN vss_1v2.t195 vss_1v2.t194 vss_1v2.t187 sg13_lv_nmos ad=63.19999f pd=0.74u as=63.19999f ps=0.74u w=0.26u l=0.5u
X220 vss_1v2.t102 vss_1v2.t101 wind_comp_0.comparator_1.dynamic_pcell$7_0.DRN_NET_BE_GATE_AB vss_1v2.t94 sg13_lv_nmos ad=63.19999f pd=0.74u as=63.19999f ps=0.74u w=0.26u l=0.5u
X221 wind_comp_0.comparator_1.dynamic_pcell$7_0.A_DRN wind_comp_0.comparator_1.dynamic_pcell$7_0.D_DRN vss_1v2.t337 vss_1v2.t304 sg13_lv_nmos ad=63.19999f pd=0.74u as=63.19999f ps=0.74u w=0.26u l=10u
X222 vss_1v2.t277 wind_comp_0.comparator_0.dynamic_pcell$7_0.A_DRN wind_comp_0.comparator_0.dynamic_pcell$7_0.A_DRN vss_1v2.t276 sg13_lv_nmos ad=63.19999f pd=0.74u as=63.19999f ps=0.74u w=0.26u l=10u
X223 wind_comp_0.comparator_0.dynamic_pcell$7_0.DRN_NET_CF_GATE_CD vss_1v2.t75 vss_1v2.t74 vss_1v2.t76 sg13_lv_nmos ad=63.19999f pd=0.74u as=63.19999f ps=0.74u w=0.26u l=0.5u
X224 vss_1v2.t285 wind_comp_0.comparator_0.sg13cmos5l_inv_16_1.A wind_comp_0.comparator_0.sg13cmos5l_inv_16_0.A vss_1v2.t294 sg13_lv_nmos ad=0.1406p pd=1.12u as=0.1406p ps=1.12u w=0.74u l=0.13u
X225 wind_comp_0.comparator_0.dynamic_pcell$7_0.SRC_NET_EF wind_comp_0.comparator_0.nmos$2_0.Drain vss_1v2.t21 vss_1v2.t327 sg13_lv_nmos ad=0.95p pd=5.38u as=0.95p ps=5.38u w=5u l=3u
X226 vss_1v2.t240 wind_comp_0.comparator_1.sg13cmos5l_inv_16_0.A wind_comp_0.sg13g2_and2_2$1_0.B vss_1v2.t247 sg13_lv_nmos ad=0.1406p pd=1.12u as=0.1406p ps=1.12u w=0.74u l=0.13u
X227 wind_comp_0.comparator_0.sg13cmos5l_inv_16_0.A wind_comp_0.comparator_0.sg13cmos5l_inv_16_1.A vss_1v2.t285 vss_1v2.t276 sg13_lv_nmos ad=0.1406p pd=1.12u as=0.1406p ps=1.12u w=0.74u l=0.13u
X228 vss_1v2.t263 enable.t5 wind_comp_0.comparator_0.nmos_0.Gate vss_1v2.t262 sg13_lv_nmos ad=0.2516p pd=2.16u as=0.2516p ps=2.16u w=0.74u l=0.13u
X229 vdd_1v2 vdd_1v2 vdd_1v2 vdd_1v2 sg13_lv_pmos ad=95f pd=0.88u as=0 ps=0 w=0.5u l=0.5u
X230 vss_1v2.t280 wind_comp_0.comparator_0.dynamic_pcell$7_0.A_DRN wind_comp_0.comparator_0.dynamic_pcell$7_0.D_DRN vss_1v2.t276 sg13_lv_nmos ad=63.19999f pd=0.74u as=63.19999f ps=0.74u w=0.26u l=10u
X231 vss_1v2.t240 wind_comp_0.comparator_1.sg13cmos5l_inv_16_0.A wind_comp_0.sg13g2_and2_2$1_0.B vss_1v2.t243 sg13_lv_nmos ad=0.1406p pd=1.12u as=0.1406p ps=1.12u w=0.74u l=0.13u
X232 vdd_1v2 vdd_1v2 vdd_1v2 vdd_1v2 sg13_lv_pmos ad=0.17p pd=1.68u as=0 ps=0 w=0.5u l=0.5u
X233 vss_1v2.t60 vss_1v2.t63 vss_1v2.t60 vss_1v2.t56 sg13_lv_nmos ad=55.5f pd=0.74u as=0 ps=0 w=0.15u l=0.5u
X234 vss_1v2.t363 wind_comp_0.comparator_0.sg13cmos5l_inv_16_0.A wind_comp_0.comparator_0.vout_comp vss_1v2.t366 sg13_lv_nmos ad=0.1406p pd=1.12u as=0.1406p ps=1.12u w=0.74u l=0.13u
X235 vdd_1v2 vdd_1v2 vdd_1v2 vdd_1v2 sg13_lv_pmos ad=0.119p pd=1.38u as=0 ps=0 w=0.35u l=0.5u
X236 wind_comp_0.comparator_1.sg13cmos5l_inv_16_0.A wind_comp_0.comparator_1.sg13cmos5l_inv_16_1.A vdd_1v2 vdd_1v2 sg13_lv_pmos ad=0.2128p pd=1.5u as=0.2128p ps=1.5u w=1.12u l=0.13u
X237 vdd_1v2 wind_comp_0.comparator_0.sg13cmos5l_inv_16_0.A wind_comp_0.comparator_0.vout_comp vdd_1v2 sg13_lv_pmos ad=0.2128p pd=1.5u as=0.2128p ps=1.5u w=1.12u l=0.13u
X238 wind_comp_0.comparator_0.dynamic_pcell$7_0.DRN_NET_CF_GATE_CD wind_comp_0.comparator_0.dynamic_pcell$7_0.DRN_NET_CF_GATE_CD vdd_1v2 vdd_1v2 sg13_lv_pmos ad=0.119p pd=1.38u as=66.49999f ps=0.73u w=0.35u l=1u
X239 vss_1v2.t337 wind_comp_0.comparator_1.dynamic_pcell$7_0.A_DRN wind_comp_0.comparator_1.dynamic_pcell$7_0.D_DRN vss_1v2.t335 sg13_lv_nmos ad=63.19999f pd=0.74u as=63.19999f ps=0.74u w=0.26u l=10u
X240 vss_1v2.t152 vss_1v2.t150 wind_comp_0.comparator_0.dynamic_pcell$7_0.A_DRN vss_1v2.t151 sg13_lv_nmos ad=63.19999f pd=0.74u as=63.19999f ps=0.74u w=0.26u l=0.5u
X241 vdd_1v2 vdd_1v2 vdd_1v2 vdd_1v2 sg13_lv_pmos ad=0.17p pd=1.68u as=0 ps=0 w=0.5u l=0.5u
X242 wind_comp_0.comparator_1.nmos$2_0.Drain vss_1v2.t232 vss_1v2.t229 vss_1v2.t23 sg13_lv_nmos ad=0.95p pd=5.38u as=0.95p ps=5.38u w=5u l=0.5u
X243 vss_1v2.t47 wind_comp_0.comparator_0.nmos$2_0.Drain wind_comp_0.comparator_0.dynamic_pcell$7_0.SRC_NET_EF vss_1v2.t325 sg13_lv_nmos ad=0.95p pd=5.38u as=0.95p ps=5.38u w=5u l=3u
X244 vss_1v2.t271 wind_comp_0.comparator_0.nmos_0.Gate wind_comp_0.comparator_0.nmos$2_0.Drain vss_1v2.t272 sg13_lv_nmos ad=55.5f pd=0.74u as=0.1005p ps=1.34u w=0.15u l=0.13u
X245 vss_1v2.t57 vss_1v2.t70 wind_comp_0.comparator_0.dynamic_pcell_0.DRN_NET_GJ_GATE_GH vss_1v2.t59 sg13_lv_nmos ad=55.5f pd=0.74u as=55.5f ps=0.74u w=0.15u l=0.5u
X246 vss_1v2.t202 vss_1v2.t201 vss_1v2.t202 vss_1v2.t168 sg13_lv_nmos ad=0.1082p pd=1.34u as=0 ps=0 w=0.26u l=0.5u
X247 wind_comp_0.comparator_0.dynamic_pcell$7_0.A_DRN vss_1v2.t148 vss_1v2.t146 vss_1v2.t149 sg13_lv_nmos ad=63.19999f pd=0.74u as=63.19999f ps=0.74u w=0.26u l=0.5u
X248 analog_bus1 a_51539_28086# vss_1v2.t324 vss_1v2.t379 sg13_lv_nmos ad=0.1406p pd=1.12u as=0.1331p ps=1.12u w=0.74u l=0.13u
X249 wind_comp_0.comparator_0.sg13cmos5l_inv_16_1.A wind_comp_0.comparator_0.dynamic_pcell$7_0.A_DRN wind_comp_0.comparator_0.dynamic_pcell_0.SRC_NET_IJ vdd_1v2 sg13_lv_pmos ad=0.5928p pd=3.5u as=0.5928p ps=3.5u w=3.12u l=1u
X250 vdd_1v2 wind_comp_0.comparator_1.sg13cmos5l_inv_16_0.A wind_comp_0.sg13g2_and2_2$1_0.B vdd_1v2 sg13_lv_pmos ad=0.2128p pd=1.5u as=0.2128p ps=1.5u w=1.12u l=0.13u
X251 wind_comp_0.comparator_0.dynamic_pcell_0.DRN_NET_GJ_GATE_GH wind_comp_0.comparator_0.dynamic_pcell$7_0.D_DRN wind_comp_0.comparator_0.dynamic_pcell_0.SRC_NET_IJ vdd_1v2 sg13_lv_pmos ad=0.5928p pd=3.5u as=0.5928p ps=3.5u w=3.12u l=1u
X252 wind_comp_0.comparator_0.dynamic_pcell$2_0.DRN_NET_LM_GATE_KL wind_comp_0.comparator_0.nmos$2_0.Drain vss_1v2.t326 vss_1v2.t325 sg13_lv_nmos ad=0.95p pd=5.38u as=0.95p ps=5.38u w=5u l=3u
X253 vss_1v2.t309 wind_comp_0.comparator_1.sg13cmos5l_inv_16_1.A wind_comp_0.comparator_1.sg13cmos5l_inv_16_0.A vss_1v2.t311 sg13_lv_nmos ad=0.1406p pd=1.12u as=0.1406p ps=1.12u w=0.74u l=0.13u
X254 wind_comp_0.sg13g2_and2_2$1_0.B wind_comp_0.comparator_1.sg13cmos5l_inv_16_0.A vdd_1v2 vdd_1v2 sg13_lv_pmos ad=0.2128p pd=1.5u as=0.2128p ps=1.5u w=1.12u l=0.13u
X255 vdd_1v2 a_51539_28086# analog_bus1 vdd_1v2 sg13_lv_pmos ad=0.4256p pd=3u as=0.2128p ps=1.5u w=1.12u l=0.13u
X256 vdd_1v2 wind_comp_0.comparator_0.sg13cmos5l_inv_16_1.A wind_comp_0.comparator_0.sg13cmos5l_inv_16_0.A vdd_1v2 sg13_lv_pmos ad=0.2128p pd=1.5u as=0.2128p ps=1.5u w=1.12u l=0.13u
X257 wind_comp_0.comparator_0.dynamic_pcell_0.SRC_NET_IJ wind_comp_0.comparator_0.dynamic_pcell$2_0.DRN_NET_LM_GATE_KL vdd_1v2 vdd_1v2 sg13_lv_pmos ad=95f pd=0.88u as=95f ps=0.88u w=0.5u l=3u
X258 vss_1v2.t161 vss_1v2.t160 wind_comp_0.comparator_0.dynamic_pcell$7_0.D_DRN vss_1v2.t151 sg13_lv_nmos ad=63.19999f pd=0.74u as=63.19999f ps=0.74u w=0.26u l=0.5u
X259 a_51633_28086# wind_comp_0.comparator_0.vout_comp a_51539_28086# vss_1v2.t273 sg13_lv_nmos ad=0.1216p pd=1.02u as=0.2176p ps=1.96u w=0.64u l=0.13u
X260 vdd_1v2 vdd_1v2 vdd_1v2 vdd_1v2 sg13_lv_pmos ad=66.49999f pd=0.73u as=0 ps=0 w=0.35u l=0.5u
X261 wind_comp_0.sg13g2_and2_2$1_0.B wind_comp_0.comparator_1.sg13cmos5l_inv_16_0.A vdd_1v2 vdd_1v2 sg13_lv_pmos ad=0.2128p pd=1.5u as=0.2128p ps=1.5u w=1.12u l=0.13u
X262 vdd_1v2 wind_comp_0.comparator_1.dynamic_pcell$7_0.DRN_NET_BE_GATE_AB wind_comp_0.comparator_1.dynamic_pcell$7_0.DRN_NET_BE_GATE_AB vdd_1v2 sg13_lv_pmos ad=66.49999f pd=0.73u as=0.119p ps=1.38u w=0.35u l=1u
X263 enable.t7 vdd_1v2 dpantenna l=1.34u w=1.05u
X264 vdd_1v2 enable.t5 wind_comp_0.comparator_0.nmos_0.Gate vdd_1v2 sg13_lv_pmos ad=0.3808p pd=2.92u as=0.3808p ps=2.92u w=1.12u l=0.13u
X265 ibias0 enable.t1 wind_comp_0.comparator_0.nmos$2_0.Drain vss_1v2.t264 sg13_lv_nmos ad=55.5f pd=0.74u as=0.1005p ps=1.34u w=0.15u l=0.13u
X266 vdd_1v2 wind_comp_0.comparator_1.sg13cmos5l_inv_16_1.A wind_comp_0.comparator_1.sg13cmos5l_inv_16_0.A vdd_1v2 sg13_lv_pmos ad=0.4368p pd=3.02u as=0.2128p ps=1.5u w=1.12u l=0.13u
X267 vss_1v2.t231 vss_1v2.t230 wind_comp_0.comparator_1.dynamic_pcell$2_0.DRN_NET_LM_GATE_KL vss_1v2.t29 sg13_lv_nmos ad=0.95p pd=5.38u as=0.95p ps=5.38u w=5u l=0.5u
X268 wind_comp_0.comparator_0.vout_comp wind_comp_0.comparator_0.sg13cmos5l_inv_16_0.A vdd_1v2 vdd_1v2 sg13_lv_pmos ad=0.2128p pd=1.5u as=0.2128p ps=1.5u w=1.12u l=0.13u
X269 vss_1v2.t359 wind_comp_0.comparator_1.dynamic_pcell_0.DRN_NET_GJ_GATE_GH wind_comp_0.comparator_1.dynamic_pcell_0.DRN_NET_GJ_GATE_GH vss_1v2.t302 sg13_lv_nmos ad=55.5f pd=0.74u as=55.5f ps=0.74u w=0.15u l=3u
X270 vss_1v2.t47 vss_1v2.t45 vss_1v2.t46 vss_1v2.t12 sg13_lv_nmos ad=0.95p pd=5.38u as=0 ps=0 w=5u l=0.5u
X271 wind_comp_0.comparator_0.dynamic_pcell$7_0.D_DRN vss_1v2.t158 vss_1v2.t156 vss_1v2.t149 sg13_lv_nmos ad=63.19999f pd=0.74u as=63.19999f ps=0.74u w=0.26u l=0.5u
X272 wind_comp_0.sg13g2_and2_2$1_0.B wind_comp_0.comparator_1.sg13cmos5l_inv_16_0.A vss_1v2.t240 vss_1v2.t239 sg13_lv_nmos ad=0.1406p pd=1.12u as=0.2516p ps=2.16u w=0.74u l=0.13u
X273 vss_1v2.t92 vss_1v2.t90 vss_1v2.t92 vss_1v2.t91 sg13_lv_nmos ad=63.19999f pd=0.74u as=0 ps=0 w=0.26u l=0.5u
X274 wind_comp_0.comparator_0.vout_comp wind_comp_0.comparator_0.sg13cmos5l_inv_16_0.A vdd_1v2 vdd_1v2 sg13_lv_pmos ad=0.2128p pd=1.5u as=0.2128p ps=1.5u w=1.12u l=0.13u
X275 wind_comp_0.comparator_0.dynamic_pcell$2_0.DRN_NET_LM_GATE_KL vss_1v2.t137 vss_1v2.t135 vss_1v2.t15 sg13_lv_nmos ad=0.95p pd=5.38u as=0.95p ps=5.38u w=5u l=0.5u
X276 wind_comp_0.comparator_0.vout_comp wind_comp_0.comparator_0.sg13cmos5l_inv_16_0.A vdd_1v2 vdd_1v2 sg13_lv_pmos ad=0.2128p pd=1.5u as=0.4368p ps=3.02u w=1.12u l=0.13u
X277 vss_1v2.t13 vss_1v2.t11 wind_comp_0.comparator_0.dynamic_pcell$2_0.DRN_NET_LM_GATE_KL vss_1v2.t12 sg13_lv_nmos ad=0.95p pd=5.38u as=0.95p ps=5.38u w=5u l=0.5u
X278 vss_1v2.t240 wind_comp_0.comparator_1.sg13cmos5l_inv_16_0.A wind_comp_0.sg13g2_and2_2$1_0.B vss_1v2.t255 sg13_lv_nmos ad=0.2516p pd=2.16u as=0.1406p ps=1.12u w=0.74u l=0.13u
X279 wind_comp_0.comparator_1.dynamic_pcell$7_0.DRN_NET_CF_GATE_CD vss_1v2.t99 vss_1v2.t98 vss_1v2.t96 sg13_lv_nmos ad=63.19999f pd=0.74u as=63.19999f ps=0.74u w=0.26u l=0.5u
X280 vdd_1v2 vdd_1v2 wind_comp_0.comparator_0.dynamic_pcell_0.SRC_NET_IJ vdd_1v2 sg13_lv_pmos ad=95f pd=0.88u as=95f ps=0.88u w=0.5u l=0.5u
X281 vss_1v2.t240 wind_comp_0.comparator_1.sg13cmos5l_inv_16_0.A wind_comp_0.sg13g2_and2_2$1_0.B vss_1v2.t251 sg13_lv_nmos ad=0.1406p pd=1.12u as=0.1406p ps=1.12u w=0.74u l=0.13u
X282 wind_comp_0.comparator_1.sg13cmos5l_inv_16_0.A wind_comp_0.comparator_1.sg13cmos5l_inv_16_1.A vss_1v2.t309 vss_1v2.t312 sg13_lv_nmos ad=0.1406p pd=1.12u as=0.1406p ps=1.12u w=0.74u l=0.13u
X283 vss_1v2.t190 vss_1v2.t188 wind_comp_0.comparator_1.dynamic_pcell$7_0.A_DRN vss_1v2.t189 sg13_lv_nmos ad=63.19999f pd=0.74u as=63.19999f ps=0.74u w=0.26u l=0.5u
X284 vss_1v2.t263 wind_comp_0.comparator_0.sg13cmos5l_inv_16_0.A wind_comp_0.comparator_0.vout_comp vss_1v2.t378 sg13_lv_nmos ad=0.2516p pd=2.16u as=0.1406p ps=1.12u w=0.74u l=0.13u
X285 enable.t6 vdd_1v2 dpantenna l=1.34u w=1.05u
X286 wind_comp_0.comparator_1.dynamic_pcell$7_0.SRC_NET_EF wind_comp_0.comparator_1.nmos$2_0.Drain vss_1v2.t220 vss_1v2.t348 sg13_lv_nmos ad=0.95p pd=5.38u as=0.95p ps=5.38u w=5u l=3u
X287 wind_comp_0.comparator_1.sg13cmos5l_inv_16_0.A wind_comp_0.comparator_1.sg13cmos5l_inv_16_1.A vss_1v2.t240 vss_1v2.t307 sg13_lv_nmos ad=0.1406p pd=1.12u as=0.1406p ps=1.12u w=0.74u l=0.13u
X288 vss_1v2.t263 wind_comp_0.comparator_0.sg13cmos5l_inv_16_0.A wind_comp_0.comparator_0.vout_comp vss_1v2.t374 sg13_lv_nmos ad=0.1406p pd=1.12u as=0.1406p ps=1.12u w=0.74u l=0.13u
X289 wind_comp_0.comparator_0.sg13cmos5l_inv_16_0.A wind_comp_0.comparator_0.sg13cmos5l_inv_16_1.A vdd_1v2 vdd_1v2 sg13_lv_pmos ad=0.2128p pd=1.5u as=0.2128p ps=1.5u w=1.12u l=0.13u
X290 wind_comp_0.comparator_1.sg13cmos5l_inv_16_0.A wind_comp_0.comparator_1.sg13cmos5l_inv_16_1.A vss_1v2.t240 vss_1v2.t303 sg13_lv_nmos ad=0.1406p pd=1.12u as=0.1406p ps=1.12u w=0.74u l=0.13u
X291 wind_comp_0.comparator_0.dynamic_pcell$7_0.SRC_NET_EF s4_an[0] wind_comp_0.comparator_0.dynamic_pcell$7_0.DRN_NET_BE_GATE_AB vss_1v2.t283 sg13_lv_nmos ad=63.19999f pd=0.74u as=63.19999f ps=0.74u w=0.26u l=3u
X292 vdd_1v2 vdd_1v2 wind_comp_0.comparator_1.dynamic_pcell$7_0.A_DRN vdd_1v2 sg13_lv_pmos ad=66.49999f pd=0.73u as=66.49999f ps=0.73u w=0.35u l=0.5u
X293 wind_comp_0.comparator_1.dynamic_pcell$2_0.DRN_NET_LM_GATE_KL wind_comp_0.comparator_1.nmos$2_0.Drain vss_1v2.t355 vss_1v2.t351 sg13_lv_nmos ad=0.95p pd=5.38u as=0.95p ps=5.38u w=5u l=3u
X294 vss_1v2.t256 enable.t4 dantenna l=0.78u w=0.78u
X295 vss_1v2.t349 wind_comp_0.comparator_1.nmos$2_0.Drain wind_comp_0.comparator_1.dynamic_pcell$2_0.DRN_NET_LM_GATE_KL vss_1v2.t348 sg13_lv_nmos ad=0.95p pd=5.38u as=0.95p ps=5.38u w=5u l=3u
X296 wind_comp_0.comparator_0.sg13cmos5l_inv_16_0.A wind_comp_0.comparator_0.sg13cmos5l_inv_16_1.A vss_1v2.t285 vss_1v2.t291 sg13_lv_nmos ad=0.1406p pd=1.12u as=0.1406p ps=1.12u w=0.74u l=0.13u
X297 vdd_1v2 vdd_1v2 vdd_1v2 vdd_1v2 sg13_lv_pmos ad=1.0608p pd=6.92u as=0 ps=0 w=3.12u l=0.5u
X298 vdd_1v2 vdd_1v2 vdd_1v2 vdd_1v2 sg13_lv_pmos ad=1.0608p pd=6.92u as=0 ps=0 w=3.12u l=0.5u
X299 wind_comp_0.comparator_0.sg13cmos5l_inv_16_0.A wind_comp_0.comparator_0.sg13cmos5l_inv_16_1.A vss_1v2.t285 vss_1v2.t287 sg13_lv_nmos ad=0.1406p pd=1.12u as=0.1406p ps=1.12u w=0.74u l=0.13u
X300 vdd_1v2 wind_comp_0.comparator_1.dynamic_pcell$2_0.DRN_NET_LM_GATE_KL wind_comp_0.comparator_1.dynamic_pcell_0.SRC_NET_IJ vdd_1v2 sg13_lv_pmos ad=95f pd=0.88u as=95f ps=0.88u w=0.5u l=3u
X301 vss_1v2.t124 vss_1v2.t126 vss_1v2.t127 vss_1v2.t23 sg13_lv_nmos ad=0.95p pd=5.38u as=0 ps=0 w=5u l=0.5u
X302 vss_1v2.t198 vss_1v2.t197 wind_comp_0.comparator_1.dynamic_pcell$7_0.D_DRN vss_1v2.t189 sg13_lv_nmos ad=63.19999f pd=0.74u as=63.19999f ps=0.74u w=0.26u l=0.5u
X303 vss_1v2.t107 vss_1v2.t105 vss_1v2.t107 vss_1v2.t106 sg13_lv_nmos ad=0.1005p pd=1.34u as=0 ps=0 w=0.15u l=0.5u
X304 vdd_1v2 wind_comp_0.comparator_0.dynamic_pcell$2_0.DRN_NET_LM_GATE_KL wind_comp_0.comparator_0.dynamic_pcell_0.SRC_NET_IJ vdd_1v2 sg13_lv_pmos ad=95f pd=0.88u as=95f ps=0.88u w=0.5u l=3u
X305 wind_comp_0.comparator_1.dynamic_pcell$7_0.A_DRN wind_comp_0.comparator_1.dynamic_pcell$7_0.A_DRN vss_1v2.t338 vss_1v2.t304 sg13_lv_nmos ad=63.19999f pd=0.74u as=63.19999f ps=0.74u w=0.26u l=10u
X306 wind_comp_0.comparator_1.dynamic_pcell_0.DRN_NET_GJ_GATE_GH vss_1v2.t119 vss_1v2.t107 vss_1v2.t109 sg13_lv_nmos ad=55.5f pd=0.74u as=55.5f ps=0.74u w=0.15u l=0.5u
X307 wind_comp_0.comparator_1.sg13cmos5l_inv_16_1.A wind_comp_0.comparator_1.dynamic_pcell_0.DRN_NET_GJ_GATE_GH vss_1v2.t359 vss_1v2.t358 sg13_lv_nmos ad=55.5f pd=0.74u as=55.5f ps=0.74u w=0.15u l=3u
X308 vss_1v2.t226 vss_1v2.t224 vss_1v2.t223 vss_1v2.t25 sg13_lv_nmos ad=0.95p pd=5.38u as=0 ps=0 w=5u l=0.5u
X309 wind_comp_0.sg13g2_and2_2$1_0.B wind_comp_0.comparator_1.sg13cmos5l_inv_16_0.A vss_1v2.t240 vss_1v2.t252 sg13_lv_nmos ad=0.1406p pd=1.12u as=0.1406p ps=1.12u w=0.74u l=0.13u
X310 vss_1v2.t177 vss_1v2.t176 vss_1v2.t177 vss_1v2.t145 sg13_lv_nmos ad=0.1082p pd=1.34u as=0 ps=0 w=0.26u l=0.5u
X311 wind_comp_0.comparator_1.nmos$2_0.Drain enable.t0 ibias0 vss_1v2.t267 sg13_lv_nmos ad=55.5f pd=0.74u as=0.1005p ps=1.34u w=0.15u l=0.13u
X312 a_51539_28086# wind_comp_0.comparator_0.vout_comp vdd_1v2 vdd_1v2 sg13_lv_pmos ad=0.1596p pd=1.22u as=0.2856p ps=2.36u w=0.84u l=0.13u
X313 vdd_1v2 wind_comp_0.comparator_0.dynamic_pcell$7_0.DRN_NET_BE_GATE_AB wind_comp_0.comparator_0.dynamic_pcell$7_0.A_DRN vdd_1v2 sg13_lv_pmos ad=66.49999f pd=0.73u as=66.49999f ps=0.73u w=0.35u l=1u
X314 vss_1v2.t41 vss_1v2.t39 vss_1v2.t40 vss_1v2.t1 sg13_lv_nmos ad=1.7p pd=10.68u as=0 ps=0 w=5u l=0.5u
X315 vss_1v2.t27 vss_1v2.t24 vss_1v2.t26 vss_1v2.t25 sg13_lv_nmos ad=0.95p pd=5.38u as=0 ps=0 w=5u l=0.5u
X316 vss_1v2.t258 enable.t3 dantenna l=0.78u w=0.78u
X317 vdd_1v2 wind_comp_0.comparator_1.sg13cmos5l_inv_16_1.A wind_comp_0.comparator_1.sg13cmos5l_inv_16_0.A vdd_1v2 sg13_lv_pmos ad=0.2128p pd=1.5u as=0.2128p ps=1.5u w=1.12u l=0.13u
X318 vss_1v2.t98 vss_1v2.t97 vss_1v2.t98 vss_1v2.t9 sg13_lv_nmos ad=0.1082p pd=1.34u as=0 ps=0 w=0.26u l=0.5u
X319 wind_comp_0.comparator_1.dynamic_pcell$7_0.D_DRN wind_comp_0.comparator_1.dynamic_pcell$7_0.A_DRN vss_1v2.t336 vss_1v2.t304 sg13_lv_nmos ad=63.19999f pd=0.74u as=63.19999f ps=0.74u w=0.26u l=10u
X320 vdd_1v2 vdd_1v2 vdd_1v2 vdd_1v2 sg13_lv_pmos ad=95f pd=0.88u as=0 ps=0 w=0.5u l=0.5u
X321 vss_1v2.t130 vss_1v2.t128 vss_1v2.t129 vss_1v2.t29 sg13_lv_nmos ad=0.95p pd=5.38u as=0 ps=0 w=5u l=0.5u
X322 vdd_1v2 wind_comp_0.comparator_1.sg13cmos5l_inv_16_1.A wind_comp_0.comparator_1.sg13cmos5l_inv_16_0.A vdd_1v2 sg13_lv_pmos ad=0.2128p pd=1.5u as=0.2128p ps=1.5u w=1.12u l=0.13u
X323 vss_1v2.t3 vss_1v2.t0 vss_1v2.t2 vss_1v2.t1 sg13_lv_nmos ad=1.7p pd=10.68u as=0 ps=0 w=5u l=0.5u
X324 wind_comp_0.comparator_0.vout_comp wind_comp_0.comparator_0.sg13cmos5l_inv_16_0.A vdd_1v2 vdd_1v2 sg13_lv_pmos ad=0.2128p pd=1.5u as=0.2128p ps=1.5u w=1.12u l=0.13u
X325 vss_1v2.t205 vss_1v2.t203 vss_1v2.t204 vss_1v2.t5 sg13_lv_nmos ad=1.7p pd=10.68u as=0 ps=0 w=5u l=0.5u
X326 vdd_1v2 wind_comp_0.comparator_1.sg13cmos5l_inv_16_1.A wind_comp_0.comparator_1.sg13cmos5l_inv_16_0.A vdd_1v2 sg13_lv_pmos ad=0.2128p pd=1.5u as=0.2128p ps=1.5u w=1.12u l=0.13u
X327 vdd_1v2 vdd_1v2 vdd_1v2 vdd_1v2 sg13_lv_pmos ad=0.17p pd=1.68u as=0 ps=0 w=0.5u l=0.5u
X328 vss_1v2.t21 vss_1v2.t19 vss_1v2.t20 vss_1v2.t15 sg13_lv_nmos ad=0.95p pd=5.38u as=0 ps=0 w=5u l=0.5u
X329 wind_comp_0.comparator_0.dynamic_pcell$7_0.D_DRN wind_comp_0.comparator_0.dynamic_pcell$7_0.A_DRN vss_1v2.t279 vss_1v2.t278 sg13_lv_nmos ad=63.19999f pd=0.74u as=63.19999f ps=0.74u w=0.26u l=10u
X330 vdd_1v2 wind_comp_0.comparator_0.sg13cmos5l_inv_16_1.A wind_comp_0.comparator_0.sg13cmos5l_inv_16_0.A vdd_1v2 sg13_lv_pmos ad=0.2128p pd=1.5u as=0.2128p ps=1.5u w=1.12u l=0.13u
X331 wind_comp_0.comparator_0.sg13cmos5l_inv_16_1.A vdd_1v2 vdd_1v2 vdd_1v2 sg13_lv_pmos ad=0.5928p pd=3.5u as=0.5928p ps=3.5u w=3.12u l=0.5u
X332 wind_comp_0.comparator_0.dynamic_pcell_0.DRN_NET_GJ_GATE_GH vdd_1v2 vdd_1v2 vdd_1v2 sg13_lv_pmos ad=0.5928p pd=3.5u as=0.5928p ps=3.5u w=3.12u l=0.5u
X333 vss_1v2.t79 vss_1v2.t77 wind_comp_0.comparator_0.dynamic_pcell$7_0.DRN_NET_BE_GATE_AB vss_1v2.t78 sg13_lv_nmos ad=63.19999f pd=0.74u as=63.19999f ps=0.74u w=0.26u l=0.5u
X334 vss_1v2.t7 vss_1v2.t4 vss_1v2.t6 vss_1v2.t5 sg13_lv_nmos ad=1.7p pd=10.68u as=0 ps=0 w=5u l=0.5u
X335 wind_comp_0.comparator_0.dynamic_pcell$7_0.DRN_NET_CF_GATE_CD analog_bus2 wind_comp_0.comparator_0.dynamic_pcell$7_0.SRC_NET_EF vss_1v2.t282 sg13_lv_nmos ad=63.19999f pd=0.74u as=63.19999f ps=0.74u w=0.26u l=3u
X336 vdd_1v2 wind_comp_0.comparator_0.sg13cmos5l_inv_16_1.A wind_comp_0.comparator_0.sg13cmos5l_inv_16_0.A vdd_1v2 sg13_lv_pmos ad=0.2128p pd=1.5u as=0.2128p ps=1.5u w=1.12u l=0.13u
X337 vss_1v2.t143 vss_1v2.t141 vss_1v2.t140 vss_1v2.t17 sg13_lv_nmos ad=0.95p pd=5.38u as=0 ps=0 w=5u l=0.5u
X338 wind_comp_0.comparator_1.dynamic_pcell$7_0.SRC_NET_EF analog_bus0 wind_comp_0.comparator_1.dynamic_pcell$7_0.DRN_NET_BE_GATE_AB vss_1v2.t274 sg13_lv_nmos ad=63.19999f pd=0.74u as=63.19999f ps=0.74u w=0.26u l=3u
X339 vdd_1v2 vdd_1v2 vdd_1v2 vdd_1v2 sg13_lv_pmos ad=0.17p pd=1.68u as=0 ps=0 w=0.5u l=0.5u
X340 vss_1v2.t173 vss_1v2.t174 vss_1v2.t173 vss_1v2.t154 sg13_lv_nmos ad=63.19999f pd=0.74u as=0 ps=0 w=0.26u l=0.5u
X341 vss_1v2.t337 wind_comp_0.comparator_1.dynamic_pcell$7_0.A_DRN wind_comp_0.comparator_1.dynamic_pcell$7_0.A_DRN vss_1v2.t335 sg13_lv_nmos ad=63.19999f pd=0.74u as=63.19999f ps=0.74u w=0.26u l=10u
X342 wind_comp_0.comparator_1.sg13cmos5l_inv_16_0.A wind_comp_0.comparator_1.sg13cmos5l_inv_16_1.A vss_1v2.t309 vss_1v2.t316 sg13_lv_nmos ad=0.1406p pd=1.12u as=0.1406p ps=1.12u w=0.74u l=0.13u
X343 vss_1v2.t263 wind_comp_0.comparator_0.sg13cmos5l_inv_16_0.A wind_comp_0.comparator_0.vout_comp vss_1v2.t370 sg13_lv_nmos ad=0.1406p pd=1.12u as=0.1406p ps=1.12u w=0.74u l=0.13u
X344 vdd_1v2 wind_comp_0.comparator_1.sg13cmos5l_inv_16_0.A wind_comp_0.sg13g2_and2_2$1_0.B vdd_1v2 sg13_lv_pmos ad=0.2128p pd=1.5u as=0.2128p ps=1.5u w=1.12u l=0.13u
X345 vss_1v2.t320 wind_comp_0.comparator_0.dynamic_pcell_0.DRN_NET_GJ_GATE_GH wind_comp_0.comparator_0.dynamic_pcell_0.DRN_NET_GJ_GATE_GH vss_1v2.t318 sg13_lv_nmos ad=55.5f pd=0.74u as=55.5f ps=0.74u w=0.15u l=3u
X346 vss_1v2.t185 vss_1v2.t184 vss_1v2.t185 vss_1v2.t168 sg13_lv_nmos ad=0.1082p pd=1.34u as=0 ps=0 w=0.26u l=0.5u
X347 vdd_1v2 vdd_1v2 wind_comp_0.comparator_0.dynamic_pcell$7_0.D_DRN vdd_1v2 sg13_lv_pmos ad=66.49999f pd=0.73u as=66.49999f ps=0.73u w=0.35u l=0.5u
X348 wind_comp_0.comparator_0.dynamic_pcell_0.SRC_NET_IJ wind_comp_0.comparator_0.dynamic_pcell$2_0.DRN_NET_LM_GATE_KL vdd_1v2 vdd_1v2 sg13_lv_pmos ad=95f pd=0.88u as=95f ps=0.88u w=0.5u l=3u
X349 vss_1v2.t118 vss_1v2.t117 wind_comp_0.comparator_1.sg13cmos5l_inv_16_1.A vss_1v2.t111 sg13_lv_nmos ad=55.5f pd=0.74u as=55.5f ps=0.74u w=0.15u l=0.5u
X350 vdd_1v2 wind_comp_0.comparator_1.dynamic_pcell$7_0.DRN_NET_BE_GATE_AB wind_comp_0.comparator_1.dynamic_pcell$7_0.A_DRN vdd_1v2 sg13_lv_pmos ad=66.49999f pd=0.73u as=66.49999f ps=0.73u w=0.35u l=1u
X351 vdd_1v2 wind_comp_0.comparator_0.sg13cmos5l_inv_16_0.A wind_comp_0.comparator_0.vout_comp vdd_1v2 sg13_lv_pmos ad=0.2128p pd=1.5u as=0.2128p ps=1.5u w=1.12u l=0.13u
X352 vss_1v2.t129 wind_comp_0.comparator_1.nmos$2_0.Drain wind_comp_0.comparator_1.dynamic_pcell$7_0.SRC_NET_EF vss_1v2.t351 sg13_lv_nmos ad=0.95p pd=5.38u as=0.95p ps=5.38u w=5u l=3u
X353 vdd_1v2 wind_comp_0.comparator_0.sg13cmos5l_inv_16_0.A wind_comp_0.comparator_0.vout_comp vdd_1v2 sg13_lv_pmos ad=0.2128p pd=1.5u as=0.2128p ps=1.5u w=1.12u l=0.13u
X354 wind_comp_0.comparator_0.dynamic_pcell$7_0.D_DRN wind_comp_0.comparator_0.dynamic_pcell$7_0.DRN_NET_CF_GATE_CD vdd_1v2 vdd_1v2 sg13_lv_pmos ad=66.49999f pd=0.73u as=66.49999f ps=0.73u w=0.35u l=1u
X355 vss_1v2.t67 vss_1v2.t65 vss_1v2.t66 vss_1v2.t52 sg13_lv_nmos ad=0.1005p pd=1.34u as=0 ps=0 w=0.15u l=0.5u
X356 vss_1v2.t240 wind_comp_0.comparator_1.sg13cmos5l_inv_16_0.A wind_comp_0.sg13g2_and2_2$1_0.B vss_1v2.t241 sg13_lv_nmos ad=0.1406p pd=1.12u as=0.1406p ps=1.12u w=0.74u l=0.13u
X357 vss_1v2.t194 vss_1v2.t193 vss_1v2.t194 vss_1v2.t168 sg13_lv_nmos ad=0.1082p pd=1.34u as=0 ps=0 w=0.26u l=0.5u
X358 wind_comp_0.sg13g2_and2_2$1_0.B wind_comp_0.comparator_1.sg13cmos5l_inv_16_0.A vss_1v2.t240 vss_1v2.t248 sg13_lv_nmos ad=0.1406p pd=1.12u as=0.1406p ps=1.12u w=0.74u l=0.13u
X359 vss_1v2.t285 wind_comp_0.comparator_0.sg13cmos5l_inv_16_1.A wind_comp_0.comparator_0.sg13cmos5l_inv_16_0.A vss_1v2.t298 sg13_lv_nmos ad=0.1406p pd=1.12u as=0.1406p ps=1.12u w=0.74u l=0.13u
X360 vss_1v2.t74 vss_1v2.t72 vss_1v2.t74 vss_1v2.t73 sg13_lv_nmos ad=0.1082p pd=1.34u as=0 ps=0 w=0.26u l=0.5u
X361 wind_comp_0.comparator_0.sg13cmos5l_inv_16_0.A wind_comp_0.comparator_0.sg13cmos5l_inv_16_1.A vdd_1v2 vdd_1v2 sg13_lv_pmos ad=0.2128p pd=1.5u as=0.4368p ps=3.02u w=1.12u l=0.13u
X362 wind_comp_0.sg13g2_and2_2$1_0.B wind_comp_0.comparator_1.sg13cmos5l_inv_16_0.A vss_1v2.t240 vss_1v2.t244 sg13_lv_nmos ad=0.1406p pd=1.12u as=0.1406p ps=1.12u w=0.74u l=0.13u
X363 wind_comp_0.comparator_1.nmos_0.Gate enable.t2 vss_1v2.t261 vss_1v2.t260 sg13_lv_nmos ad=0.2516p pd=2.16u as=0.2516p ps=2.16u w=0.74u l=0.13u
X364 wind_comp_0.comparator_0.dynamic_pcell$7_0.D_DRN vdd_1v2 vdd_1v2 vdd_1v2 sg13_lv_pmos ad=66.49999f pd=0.73u as=66.49999f ps=0.73u w=0.35u l=0.5u
X365 vss_1v2.t309 wind_comp_0.comparator_1.sg13cmos5l_inv_16_1.A wind_comp_0.comparator_1.sg13cmos5l_inv_16_0.A vss_1v2.t317 sg13_lv_nmos ad=0.2516p pd=2.16u as=0.1406p ps=1.12u w=0.74u l=0.13u
X366 wind_comp_0.comparator_0.vout_comp wind_comp_0.comparator_0.sg13cmos5l_inv_16_0.A vss_1v2.t263 vss_1v2.t371 sg13_lv_nmos ad=0.1406p pd=1.12u as=0.1406p ps=1.12u w=0.74u l=0.13u
X367 wind_comp_0.comparator_0.vout_comp wind_comp_0.comparator_0.sg13cmos5l_inv_16_0.A vss_1v2.t363 vss_1v2.t367 sg13_lv_nmos ad=0.1406p pd=1.12u as=0.1406p ps=1.12u w=0.74u l=0.13u
X368 vss_1v2.t85 vss_1v2.t84 vss_1v2.t85 vss_1v2.t81 sg13_lv_nmos ad=63.19999f pd=0.74u as=0 ps=0 w=0.26u l=0.5u
X369 wind_comp_0.comparator_0.vout_comp wind_comp_0.comparator_0.sg13cmos5l_inv_16_0.A vss_1v2.t363 vss_1v2.t362 sg13_lv_nmos ad=0.1406p pd=1.12u as=0.2516p ps=2.16u w=0.74u l=0.13u
X370 wind_comp_0.comparator_1.dynamic_pcell$7_0.DRN_NET_BE_GATE_AB wind_comp_0.comparator_1.dynamic_pcell$7_0.DRN_NET_BE_GATE_AB vdd_1v2 vdd_1v2 sg13_lv_pmos ad=0.119p pd=1.38u as=66.49999f ps=0.73u w=0.35u l=1u
X371 wind_comp_0.comparator_1.dynamic_pcell$7_0.DRN_NET_CF_GATE_CD s4_an[0] wind_comp_0.comparator_1.dynamic_pcell$7_0.SRC_NET_EF vss_1v2.t275 sg13_lv_nmos ad=63.19999f pd=0.74u as=63.19999f ps=0.74u w=0.26u l=3u
X372 vss_1v2.t209 vss_1v2.t210 vss_1v2.t209 vss_1v2.t192 sg13_lv_nmos ad=63.19999f pd=0.74u as=0 ps=0 w=0.26u l=0.5u
X373 wind_comp_0.comparator_0.sg13cmos5l_inv_16_1.A wind_comp_0.comparator_0.dynamic_pcell_0.DRN_NET_GJ_GATE_GH vss_1v2.t320 vss_1v2.t299 sg13_lv_nmos ad=55.5f pd=0.74u as=55.5f ps=0.74u w=0.15u l=3u
X374 vdd_1v2 vdd_1v2 wind_comp_0.comparator_0.sg13cmos5l_inv_16_1.A vdd_1v2 sg13_lv_pmos ad=0.5928p pd=3.5u as=0.5928p ps=3.5u w=3.12u l=0.5u
X375 vdd_1v2 vdd_1v2 wind_comp_0.comparator_0.dynamic_pcell_0.DRN_NET_GJ_GATE_GH vdd_1v2 sg13_lv_pmos ad=0.5928p pd=3.5u as=0.5928p ps=3.5u w=3.12u l=0.5u
X376 wind_comp_0.comparator_1.dynamic_pcell$2_0.DRN_NET_LM_GATE_KL vdd_1v2 vdd_1v2 vdd_1v2 sg13_lv_pmos ad=95f pd=0.88u as=95f ps=0.88u w=0.5u l=0.5u
X377 vss_1v2.t57 vss_1v2.t55 vss_1v2.t57 vss_1v2.t56 sg13_lv_nmos ad=55.5f pd=0.74u as=0 ps=0 w=0.15u l=0.5u
X378 vss_1v2.t381 a_51539_28086# analog_bus1 vss_1v2.t380 sg13_lv_nmos ad=0.2812p pd=2.24u as=0.1406p ps=1.12u w=0.74u l=0.13u
X379 wind_comp_0.comparator_1.dynamic_pcell$7_0.D_DRN wind_comp_0.comparator_1.dynamic_pcell$7_0.DRN_NET_CF_GATE_CD vdd_1v2 vdd_1v2 sg13_lv_pmos ad=66.49999f pd=0.73u as=66.49999f ps=0.73u w=0.35u l=1u
X380 vss_1v2.t38 vss_1v2.t36 vss_1v2.t34 vss_1v2.t17 sg13_lv_nmos ad=0.95p pd=5.38u as=0 ps=0 w=5u l=0.5u
X381 wind_comp_0.comparator_0.sg13cmos5l_inv_16_0.A wind_comp_0.comparator_0.sg13cmos5l_inv_16_1.A vss_1v2.t285 vss_1v2.t295 sg13_lv_nmos ad=0.1406p pd=1.12u as=0.1406p ps=1.12u w=0.74u l=0.13u
X382 vdd_1v2 wind_comp_0.comparator_1.sg13cmos5l_inv_16_0.A wind_comp_0.sg13g2_and2_2$1_0.B vdd_1v2 sg13_lv_pmos ad=0.2128p pd=1.5u as=0.2128p ps=1.5u w=1.12u l=0.13u
X383 wind_comp_0.comparator_0.sg13cmos5l_inv_16_0.A wind_comp_0.comparator_0.sg13cmos5l_inv_16_1.A vdd_1v2 vdd_1v2 sg13_lv_pmos ad=0.2128p pd=1.5u as=0.2128p ps=1.5u w=1.12u l=0.13u
X384 vss_1v2.t324 wind_comp_0.sg13g2_and2_2$1_0.B a_51633_28086# vss_1v2.t323 sg13_lv_nmos ad=0.1331p pd=1.12u as=0.1216p ps=1.02u w=0.64u l=0.13u
X385 vdd_1v2 wind_comp_0.comparator_1.sg13cmos5l_inv_16_0.A wind_comp_0.sg13g2_and2_2$1_0.B vdd_1v2 sg13_lv_pmos ad=0.2128p pd=1.5u as=0.2128p ps=1.5u w=1.12u l=0.13u
X386 vdd_1v2 vdd_1v2 vdd_1v2 vdd_1v2 sg13_lv_pmos ad=0.119p pd=1.38u as=0 ps=0 w=0.35u l=0.5u
X387 vdd_1v2 vdd_1v2 vdd_1v2 vdd_1v2 sg13_lv_pmos ad=66.49999f pd=0.73u as=0 ps=0 w=0.35u l=0.5u
X388 vss_1v2.t147 vss_1v2.t144 vss_1v2.t146 vss_1v2.t145 sg13_lv_nmos ad=0.1082p pd=1.34u as=0 ps=0 w=0.26u l=0.5u
X389 wind_comp_0.comparator_1.nmos_0.Gate enable.t2 vdd_1v2 vdd_1v2 sg13_lv_pmos ad=0.3808p pd=2.92u as=0.3808p ps=2.92u w=1.12u l=0.13u
X390 wind_comp_0.comparator_0.dynamic_pcell$7_0.DRN_NET_BE_GATE_AB wind_comp_0.comparator_0.dynamic_pcell$7_0.DRN_NET_BE_GATE_AB vdd_1v2 vdd_1v2 sg13_lv_pmos ad=0.119p pd=1.38u as=66.49999f ps=0.73u w=0.35u l=1u
X391 wind_comp_0.comparator_1.sg13cmos5l_inv_16_0.A wind_comp_0.comparator_1.sg13cmos5l_inv_16_1.A vdd_1v2 vdd_1v2 sg13_lv_pmos ad=0.2128p pd=1.5u as=0.2128p ps=1.5u w=1.12u l=0.13u
X392 wind_comp_0.comparator_1.sg13cmos5l_inv_16_0.A wind_comp_0.comparator_1.sg13cmos5l_inv_16_1.A vdd_1v2 vdd_1v2 sg13_lv_pmos ad=0.2128p pd=1.5u as=0.3808p ps=2.92u w=1.12u l=0.13u
X393 vdd_1v2 vdd_1v2 wind_comp_0.comparator_1.dynamic_pcell_0.SRC_NET_IJ vdd_1v2 sg13_lv_pmos ad=95f pd=0.88u as=95f ps=0.88u w=0.5u l=0.5u
X394 wind_comp_0.comparator_1.dynamic_pcell$2_0.DRN_NET_LM_GATE_KL enable.t8 vdd_1v2 vdd_1v2 sg13_lv_pmos ad=0.1005p pd=1.34u as=55.5f ps=0.74u w=0.15u l=0.13u
X395 vdd_1v2 wind_comp_0.comparator_0.sg13cmos5l_inv_16_0.A wind_comp_0.comparator_0.vout_comp vdd_1v2 sg13_lv_pmos ad=0.2128p pd=1.5u as=0.2128p ps=1.5u w=1.12u l=0.13u
C0 wind_comp_0.comparator_0.nmos$2_0.Drain wind_comp_0.comparator_0.dynamic_pcell$7_0.SRC_NET_EF 2.62856f
C1 ibias0 vdd_1v2 8.64245f
C2 analog_bus1 vdd_1v2 6.63968f
C3 vdd_1v2 enable 6.89936f
C4 wind_comp_0.comparator_1.dynamic_pcell$2_0.DRN_NET_LM_GATE_KL wind_comp_0.comparator_1.nmos$2_0.Drain 2.21668f
C5 wind_comp_0.comparator_0.dynamic_pcell$7_0.A_DRN wind_comp_0.comparator_0.sg13cmos5l_inv_16_1.A 2.18082f
C6 wind_comp_0.comparator_0.sg13cmos5l_inv_16_1.A vdd_1v2 2.87539f
C7 vdd_1v2 wind_comp_0.comparator_0.dynamic_pcell$7_0.DRN_NET_CF_GATE_CD 3.25308f
C8 analog_bus0 ibias0 9.96866f
C9 wind_comp_0.comparator_0.dynamic_pcell_0.DRN_NET_GJ_GATE_GH wind_comp_0.comparator_0.sg13cmos5l_inv_16_1.A 2.54903f
C10 analog_bus0 analog_bus1 6.25352f
C11 wind_comp_0.comparator_1.dynamic_pcell$7_0.DRN_NET_CF_GATE_CD wind_comp_0.comparator_1.dynamic_pcell$7_0.DRN_NET_BE_GATE_AB 5.06493f
C12 wind_comp_0.comparator_0.dynamic_pcell$2_0.DRN_NET_LM_GATE_KL wind_comp_0.comparator_0.dynamic_pcell_0.SRC_NET_IJ 3.29264f
C13 wind_comp_0.comparator_1.dynamic_pcell$2_0.DRN_NET_LM_GATE_KL vdd_1v2 10.5194f
C14 s4_an[0] analog_bus0 3.75051f
C15 wind_comp_0.comparator_1.dynamic_pcell$7_0.A_DRN vdd_1v2 3.24221f
C16 wind_comp_0.comparator_0.dynamic_pcell$7_0.A_DRN vdd_1v2 3.35931f
C17 wind_comp_0.comparator_1.dynamic_pcell_0.DRN_NET_GJ_GATE_GH wind_comp_0.comparator_1.nmos$2_0.Drain 2.84385f
C18 wind_comp_0.comparator_1.dynamic_pcell_0.SRC_NET_IJ wind_comp_0.comparator_1.dynamic_pcell$2_0.DRN_NET_LM_GATE_KL 3.29264f
C19 wind_comp_0.comparator_0.sg13cmos5l_inv_16_0.A vdd_1v2 2.59354f
C20 wind_comp_0.comparator_1.dynamic_pcell$7_0.A_DRN wind_comp_0.comparator_1.dynamic_pcell$7_0.D_DRN 12.5652f
C21 vdd_1v2 wind_comp_0.comparator_1.dynamic_pcell$7_0.D_DRN 4.3393f
C22 wind_comp_0.comparator_0.dynamic_pcell$7_0.DRN_NET_CF_GATE_CD wind_comp_0.comparator_0.dynamic_pcell$7_0.D_DRN 5.00743f
C23 analog_bus0 vdd_1v2 6.0004f
C24 wind_comp_0.comparator_1.dynamic_pcell_0.SRC_NET_IJ vdd_1v2 2.81501f
C25 s4_an[0] wind_comp_0.comparator_0.dynamic_pcell$7_0.D_DRN 3.18103f
C26 wind_comp_0.comparator_0.nmos$2_0.Drain wind_comp_0.comparator_0.dynamic_pcell_0.DRN_NET_GJ_GATE_GH 2.84385f
C27 analog_bus2 analog_bus1 6.30423f
C28 analog_bus2 enable 10.6373f
C29 analog_bus0 wind_comp_0.comparator_1.dynamic_pcell$7_0.D_DRN 3.17001f
C30 wind_comp_0.comparator_1.dynamic_pcell$7_0.SRC_NET_EF wind_comp_0.comparator_1.nmos$2_0.Drain 2.62856f
C31 wind_comp_0.comparator_1.dynamic_pcell_0.DRN_NET_GJ_GATE_GH wind_comp_0.comparator_1.dynamic_pcell$7_0.D_DRN 2.14662f
C32 analog_bus2 s4_an[0] 3.65215f
C33 wind_comp_0.comparator_0.dynamic_pcell$7_0.A_DRN wind_comp_0.comparator_0.dynamic_pcell$7_0.D_DRN 12.5652f
C34 wind_comp_0.comparator_1.dynamic_pcell$7_0.A_DRN wind_comp_0.comparator_1.dynamic_pcell$7_0.DRN_NET_BE_GATE_AB 4.7028f
C35 vdd_1v2 wind_comp_0.comparator_0.dynamic_pcell$7_0.D_DRN 4.3491f
C36 wind_comp_0.comparator_1.sg13cmos5l_inv_16_0.A vdd_1v2 2.59324f
C37 vdd_1v2 wind_comp_0.comparator_1.dynamic_pcell$7_0.DRN_NET_BE_GATE_AB 2.81935f
C38 wind_comp_0.comparator_1.dynamic_pcell$7_0.A_DRN wind_comp_0.comparator_1.sg13cmos5l_inv_16_1.A 2.18082f
C39 wind_comp_0.comparator_0.dynamic_pcell_0.DRN_NET_GJ_GATE_GH wind_comp_0.comparator_0.dynamic_pcell$7_0.D_DRN 2.14662f
C40 vdd_1v2 wind_comp_0.comparator_0.dynamic_pcell$2_0.DRN_NET_LM_GATE_KL 10.5194f
C41 wind_comp_0.comparator_1.sg13cmos5l_inv_16_1.A vdd_1v2 2.8825f
C42 wind_comp_0.comparator_0.dynamic_pcell$7_0.DRN_NET_BE_GATE_AB wind_comp_0.comparator_0.dynamic_pcell$7_0.DRN_NET_CF_GATE_CD 5.06493f
C43 analog_bus2 vdd_1v2 6.13436f
C44 wind_comp_0.comparator_0.nmos$2_0.Drain wind_comp_0.comparator_0.dynamic_pcell$2_0.DRN_NET_LM_GATE_KL 2.21668f
C45 analog_bus1 ibias0 10.3119f
C46 ibias0 enable 3.93416f
C47 analog_bus1 enable 9.39207f
C48 wind_comp_0.comparator_1.sg13cmos5l_inv_16_1.A wind_comp_0.comparator_1.dynamic_pcell_0.DRN_NET_GJ_GATE_GH 2.54903f
C49 vdd_1v2 wind_comp_0.comparator_0.dynamic_pcell_0.SRC_NET_IJ 2.813f
C50 vdd_1v2 wind_comp_0.comparator_1.dynamic_pcell$7_0.DRN_NET_CF_GATE_CD 3.24896f
C51 wind_comp_0.comparator_0.dynamic_pcell$7_0.A_DRN wind_comp_0.comparator_0.dynamic_pcell$7_0.DRN_NET_BE_GATE_AB 4.7028f
C52 vdd_1v2 wind_comp_0.comparator_0.dynamic_pcell$7_0.DRN_NET_BE_GATE_AB 2.82363f
C53 wind_comp_0.comparator_1.dynamic_pcell$7_0.DRN_NET_CF_GATE_CD wind_comp_0.comparator_1.dynamic_pcell$7_0.D_DRN 5.00762f
R0 enable enable.n11 159.688
R1 enable.n9 enable.t1 35.3051
R2 enable.n6 enable.t0 35.3043
R3 enable.n1 enable.t10 16.5863
R4 enable.n10 enable.t11 16.5863
R5 enable.n5 enable.t2 15.0022
R6 enable.n8 enable.t5 15.0022
R7 enable.n1 enable.t8 15.1275
R8 enable.n1 enable.t9 15.0005
R9 enable.n10 enable.t12 15.0005
R10 enable.n0 enable.n6 12.8903
R11 enable.n2 enable.n10 0.12986
R12 enable.n2 enable.n3 8.91724
R13 enable.n6 enable.n5 9.0005
R14 enable.n9 enable.n8 9.0005
R15 enable.n11 enable.n0 6.78408
R16 enable.n7 enable.t4 5.2628
R17 enable.n4 enable.t3 5.24447
R18 enable.n4 enable.t6 4.39106
R19 enable.n7 enable.t7 4.39106
R20 enable.n11 enable.n3 3.69968
R21 enable.n5 enable.n4 0.468833
R22 enable.n8 enable.n7 0.468833
R23 enable.t13 enable.n2 15.1275
R24 enable.n3 enable.n9 12.8903
R25 enable.n1 enable.n0 9.0466
R26 vss_1v2.n1328 vss_1v2.n1327 363006
R27 vss_1v2.n2184 vss_1v2.n626 363003
R28 vss_1v2.n1914 vss_1v2.n68 5.64921
R29 vss_1v2.n39 vss_1v2.n177 5.39332
R30 vss_1v2.n1627 vss_1v2.n38 5.87124
R31 vss_1v2.n1644 vss_1v2.n39 8.84404
R32 vss_1v2.t309 vss_1v2.t349 18.0005
R33 vss_1v2.n399 vss_1v2.t355 18.0005
R34 vss_1v2.n171 vss_1v2.n1226 18.0005
R35 vss_1v2.t328 vss_1v2.n402 18.0005
R36 vss_1v2.t326 vss_1v2.n426 18.0005
R37 vss_1v2.n2193 vss_1v2.n168 18.0005
R38 vss_1v2.n1652 vss_1v2.n39 8.74671
R39 vss_1v2.n1644 vss_1v2.n38 9.85194
R40 vss_1v2.n1523 vss_1v2.n38 17.002
R41 vss_1v2.n38 vss_1v2.n226 17.0016
R42 vss_1v2.n29 vss_1v2.n27 0.254266
R43 vss_1v2.n28 vss_1v2.n41 0.847578
R44 vss_1v2.n41 vss_1v2.n660 17.0005
R45 vss_1v2.n41 vss_1v2.n654 17.0005
R46 vss_1v2.n41 vss_1v2.n653 17.0005
R47 vss_1v2.n41 vss_1v2.n652 17.0005
R48 vss_1v2.n41 vss_1v2.n651 17.0005
R49 vss_1v2.n41 vss_1v2.n658 17.0005
R50 vss_1v2.n41 vss_1v2.n656 17.0005
R51 vss_1v2.n41 vss_1v2.n657 17.0005
R52 vss_1v2.n41 vss_1v2.n655 17.0005
R53 vss_1v2.n41 vss_1v2.n258 8.49829
R54 vss_1v2.n258 vss_1v2.n257 0.00642642
R55 vss_1v2.n41 vss_1v2.n256 5.66448
R56 vss_1v2.n41 vss_1v2.n260 8.49845
R57 vss_1v2.n41 vss_1v2.n47 1.02852
R58 vss_1v2.n79 vss_1v2.n1326 17.0005
R59 vss_1v2.n79 vss_1v2.n1018 17.0005
R60 vss_1v2.n79 vss_1v2.n1232 17.0005
R61 vss_1v2.n79 vss_1v2.n1234 17.0005
R62 vss_1v2.n79 vss_1v2.n1235 17.0005
R63 vss_1v2.n79 vss_1v2.n1237 17.0005
R64 vss_1v2.n79 vss_1v2.n1239 17.0005
R65 vss_1v2.n79 vss_1v2.n1241 17.0005
R66 vss_1v2.n79 vss_1v2.n1243 17.0005
R67 vss_1v2.n79 vss_1v2.n1245 17.0005
R68 vss_1v2.n79 vss_1v2.n1247 17.0005
R69 vss_1v2.n79 vss_1v2.n1249 17.0005
R70 vss_1v2.n79 vss_1v2.n1251 17.0005
R71 vss_1v2.n79 vss_1v2.n1253 17.0005
R72 vss_1v2.n79 vss_1v2.n1255 17.0005
R73 vss_1v2.n79 vss_1v2.n1257 17.0005
R74 vss_1v2.n79 vss_1v2.n1259 17.0005
R75 vss_1v2.n79 vss_1v2.n1261 17.0005
R76 vss_1v2.n79 vss_1v2.n1263 17.0005
R77 vss_1v2.n79 vss_1v2.n1265 17.0005
R78 vss_1v2.n79 vss_1v2.n1276 17.0005
R79 vss_1v2.n79 vss_1v2.n1278 17.0005
R80 vss_1v2.n79 vss_1v2.n1280 17.0005
R81 vss_1v2.n79 vss_1v2.n1019 17.0005
R82 vss_1v2.n79 vss_1v2.n1080 17.0005
R83 vss_1v2.n79 vss_1v2.n164 8.49837
R84 vss_1v2.n164 vss_1v2.n162 0.00625857
R85 vss_1v2.n79 vss_1v2.n1082 17.0005
R86 vss_1v2.n79 vss_1v2.n1084 17.0005
R87 vss_1v2.n79 vss_1v2.n1086 17.0005
R88 vss_1v2.n79 vss_1v2.n1088 17.0005
R89 vss_1v2.n79 vss_1v2.n1090 17.0005
R90 vss_1v2.n79 vss_1v2.n1092 17.0005
R91 vss_1v2.n79 vss_1v2.n1094 17.0005
R92 vss_1v2.n79 vss_1v2.n1096 17.0005
R93 vss_1v2.n79 vss_1v2.n1098 17.0005
R94 vss_1v2.n79 vss_1v2.n1100 17.0005
R95 vss_1v2.n79 vss_1v2.n1102 17.0005
R96 vss_1v2.n79 vss_1v2.n1104 17.0005
R97 vss_1v2.n79 vss_1v2.n1106 17.0005
R98 vss_1v2.n79 vss_1v2.n1108 17.0005
R99 vss_1v2.n79 vss_1v2.n1110 17.0005
R100 vss_1v2.n79 vss_1v2.n1119 17.0005
R101 vss_1v2.n79 vss_1v2.n1121 17.0005
R102 vss_1v2.n79 vss_1v2.n1123 17.0005
R103 vss_1v2.n79 vss_1v2.n1020 17.0005
R104 vss_1v2.n79 vss_1v2.n1022 17.0005
R105 vss_1v2.n79 vss_1v2.n1024 17.0005
R106 vss_1v2.n79 vss_1v2.n1025 17.0005
R107 vss_1v2.n79 vss_1v2.n1027 17.0005
R108 vss_1v2.n79 vss_1v2.n1031 17.0005
R109 vss_1v2.n79 vss_1v2.n1033 17.0005
R110 vss_1v2.n79 vss_1v2.n1035 17.0005
R111 vss_1v2.n79 vss_1v2.n1037 17.0005
R112 vss_1v2.n79 vss_1v2.n1039 17.0005
R113 vss_1v2.n79 vss_1v2.n1041 17.0005
R114 vss_1v2.n79 vss_1v2.n1043 17.0005
R115 vss_1v2.n79 vss_1v2.n1045 17.0005
R116 vss_1v2.n79 vss_1v2.n1047 17.0005
R117 vss_1v2.n79 vss_1v2.n1049 17.0005
R118 vss_1v2.n79 vss_1v2.n1051 17.0005
R119 vss_1v2.n79 vss_1v2.n1053 17.0005
R120 vss_1v2.n79 vss_1v2.n1064 17.0005
R121 vss_1v2.n79 vss_1v2.n1066 17.0005
R122 vss_1v2.n79 vss_1v2.n1068 17.0005
R123 vss_1v2.n271 vss_1v2.n81 17.0005
R124 vss_1v2.n269 vss_1v2.n268 0.0120155
R125 vss_1v2.n81 vss_1v2.n269 8.49837
R126 vss_1v2.n157 vss_1v2.n81 17.0005
R127 vss_1v2.n81 vss_1v2.n267 8.49852
R128 vss_1v2.n265 vss_1v2.n264 0.00625857
R129 vss_1v2.n265 vss_1v2.n81 8.49837
R130 vss_1v2.n81 vss_1v2.n218 5.66324
R131 vss_1v2.n81 vss_1v2.n1885 17.0005
R132 vss_1v2.n1893 vss_1v2.n81 17.0005
R133 vss_1v2.n81 vss_1v2.n1896 17.0005
R134 vss_1v2.n81 vss_1v2.n1883 17.0005
R135 vss_1v2.n81 vss_1v2.n1881 17.0005
R136 vss_1v2.n1897 vss_1v2.n81 17.0005
R137 vss_1v2.n81 vss_1v2.n1900 17.0005
R138 vss_1v2.n81 vss_1v2.n1879 17.0005
R139 vss_1v2.n1901 vss_1v2.n81 17.0005
R140 vss_1v2.n79 vss_1v2.n1904 17.0005
R141 vss_1v2.n79 vss_1v2.n1876 17.0005
R142 vss_1v2.n1281 vss_1v2.n81 17.0005
R143 vss_1v2.n1283 vss_1v2.n81 17.0005
R144 vss_1v2.n1284 vss_1v2.n81 17.0005
R145 vss_1v2.n1285 vss_1v2.n81 17.0005
R146 vss_1v2.n1286 vss_1v2.n81 17.0005
R147 vss_1v2.n1287 vss_1v2.n81 17.0005
R148 vss_1v2.n1288 vss_1v2.n81 17.0005
R149 vss_1v2.n1289 vss_1v2.n81 17.0005
R150 vss_1v2.n1290 vss_1v2.n81 17.0005
R151 vss_1v2.n1292 vss_1v2.n81 17.0005
R152 vss_1v2.n1293 vss_1v2.n81 17.0005
R153 vss_1v2.n1296 vss_1v2.n79 3.40021
R154 vss_1v2.n1297 vss_1v2.n81 17.0005
R155 vss_1v2.n1300 vss_1v2.n81 3.4006
R156 vss_1v2.n1301 vss_1v2.n81 17.0005
R157 vss_1v2.n1304 vss_1v2.n81 17.0005
R158 vss_1v2.n1305 vss_1v2.n81 17.0005
R159 vss_1v2.n1308 vss_1v2.n81 17.0005
R160 vss_1v2.n1311 vss_1v2.n81 17.0005
R161 vss_1v2.n1312 vss_1v2.n81 17.0005
R162 vss_1v2.n1314 vss_1v2.n81 17.0005
R163 vss_1v2.n1315 vss_1v2.n81 3.40039
R164 vss_1v2.n1316 vss_1v2.n81 17.0005
R165 vss_1v2.n1317 vss_1v2.n81 17.0005
R166 vss_1v2.n1318 vss_1v2.n81 17.0005
R167 vss_1v2.n1319 vss_1v2.n81 17.0005
R168 vss_1v2.n1322 vss_1v2.n81 17.0005
R169 vss_1v2.n1323 vss_1v2.n81 17.0005
R170 vss_1v2.n80 vss_1v2.n81 0.00460174
R171 vss_1v2.n79 vss_1v2.n1125 17.0005
R172 vss_1v2.n79 vss_1v2.n1124 17.0005
R173 vss_1v2.n79 vss_1v2.n167 8.49855
R174 vss_1v2.n167 vss_1v2.n165 0.00589388
R175 vss_1v2.n79 vss_1v2.n429 17.0005
R176 vss_1v2.n106 vss_1v2.n119 0.00589388
R177 vss_1v2.n79 vss_1v2.n101 2.82945
R178 vss_1v2.n101 vss_1v2.n121 0.0131543
R179 vss_1v2.n79 vss_1v2.n392 17.0005
R180 vss_1v2.n161 vss_1v2.n159 0.00589388
R181 vss_1v2.n79 vss_1v2.n161 8.49855
R182 vss_1v2.n79 vss_1v2.n1294 17.0005
R183 vss_1v2.n79 vss_1v2.n1295 17.0005
R184 vss_1v2.n79 vss_1v2.n1298 17.0005
R185 vss_1v2.n79 vss_1v2.n1299 17.0005
R186 vss_1v2.n79 vss_1v2.n1302 17.0005
R187 vss_1v2.n79 vss_1v2.n1303 17.0005
R188 vss_1v2.n79 vss_1v2.n428 17.0005
R189 vss_1v2.n79 vss_1v2.n1306 17.0005
R190 vss_1v2.n79 vss_1v2.n1309 17.0005
R191 vss_1v2.n79 vss_1v2.n1310 17.0005
R192 vss_1v2.n79 vss_1v2.n1313 17.0005
R193 vss_1v2.n79 vss_1v2.n180 8.49855
R194 vss_1v2.n180 vss_1v2.n178 0.00589388
R195 vss_1v2.n79 vss_1v2.n391 17.0005
R196 vss_1v2.n79 vss_1v2.n91 8.49855
R197 vss_1v2.n91 vss_1v2.n89 0.00589388
R198 vss_1v2.n79 vss_1v2.n1320 17.0005
R199 vss_1v2.n79 vss_1v2.n1321 17.0005
R200 vss_1v2.n79 vss_1v2.n111 8.4996
R201 vss_1v2.n79 vss_1v2.n1126 17.0005
R202 vss_1v2.n79 vss_1v2.n400 8.49862
R203 vss_1v2.n400 vss_1v2.n1127 0.0057562
R204 vss_1v2.n79 vss_1v2.n1130 17.0005
R205 vss_1v2.n79 vss_1v2.n1131 17.0005
R206 vss_1v2.n79 vss_1v2.n1133 17.0005
R207 vss_1v2.n79 vss_1v2.n1135 17.0005
R208 vss_1v2.n79 vss_1v2.n1136 17.0005
R209 vss_1v2.n79 vss_1v2.n274 17.0005
R210 vss_1v2.n79 vss_1v2.n152 5.6647
R211 vss_1v2.n79 vss_1v2.n1139 17.0005
R212 vss_1v2.n79 vss_1v2.n1145 17.0005
R213 vss_1v2.n79 vss_1v2.n1147 17.0005
R214 vss_1v2.n79 vss_1v2.n1149 17.0005
R215 vss_1v2.n79 vss_1v2.n1150 17.0005
R216 vss_1v2.n79 vss_1v2.n1171 17.0005
R217 vss_1v2.n79 vss_1v2.n1173 17.0005
R218 vss_1v2.n79 vss_1v2.n1175 17.0005
R219 vss_1v2.n79 vss_1v2.n172 8.49956
R220 vss_1v2.n79 vss_1v2.n97 3.38853
R221 vss_1v2.n97 vss_1v2.n96 0.016675
R222 vss_1v2.n96 vss_1v2.n98 0.0123082
R223 vss_1v2.n79 vss_1v2.n107 4.24792
R224 vss_1v2.n79 vss_1v2.n1176 17.0005
R225 vss_1v2.n79 vss_1v2.n1178 17.0005
R226 vss_1v2.n79 vss_1v2.n215 17.0005
R227 vss_1v2.n79 vss_1v2.n1073 17.0005
R228 vss_1v2.n79 vss_1v2.n1078 17.0005
R229 vss_1v2.n208 vss_1v2.n72 8.49855
R230 vss_1v2.n209 vss_1v2.n208 0.00589388
R231 vss_1v2.n1850 vss_1v2.n72 17.0005
R232 vss_1v2.n1134 vss_1v2.n72 17.0005
R233 vss_1v2.n1132 vss_1v2.n72 17.0005
R234 vss_1v2.n1156 vss_1v2.n72 17.0005
R235 vss_1v2.n1129 vss_1v2.n72 17.0005
R236 vss_1v2.n1162 vss_1v2.n72 17.0005
R237 vss_1v2.n1127 vss_1v2.n72 17.0005
R238 vss_1v2.n1148 vss_1v2.n72 17.0005
R239 vss_1v2.n1146 vss_1v2.n72 17.0005
R240 vss_1v2.n1144 vss_1v2.n72 17.0005
R241 vss_1v2.n1138 vss_1v2.n72 17.0005
R242 vss_1v2.n150 vss_1v2.n151 0.00824997
R243 vss_1v2.n151 vss_1v2.n72 5.66445
R244 vss_1v2.n1137 vss_1v2.n72 17.0005
R245 vss_1v2.n96 vss_1v2.n72 8.49956
R246 vss_1v2.n170 vss_1v2.n72 8.49855
R247 vss_1v2.n171 vss_1v2.n170 0.00590029
R248 vss_1v2.n1229 vss_1v2.n72 17.0005
R249 vss_1v2.n1174 vss_1v2.n72 17.0005
R250 vss_1v2.n1172 vss_1v2.n72 17.0005
R251 vss_1v2.n1170 vss_1v2.n72 17.0005
R252 vss_1v2.n1177 vss_1v2.n15 17.0005
R253 vss_1v2.n15 vss_1v2.n1695 17.0005
R254 vss_1v2.n15 vss_1v2.n1694 17.0005
R255 vss_1v2.n1692 vss_1v2.n15 17.0005
R256 vss_1v2.n15 vss_1v2.n108 17.0005
R257 vss_1v2.n98 vss_1v2.n108 0.0154752
R258 vss_1v2.n72 vss_1v2.n100 0.0865127
R259 vss_1v2.n73 vss_1v2.n15 0.00132726
R260 vss_1v2.n1687 vss_1v2.n72 3.40013
R261 vss_1v2.n1609 vss_1v2.n1608 17.0005
R262 vss_1v2.n1609 vss_1v2.n1605 17.0005
R263 vss_1v2.n1609 vss_1v2.n1544 17.0005
R264 vss_1v2.n1609 vss_1v2.n393 17.0005
R265 vss_1v2.n1609 vss_1v2.n1600 17.0005
R266 vss_1v2.n1609 vss_1v2.n394 0.761073
R267 vss_1v2.n1609 vss_1v2.n1545 17.0005
R268 vss_1v2.n1609 vss_1v2.t283 17.0005
R269 vss_1v2.n1609 vss_1v2.n1547 17.0005
R270 vss_1v2.n1609 vss_1v2.n1599 17.0005
R271 vss_1v2.n1609 vss_1v2.n1548 17.0005
R272 vss_1v2.n1609 vss_1v2.n1598 17.0005
R273 vss_1v2.n1609 vss_1v2.n1549 17.0005
R274 vss_1v2.n1609 vss_1v2.n1597 17.0005
R275 vss_1v2.n1609 vss_1v2.n1550 17.0005
R276 vss_1v2.n1609 vss_1v2.n1595 17.0005
R277 vss_1v2.n1609 vss_1v2.n1552 17.0005
R278 vss_1v2.n1609 vss_1v2.n1594 17.0005
R279 vss_1v2.n1609 vss_1v2.n1554 17.0005
R280 vss_1v2.n1609 vss_1v2.n1592 17.0005
R281 vss_1v2.n1609 vss_1v2.n1556 17.0005
R282 vss_1v2.n1610 vss_1v2.n1609 17.0005
R283 vss_1v2.n1609 vss_1v2.n1557 17.0005
R284 vss_1v2.n1609 vss_1v2.n1590 17.0005
R285 vss_1v2.n1609 vss_1v2.n1558 17.0005
R286 vss_1v2.n1609 vss_1v2.n1589 17.0005
R287 vss_1v2.n1609 vss_1v2.n1559 17.0005
R288 vss_1v2.n1609 vss_1v2.n1588 17.0005
R289 vss_1v2.n1609 vss_1v2.n1562 17.0005
R290 vss_1v2.n1609 vss_1v2.n1587 17.0005
R291 vss_1v2.n1609 vss_1v2.n1563 17.0005
R292 vss_1v2.n1609 vss_1v2.n1585 17.0005
R293 vss_1v2.n1609 vss_1v2.n1564 17.0005
R294 vss_1v2.n1609 vss_1v2.n1583 17.0005
R295 vss_1v2.n1609 vss_1v2.n1566 17.0005
R296 vss_1v2.n1609 vss_1v2.n1581 17.0005
R297 vss_1v2.n1609 vss_1v2.n1568 17.0005
R298 vss_1v2.n1609 vss_1v2.n1580 17.0005
R299 vss_1v2.n1609 vss_1v2.n1569 17.0005
R300 vss_1v2.n1609 vss_1v2.n1579 17.0005
R301 vss_1v2.n1609 vss_1v2.n1570 17.0005
R302 vss_1v2.n1609 vss_1v2.n1578 17.0005
R303 vss_1v2.n1609 vss_1v2.n1571 17.0005
R304 vss_1v2.n1609 vss_1v2.n1576 17.0005
R305 vss_1v2.n1609 vss_1v2.n1572 17.0005
R306 vss_1v2.n1609 vss_1v2.n1574 17.0005
R307 vss_1v2.n1609 vss_1v2.n1509 17.0005
R308 vss_1v2.n140 vss_1v2.t380 2.4794
R309 vss_1v2.n1916 vss_1v2.n1007 17.0005
R310 vss_1v2.n1916 vss_1v2.n1005 17.0005
R311 vss_1v2.n1916 vss_1v2.n1006 17.0005
R312 vss_1v2.n1971 vss_1v2.n1970 17.0005
R313 vss_1v2.n1971 vss_1v2.n1920 17.0005
R314 vss_1v2.n1971 vss_1v2.t189 17.0005
R315 vss_1v2.n1971 vss_1v2.n1921 17.0005
R316 vss_1v2.n1971 vss_1v2.n1969 17.0005
R317 vss_1v2.n1971 vss_1v2.n1922 17.0005
R318 vss_1v2.n1971 vss_1v2.n1968 17.0005
R319 vss_1v2.n1971 vss_1v2.n1923 17.0005
R320 vss_1v2.n1971 vss_1v2.n840 17.0005
R321 vss_1v2.n1971 vss_1v2.n1924 17.0005
R322 vss_1v2.n1971 vss_1v2.n1967 17.0005
R323 vss_1v2.n1971 vss_1v2.n1925 17.0005
R324 vss_1v2.n1971 vss_1v2.n1966 17.0005
R325 vss_1v2.n1971 vss_1v2.n1926 17.0005
R326 vss_1v2.n1971 vss_1v2.n454 17.0005
R327 vss_1v2.n1971 vss_1v2.n1927 17.0005
R328 vss_1v2.n1971 vss_1v2.n1965 17.0005
R329 vss_1v2.n1971 vss_1v2.n1928 17.0005
R330 vss_1v2.n1971 vss_1v2.n1964 17.0005
R331 vss_1v2.n1971 vss_1v2.n1929 17.0005
R332 vss_1v2.n1971 vss_1v2.n1963 17.0005
R333 vss_1v2.n1971 vss_1v2.n1930 17.0005
R334 vss_1v2.n1971 vss_1v2.n1951 17.0005
R335 vss_1v2.n1971 vss_1v2.n1932 17.0005
R336 vss_1v2.n1971 vss_1v2.n1950 17.0005
R337 vss_1v2.n1971 vss_1v2.n972 17.0005
R338 vss_1v2.n1971 vss_1v2.n1949 17.0005
R339 vss_1v2.n1971 vss_1v2.n1933 17.0005
R340 vss_1v2.n1971 vss_1v2.n1948 17.0005
R341 vss_1v2.n1971 vss_1v2.n1934 17.0005
R342 vss_1v2.n1971 vss_1v2.n1947 17.0005
R343 vss_1v2.n1971 vss_1v2.n478 17.0005
R344 vss_1v2.n1971 vss_1v2.n1946 17.0005
R345 vss_1v2.n1971 vss_1v2.n1935 17.0005
R346 vss_1v2.n1971 vss_1v2.n1945 17.0005
R347 vss_1v2.n1971 vss_1v2.n1936 17.0005
R348 vss_1v2.n1971 vss_1v2.n1944 17.0005
R349 vss_1v2.n1971 vss_1v2.n1937 17.0005
R350 vss_1v2.n1971 vss_1v2.n1943 17.0005
R351 vss_1v2.n1971 vss_1v2.t275 17.0005
R352 vss_1v2.n1971 vss_1v2.n295 17.0005
R353 vss_1v2.n1971 vss_1v2.n1939 17.0005
R354 vss_1v2.n396 vss_1v2.n1971 0.760915
R355 vss_1v2.n1971 vss_1v2.n1942 17.0005
R356 vss_1v2.n1971 vss_1v2.n395 17.0005
R357 vss_1v2.n1971 vss_1v2.n1940 17.0005
R358 vss_1v2.n1971 vss_1v2.n1941 17.0005
R359 vss_1v2.n39 vss_1v2.n381 3.39707
R360 vss_1v2.n39 vss_1v2.n380 3.39036
R361 vss_1v2.n39 vss_1v2.n379 3.38788
R362 vss_1v2.n39 vss_1v2.n141 5.65782
R363 vss_1v2.n39 vss_1v2.n61 2.67262
R364 vss_1v2.n39 vss_1v2.n377 5.6577
R365 vss_1v2.n39 vss_1v2.n376 5.65676
R366 vss_1v2.n39 vss_1v2.n55 2.73756
R367 vss_1v2.n39 vss_1v2.n375 5.65634
R368 vss_1v2.n39 vss_1v2.n59 2.91505
R369 vss_1v2.n39 vss_1v2.n57 3.16114
R370 vss_1v2.n39 vss_1v2.n56 3.1611
R371 vss_1v2.n39 vss_1v2.n53 1.36054
R372 vss_1v2.n39 vss_1v2.n374 5.65547
R373 vss_1v2.n39 vss_1v2.n373 5.65822
R374 vss_1v2.n39 vss_1v2.n372 5.65516
R375 vss_1v2.n39 vss_1v2.n371 5.65485
R376 vss_1v2.n39 vss_1v2.n370 5.65454
R377 vss_1v2.n39 vss_1v2.n13 0.468526
R378 vss_1v2.n39 vss_1v2.n369 5.65423
R379 vss_1v2.n39 vss_1v2.n922 17.0005
R380 vss_1v2.n39 vss_1v2.n368 5.65392
R381 vss_1v2.n39 vss_1v2.n940 17.0005
R382 vss_1v2.n39 vss_1v2.n367 5.65361
R383 vss_1v2.n39 vss_1v2.n923 17.0005
R384 vss_1v2.n39 vss_1v2.n366 5.6533
R385 vss_1v2.n39 vss_1v2.n937 17.0005
R386 vss_1v2.n39 vss_1v2.n365 5.65299
R387 vss_1v2.n39 vss_1v2.n924 17.0005
R388 vss_1v2.n39 vss_1v2.n364 5.66535
R389 vss_1v2.n39 vss_1v2.n934 17.0005
R390 vss_1v2.n39 vss_1v2.n363 5.65269
R391 vss_1v2.n39 vss_1v2.n925 17.0005
R392 vss_1v2.n39 vss_1v2.n362 5.65238
R393 vss_1v2.n39 vss_1v2.n931 17.0005
R394 vss_1v2.n39 vss_1v2.n361 5.65208
R395 vss_1v2.n39 vss_1v2.n926 17.0005
R396 vss_1v2.n39 vss_1v2.n928 17.0005
R397 vss_1v2.n39 vss_1v2.n62 2.91562
R398 vss_1v2.n39 vss_1v2.n378 5.65904
R399 vss_1v2.n39 vss_1v2.n54 1.07455
R400 vss_1v2.n1604 vss_1v2.n39 17.0005
R401 vss_1v2.t263 vss_1v2.n39 8.49846
R402 vss_1v2.n38 vss_1v2.n253 5.65118
R403 vss_1v2.n38 vss_1v2.n251 5.6511
R404 vss_1v2.n38 vss_1v2.n246 5.65167
R405 vss_1v2.n38 vss_1v2.n227 17.0005
R406 vss_1v2.n38 vss_1v2.n1529 17.0005
R407 vss_1v2.n1530 vss_1v2.n38 17.0005
R408 vss_1v2.n38 vss_1v2.n231 5.65191
R409 vss_1v2.n38 vss_1v2.t366 5.65164
R410 vss_1v2.n38 vss_1v2.n232 5.66717
R411 vss_1v2.n38 vss_1v2.n255 5.667
R412 vss_1v2.n38 vss_1v2.n254 5.66565
R413 vss_1v2.n38 vss_1v2.n234 5.66704
R414 vss_1v2.n38 vss_1v2.n252 5.6663
R415 vss_1v2.n38 vss_1v2.n235 5.66627
R416 vss_1v2.n38 vss_1v2.n236 5.66502
R417 vss_1v2.n38 vss_1v2.n250 5.66578
R418 vss_1v2.n38 vss_1v2.n237 5.66372
R419 vss_1v2.n38 vss_1v2.n249 5.66235
R420 vss_1v2.n38 vss_1v2.n238 5.65795
R421 vss_1v2.n38 vss_1v2.n360 5.65261
R422 vss_1v2.n38 vss_1v2.t294 5.66359
R423 vss_1v2.n38 vss_1v2.n248 5.66424
R424 vss_1v2.n38 vss_1v2.n239 5.66547
R425 vss_1v2.n38 vss_1v2.t292 5.66149
R426 vss_1v2.n38 vss_1v2.n247 5.66261
R427 vss_1v2.n38 vss_1v2.t290 5.66547
R428 vss_1v2.n38 vss_1v2.n241 5.66389
R429 vss_1v2.n38 vss_1v2.t288 5.66026
R430 vss_1v2.n38 vss_1v2.n242 5.66255
R431 vss_1v2.n38 vss_1v2.n245 5.66608
R432 vss_1v2.n38 vss_1v2.t286 5.66289
R433 vss_1v2.n38 vss_1v2.n243 5.66442
R434 vss_1v2.n38 vss_1v2.n1676 17.0005
R435 vss_1v2.n1665 vss_1v2.n38 17.0005
R436 vss_1v2.n1667 vss_1v2.n38 17.0005
R437 vss_1v2.n38 vss_1v2.n1663 17.0005
R438 vss_1v2.n38 vss_1v2.t364 5.65279
R439 vss_1v2.n38 vss_1v2.n233 5.66561
R440 vss_1v2.n38 vss_1v2.n240 5.66543
R441 vss_1v2.n38 vss_1v2.n244 5.66583
R442 vss_1v2.n18 vss_1v2.n351 8.49967
R443 vss_1v2.n18 vss_1v2.n352 8.49992
R444 vss_1v2.n18 vss_1v2.n353 8.50017
R445 vss_1v2.n18 vss_1v2.n354 8.50117
R446 vss_1v2.n18 vss_1v2.n355 8.49995
R447 vss_1v2.n18 vss_1v2.n356 8.50022
R448 vss_1v2.n18 vss_1v2.n973 8.50087
R449 vss_1v2.n18 vss_1v2.n357 8.50047
R450 vss_1v2.n18 vss_1v2.n358 8.50147
R451 vss_1v2.n18 vss_1v2.n1919 17.0005
R452 vss_1v2.n18 vss_1v2.t261 8.49846
R453 vss_1v2.n19 vss_1v2.t107 0.278306
R454 vss_1v2.n18 vss_1v2.n944 17.0005
R455 vss_1v2.n18 vss_1v2.n947 17.0005
R456 vss_1v2.n18 vss_1v2.n945 17.0005
R457 vss_1v2.n18 vss_1v2.n946 17.0005
R458 vss_1v2.n18 vss_1v2.n14 0.446319
R459 vss_1v2.n14 vss_1v2.n13 0.00912784
R460 vss_1v2.n18 vss_1v2.n1002 5.65726
R461 vss_1v2.n18 vss_1v2.n1001 5.65746
R462 vss_1v2.n18 vss_1v2.n1000 5.65767
R463 vss_1v2.n18 vss_1v2.n999 5.65787
R464 vss_1v2.n18 vss_1v2.n998 5.66482
R465 vss_1v2.n18 vss_1v2.n997 5.65808
R466 vss_1v2.n18 vss_1v2.n996 5.65828
R467 vss_1v2.n18 vss_1v2.n995 5.65849
R468 vss_1v2.n18 vss_1v2.n994 5.6587
R469 vss_1v2.n18 vss_1v2.n993 5.65891
R470 vss_1v2.n18 vss_1v2.n992 5.65912
R471 vss_1v2.n18 vss_1v2.n991 5.65932
R472 vss_1v2.n18 vss_1v2.n990 5.65954
R473 vss_1v2.n18 vss_1v2.n989 5.65975
R474 vss_1v2.n18 vss_1v2.n988 5.65996
R475 vss_1v2.n18 vss_1v2.n987 5.66017
R476 vss_1v2.n18 vss_1v2.n986 5.6684
R477 vss_1v2.n18 vss_1v2.n985 5.66038
R478 vss_1v2.n18 vss_1v2.n984 5.66059
R479 vss_1v2.n18 vss_1v2.n982 5.66081
R480 vss_1v2.n18 vss_1v2.n981 5.66102
R481 vss_1v2.n18 vss_1v2.n980 5.66123
R482 vss_1v2.n18 vss_1v2.n979 5.66145
R483 vss_1v2.n18 vss_1v2.n978 5.66167
R484 vss_1v2.n18 vss_1v2.n976 5.66188
R485 vss_1v2.n18 vss_1v2.n975 5.6621
R486 vss_1v2.n18 vss_1v2.n974 5.66231
R487 vss_1v2.n18 vss_1v2.n221 5.66581
R488 vss_1v2.n18 vss_1v2.n350 8.50021
R489 vss_1v2.n18 vss_1v2.n348 8.49978
R490 vss_1v2.n18 vss_1v2.n345 8.49953
R491 vss_1v2.n18 vss_1v2.n349 8.50174
R492 vss_1v2.n18 vss_1v2.n346 3.39555
R493 vss_1v2.t107 vss_1v2.n136 17.0005
R494 vss_1v2.n273 vss_1v2.t107 5.62647
R495 vss_1v2.t107 vss_1v2.n344 5.65975
R496 vss_1v2.t107 vss_1v2.n343 5.65996
R497 vss_1v2.t107 vss_1v2.t316 5.66017
R498 vss_1v2.t107 vss_1v2.n342 5.66038
R499 vss_1v2.t107 vss_1v2.n341 5.66059
R500 vss_1v2.t107 vss_1v2.t314 5.66081
R501 vss_1v2.t107 vss_1v2.n340 5.66102
R502 vss_1v2.t107 vss_1v2.n339 5.66681
R503 vss_1v2.t107 vss_1v2.t312 5.66124
R504 vss_1v2.t107 vss_1v2.n338 5.66145
R505 vss_1v2.t107 vss_1v2.n337 5.66167
R506 vss_1v2.t107 vss_1v2.t310 5.66676
R507 vss_1v2.t107 vss_1v2.n336 5.66188
R508 vss_1v2.t107 vss_1v2.n335 5.6621
R509 vss_1v2.t107 vss_1v2.t307 5.66232
R510 vss_1v2.t107 vss_1v2.n334 5.66605
R511 vss_1v2.t107 vss_1v2.n333 5.66253
R512 vss_1v2.t107 vss_1v2.n332 5.66275
R513 vss_1v2.t107 vss_1v2.n331 5.66297
R514 vss_1v2.t107 vss_1v2.n330 5.66319
R515 vss_1v2.t107 vss_1v2.n329 5.6634
R516 vss_1v2.t107 vss_1v2.n328 5.66362
R517 vss_1v2.t107 vss_1v2.n327 5.66384
R518 vss_1v2.t107 vss_1v2.n326 5.66406
R519 vss_1v2.t107 vss_1v2.n325 5.66428
R520 vss_1v2.t107 vss_1v2.n324 5.6645
R521 vss_1v2.t107 vss_1v2.n323 5.66472
R522 vss_1v2.t107 vss_1v2.n322 5.66494
R523 vss_1v2.t107 vss_1v2.t254 5.66517
R524 vss_1v2.t107 vss_1v2.n321 5.66539
R525 vss_1v2.t107 vss_1v2.n320 5.66561
R526 vss_1v2.t107 vss_1v2.t252 5.66583
R527 vss_1v2.t107 vss_1v2.n319 5.66851
R528 vss_1v2.n43 vss_1v2.n72 0.0402137
R529 vss_1v2.n424 vss_1v2.n72 5.66349
R530 vss_1v2.n422 vss_1v2.n72 5.66349
R531 vss_1v2.n420 vss_1v2.n72 5.66349
R532 vss_1v2.n418 vss_1v2.n72 5.66349
R533 vss_1v2.n416 vss_1v2.n72 5.66349
R534 vss_1v2.n414 vss_1v2.n72 5.66349
R535 vss_1v2.n412 vss_1v2.n72 5.66349
R536 vss_1v2.n1422 vss_1v2.n72 17.0005
R537 vss_1v2.n1417 vss_1v2.n72 17.0005
R538 vss_1v2.n1413 vss_1v2.n72 17.0005
R539 vss_1v2.n1411 vss_1v2.n72 17.0005
R540 vss_1v2.n1407 vss_1v2.n72 17.0005
R541 vss_1v2.n1405 vss_1v2.n72 17.0005
R542 vss_1v2.n1401 vss_1v2.n72 17.0005
R543 vss_1v2.n1399 vss_1v2.n72 17.0005
R544 vss_1v2.n1395 vss_1v2.n72 17.0005
R545 vss_1v2.n1393 vss_1v2.n72 17.0005
R546 vss_1v2.n1389 vss_1v2.n72 17.0005
R547 vss_1v2.n1387 vss_1v2.n72 17.0005
R548 vss_1v2.n1383 vss_1v2.n72 17.0005
R549 vss_1v2.n1381 vss_1v2.n72 17.0005
R550 vss_1v2.n1378 vss_1v2.n72 17.0005
R551 vss_1v2.n1376 vss_1v2.n72 17.0005
R552 vss_1v2.n1372 vss_1v2.n72 17.0005
R553 vss_1v2.n1370 vss_1v2.n72 17.0005
R554 vss_1v2.n1366 vss_1v2.n72 17.0005
R555 vss_1v2.n1364 vss_1v2.n72 17.0005
R556 vss_1v2.n1360 vss_1v2.n72 17.0005
R557 vss_1v2.n1358 vss_1v2.n72 17.0005
R558 vss_1v2.n1354 vss_1v2.n72 17.0005
R559 vss_1v2.n1352 vss_1v2.n72 17.0005
R560 vss_1v2.n1349 vss_1v2.n72 17.0005
R561 vss_1v2.n1347 vss_1v2.n72 17.0005
R562 vss_1v2.n1343 vss_1v2.n72 17.0005
R563 vss_1v2.n228 vss_1v2.n72 8.49855
R564 vss_1v2.n230 vss_1v2.n228 0.00589388
R565 vss_1v2.n1865 vss_1v2.n72 17.0005
R566 vss_1v2.n129 vss_1v2.n72 8.49855
R567 vss_1v2.n131 vss_1v2.n129 0.00589388
R568 vss_1v2.n1861 vss_1v2.n72 17.0005
R569 vss_1v2.n1858 vss_1v2.n72 17.0005
R570 vss_1v2.n1331 vss_1v2.n72 17.0005
R571 vss_1v2.n411 vss_1v2.n72 17.0005
R572 vss_1v2.n1854 vss_1v2.n72 17.0005
R573 vss_1v2.n72 vss_1v2.n51 0.0473063
R574 vss_1v2.n1683 vss_1v2.n15 17.0005
R575 vss_1v2.n74 vss_1v2.n72 0.0571713
R576 vss_1v2.n1681 vss_1v2.n15 17.0005
R577 vss_1v2.n1678 vss_1v2.n15 17.0005
R578 vss_1v2.n1481 vss_1v2.n15 17.0005
R579 vss_1v2.n1479 vss_1v2.n15 17.0005
R580 vss_1v2.n1476 vss_1v2.n72 3.40022
R581 vss_1v2.n1474 vss_1v2.n15 17.0005
R582 vss_1v2.n1471 vss_1v2.n15 17.0005
R583 vss_1v2.n1469 vss_1v2.n15 17.0005
R584 vss_1v2.n1467 vss_1v2.n15 17.0005
R585 vss_1v2.n1465 vss_1v2.n15 17.0005
R586 vss_1v2.n1463 vss_1v2.n15 17.0005
R587 vss_1v2.n1607 vss_1v2.n15 17.0005
R588 vss_1v2.n1460 vss_1v2.n15 17.0005
R589 vss_1v2.n1458 vss_1v2.n15 17.0005
R590 vss_1v2.n1456 vss_1v2.n72 3.40022
R591 vss_1v2.n1545 vss_1v2.n72 3.40036
R592 vss_1v2.n1453 vss_1v2.n15 17.0005
R593 vss_1v2.n1451 vss_1v2.n15 17.0005
R594 vss_1v2.n1546 vss_1v2.n15 17.0005
R595 vss_1v2.n1448 vss_1v2.n15 17.0005
R596 vss_1v2.n0 vss_1v2.n15 0.764007
R597 vss_1v2.n1446 vss_1v2.n15 17.0005
R598 vss_1v2.n938 vss_1v2.n15 17.0005
R599 vss_1v2.n1444 vss_1v2.n15 17.0005
R600 vss_1v2.n939 vss_1v2.n15 17.0005
R601 vss_1v2.n1442 vss_1v2.n15 17.0005
R602 vss_1v2.n935 vss_1v2.n15 17.0005
R603 vss_1v2.n1440 vss_1v2.n15 17.0005
R604 vss_1v2.n936 vss_1v2.n15 17.0005
R605 vss_1v2.n1438 vss_1v2.n72 3.40013
R606 vss_1v2.n932 vss_1v2.n15 17.0005
R607 vss_1v2.n1596 vss_1v2.n15 17.0005
R608 vss_1v2.n933 vss_1v2.n15 17.0005
R609 vss_1v2.n1435 vss_1v2.n15 17.0005
R610 vss_1v2.n929 vss_1v2.n15 17.0005
R611 vss_1v2.n1433 vss_1v2.n15 17.0005
R612 vss_1v2.n930 vss_1v2.n15 17.0005
R613 vss_1v2.n1431 vss_1v2.n15 17.0005
R614 vss_1v2.n927 vss_1v2.n15 17.0005
R615 vss_1v2.n1624 vss_1v2.n15 17.0005
R616 vss_1v2.n1551 vss_1v2.n15 17.0005
R617 vss_1v2.n1593 vss_1v2.n15 17.0005
R618 vss_1v2.n1553 vss_1v2.n15 17.0005
R619 vss_1v2.n1426 vss_1v2.n15 17.0005
R620 vss_1v2.n1591 vss_1v2.n72 3.40047
R621 vss_1v2.n1555 vss_1v2.n15 17.0005
R622 vss_1v2.n1420 vss_1v2.n15 17.0005
R623 vss_1v2.t367 vss_1v2.n15 17.0005
R624 vss_1v2.n1482 vss_1v2.n15 17.0005
R625 vss_1v2.n1483 vss_1v2.n15 17.0005
R626 vss_1v2.t365 vss_1v2.n15 17.0005
R627 vss_1v2.n1484 vss_1v2.n15 17.0005
R628 vss_1v2.n1485 vss_1v2.n15 17.0005
R629 vss_1v2.t362 vss_1v2.n15 17.0005
R630 vss_1v2.n1487 vss_1v2.n15 17.0005
R631 vss_1v2.n1488 vss_1v2.n15 17.0005
R632 vss_1v2.n1586 vss_1v2.n15 17.0005
R633 vss_1v2.n1489 vss_1v2.n15 17.0005
R634 vss_1v2.n1490 vss_1v2.n15 17.0005
R635 vss_1v2.n1584 vss_1v2.n15 17.0005
R636 vss_1v2.n1491 vss_1v2.n15 17.0005
R637 vss_1v2.n1492 vss_1v2.n72 3.40041
R638 vss_1v2.n1582 vss_1v2.n15 17.0005
R639 vss_1v2.n1565 vss_1v2.n15 17.0005
R640 vss_1v2.n1493 vss_1v2.n15 17.0005
R641 vss_1v2.n1494 vss_1v2.n15 17.0005
R642 vss_1v2.n1567 vss_1v2.n15 17.0005
R643 vss_1v2.n1495 vss_1v2.n15 17.0005
R644 vss_1v2.n1496 vss_1v2.n15 17.0005
R645 vss_1v2.n1569 vss_1v2.n15 17.0005
R646 vss_1v2.n1497 vss_1v2.n15 17.0005
R647 vss_1v2.n1498 vss_1v2.n15 17.0005
R648 vss_1v2.n1499 vss_1v2.n15 17.0005
R649 vss_1v2.n1577 vss_1v2.n15 17.0005
R650 vss_1v2.n1500 vss_1v2.n15 17.0005
R651 vss_1v2.n1501 vss_1v2.n15 17.0005
R652 vss_1v2.n1575 vss_1v2.n72 3.4003
R653 vss_1v2.n1502 vss_1v2.n15 17.0005
R654 vss_1v2.n1503 vss_1v2.n15 17.0005
R655 vss_1v2.n1573 vss_1v2.n15 17.0005
R656 vss_1v2.n1508 vss_1v2.n72 3.4005
R657 vss_1v2.n1328 vss_1v2.n15 17.0005
R658 vss_1v2.n148 vss_1v2.n118 8.49855
R659 vss_1v2.n118 vss_1v2.n117 0.00589388
R660 vss_1v2.n148 vss_1v2.n403 17.0005
R661 vss_1v2.n109 vss_1v2.n124 0.00589388
R662 vss_1v2.n104 vss_1v2.n105 0.00691157
R663 vss_1v2.n99 vss_1v2.n104 0.00610573
R664 vss_1v2.n94 vss_1v2.n95 0.00693299
R665 vss_1v2.n93 vss_1v2.n94 0.00938727
R666 vss_1v2.n92 vss_1v2.n93 0.00936585
R667 vss_1v2.n148 vss_1v2.n92 1.6856
R668 vss_1v2.n148 vss_1v2.n731 17.0005
R669 vss_1v2.n148 vss_1v2.n838 17.0005
R670 vss_1v2.n148 vss_1v2.n732 17.0005
R671 vss_1v2.n148 vss_1v2.n836 17.0005
R672 vss_1v2.n148 vss_1v2.n733 17.0005
R673 vss_1v2.n148 vss_1v2.n834 17.0005
R674 vss_1v2.n148 vss_1v2.n734 17.0005
R675 vss_1v2.n148 vss_1v2.n832 17.0005
R676 vss_1v2.n148 vss_1v2.n735 17.0005
R677 vss_1v2.n148 vss_1v2.n830 17.0005
R678 vss_1v2.n148 vss_1v2.n736 17.0005
R679 vss_1v2.n148 vss_1v2.n828 17.0005
R680 vss_1v2.n148 vss_1v2.n737 17.0005
R681 vss_1v2.n148 vss_1v2.n826 17.0005
R682 vss_1v2.n148 vss_1v2.n738 17.0005
R683 vss_1v2.n148 vss_1v2.n824 17.0005
R684 vss_1v2.n148 vss_1v2.n739 17.0005
R685 vss_1v2.n148 vss_1v2.n822 17.0005
R686 vss_1v2.n148 vss_1v2.n740 17.0005
R687 vss_1v2.n148 vss_1v2.n820 17.0005
R688 vss_1v2.n148 vss_1v2.n741 17.0005
R689 vss_1v2.n148 vss_1v2.n818 17.0005
R690 vss_1v2.n148 vss_1v2.n742 17.0005
R691 vss_1v2.n148 vss_1v2.n816 17.0005
R692 vss_1v2.n148 vss_1v2.n743 17.0005
R693 vss_1v2.n148 vss_1v2.n815 17.0005
R694 vss_1v2.n148 vss_1v2.n744 17.0005
R695 vss_1v2.n148 vss_1v2.n814 17.0005
R696 vss_1v2.n148 vss_1v2.n745 17.0005
R697 vss_1v2.n148 vss_1v2.n813 17.0005
R698 vss_1v2.n148 vss_1v2.n746 17.0005
R699 vss_1v2.n148 vss_1v2.n812 17.0005
R700 vss_1v2.n148 vss_1v2.n747 17.0005
R701 vss_1v2.n148 vss_1v2.n811 17.0005
R702 vss_1v2.n148 vss_1v2.n748 17.0005
R703 vss_1v2.n148 vss_1v2.n810 17.0005
R704 vss_1v2.n148 vss_1v2.n749 17.0005
R705 vss_1v2.n148 vss_1v2.n809 17.0005
R706 vss_1v2.n148 vss_1v2.n750 17.0005
R707 vss_1v2.n148 vss_1v2.n808 17.0005
R708 vss_1v2.n148 vss_1v2.n751 17.0005
R709 vss_1v2.n148 vss_1v2.n807 17.0005
R710 vss_1v2.n148 vss_1v2.n752 17.0005
R711 vss_1v2.n148 vss_1v2.n806 17.0005
R712 vss_1v2.n148 vss_1v2.n753 17.0005
R713 vss_1v2.n148 vss_1v2.n805 17.0005
R714 vss_1v2.n148 vss_1v2.n754 17.0005
R715 vss_1v2.n148 vss_1v2.n804 17.0005
R716 vss_1v2.n148 vss_1v2.n755 17.0005
R717 vss_1v2.n148 vss_1v2.n803 17.0005
R718 vss_1v2.n148 vss_1v2.n756 17.0005
R719 vss_1v2.n148 vss_1v2.n802 17.0005
R720 vss_1v2.n148 vss_1v2.n757 17.0005
R721 vss_1v2.n148 vss_1v2.n801 17.0005
R722 vss_1v2.n148 vss_1v2.n758 17.0005
R723 vss_1v2.n148 vss_1v2.n800 17.0005
R724 vss_1v2.n148 vss_1v2.n759 17.0005
R725 vss_1v2.n148 vss_1v2.n799 17.0005
R726 vss_1v2.n148 vss_1v2.n760 17.0005
R727 vss_1v2.n148 vss_1v2.n798 17.0005
R728 vss_1v2.n148 vss_1v2.n761 17.0005
R729 vss_1v2.n148 vss_1v2.n50 0.0472357
R730 vss_1v2.n50 vss_1v2.n13 0.535595
R731 vss_1v2.n50 vss_1v2.n949 1.43213
R732 vss_1v2.n2185 vss_1v2.n45 17.0005
R733 vss_1v2.n792 vss_1v2.n45 17.0005
R734 vss_1v2.n845 vss_1v2.n45 17.0005
R735 vss_1v2.n791 vss_1v2.n45 17.0005
R736 vss_1v2.n844 vss_1v2.n45 17.0005
R737 vss_1v2.n790 vss_1v2.n45 17.0005
R738 vss_1v2.n843 vss_1v2.n45 17.0005
R739 vss_1v2.n789 vss_1v2.n45 17.0005
R740 vss_1v2.n842 vss_1v2.n45 17.0005
R741 vss_1v2.n788 vss_1v2.n45 17.0005
R742 vss_1v2.n841 vss_1v2.n45 17.0005
R743 vss_1v2.n787 vss_1v2.n45 17.0005
R744 vss_1v2.n840 vss_1v2.n45 17.0005
R745 vss_1v2.n786 vss_1v2.n45 17.0005
R746 vss_1v2.n839 vss_1v2.n45 17.0005
R747 vss_1v2.n785 vss_1v2.n45 17.0005
R748 vss_1v2.n837 vss_1v2.n45 17.0005
R749 vss_1v2.n784 vss_1v2.n45 17.0005
R750 vss_1v2.n835 vss_1v2.n45 17.0005
R751 vss_1v2.n783 vss_1v2.n45 17.0005
R752 vss_1v2.n833 vss_1v2.n45 17.0005
R753 vss_1v2.n782 vss_1v2.n45 17.0005
R754 vss_1v2.n831 vss_1v2.n45 17.0005
R755 vss_1v2.n781 vss_1v2.n45 17.0005
R756 vss_1v2.n829 vss_1v2.n45 17.0005
R757 vss_1v2.n780 vss_1v2.n45 17.0005
R758 vss_1v2.n827 vss_1v2.n45 17.0005
R759 vss_1v2.n779 vss_1v2.n45 17.0005
R760 vss_1v2.n825 vss_1v2.n149 3.39972
R761 vss_1v2.n778 vss_1v2.n45 17.0005
R762 vss_1v2.n823 vss_1v2.n45 17.0005
R763 vss_1v2.n777 vss_1v2.n45 17.0005
R764 vss_1v2.n821 vss_1v2.n45 17.0005
R765 vss_1v2.n776 vss_1v2.n45 17.0005
R766 vss_1v2.n819 vss_1v2.n45 17.0005
R767 vss_1v2.n775 vss_1v2.n45 17.0005
R768 vss_1v2.n817 vss_1v2.n45 17.0005
R769 vss_1v2.n774 vss_1v2.n45 17.0005
R770 vss_1v2.n45 vss_1v2.n314 17.0005
R771 vss_1v2.n45 vss_1v2.n313 17.0005
R772 vss_1v2.n45 vss_1v2.n312 17.0005
R773 vss_1v2.n45 vss_1v2.n311 17.0005
R774 vss_1v2.n45 vss_1v2.n310 17.0005
R775 vss_1v2.n45 vss_1v2.n144 0.0116511
R776 vss_1v2.n45 vss_1v2.n308 17.0005
R777 vss_1v2.n45 vss_1v2.n307 17.0005
R778 vss_1v2.n45 vss_1v2.n306 17.0005
R779 vss_1v2.n45 vss_1v2.n305 17.0005
R780 vss_1v2.n45 vss_1v2.n304 17.0005
R781 vss_1v2.n45 vss_1v2.n303 17.0005
R782 vss_1v2.n45 vss_1v2.n302 17.0005
R783 vss_1v2.n45 vss_1v2.n301 17.0005
R784 vss_1v2.n45 vss_1v2.n918 17.0005
R785 vss_1v2.n45 vss_1v2.n300 17.0005
R786 vss_1v2.n45 vss_1v2.n919 17.0005
R787 vss_1v2.n45 vss_1v2.n299 17.0005
R788 vss_1v2.n45 vss_1v2.n920 17.0005
R789 vss_1v2.n45 vss_1v2.n298 17.0005
R790 vss_1v2.n45 vss_1v2.n921 17.0005
R791 vss_1v2.n45 vss_1v2.n297 17.0005
R792 vss_1v2.n45 vss_1v2.n296 17.0005
R793 vss_1v2.n45 vss_1v2.n295 17.0005
R794 vss_1v2.n45 vss_1v2.n294 17.0005
R795 vss_1v2.n45 vss_1v2.n293 17.0005
R796 vss_1v2.n45 vss_1v2.n292 17.0005
R797 vss_1v2.n45 vss_1v2.n291 17.0005
R798 vss_1v2.n45 vss_1v2.n290 17.0005
R799 vss_1v2.n45 vss_1v2.n289 17.0005
R800 vss_1v2.n45 vss_1v2.n288 17.0005
R801 vss_1v2.n45 vss_1v2.n287 17.0005
R802 vss_1v2.n45 vss_1v2.n286 17.0005
R803 vss_1v2.n45 vss_1v2.n285 17.0005
R804 vss_1v2.n45 vss_1v2.n284 17.0005
R805 vss_1v2.n45 vss_1v2.n283 17.0005
R806 vss_1v2.n45 vss_1v2.n282 17.0005
R807 vss_1v2.n45 vss_1v2.n281 17.0005
R808 vss_1v2.n45 vss_1v2.n280 17.0005
R809 vss_1v2.n45 vss_1v2.n279 17.0005
R810 vss_1v2.n41 vss_1v2.n88 5.6656
R811 vss_1v2.n88 vss_1v2.n219 0.00737597
R812 vss_1v2.n41 vss_1v2.n650 17.0005
R813 vss_1v2.n41 vss_1v2.n83 4.24479
R814 vss_1v2.n83 vss_1v2.n82 0.0106696
R815 vss_1v2.n82 vss_1v2.n85 0.0125621
R816 vss_1v2.n41 vss_1v2.n635 17.0005
R817 vss_1v2.n41 vss_1v2.n649 17.0005
R818 vss_1v2.n41 vss_1v2.n636 17.0005
R819 vss_1v2.n41 vss_1v2.n648 17.0005
R820 vss_1v2.n41 vss_1v2.n389 17.0005
R821 vss_1v2.n41 vss_1v2.n647 17.0005
R822 vss_1v2.n41 vss_1v2.n637 17.0005
R823 vss_1v2.n41 vss_1v2.n646 17.0005
R824 vss_1v2.n41 vss_1v2.n638 17.0005
R825 vss_1v2.n41 vss_1v2.n223 8.49902
R826 vss_1v2.n41 vss_1v2.n645 17.0005
R827 vss_1v2.n41 vss_1v2.n134 8.49855
R828 vss_1v2.n134 vss_1v2.n133 0.00589388
R829 vss_1v2.n41 vss_1v2.n639 17.0005
R830 vss_1v2.n41 vss_1v2.n127 8.49855
R831 vss_1v2.n127 vss_1v2.n126 0.00589388
R832 vss_1v2.n41 vss_1v2.n644 17.0005
R833 vss_1v2.n41 vss_1v2.n640 17.0005
R834 vss_1v2.n41 vss_1v2.n643 17.0005
R835 vss_1v2.n41 vss_1v2.n386 17.0005
R836 vss_1v2.n41 vss_1v2.n642 17.0005
R837 vss_1v2.n41 vss_1v2.n404 17.0005
R838 vss_1v2.n41 vss_1v2.n641 17.0005
R839 vss_1v2.n41 vss_1v2.n634 17.0005
R840 vss_1v2.n41 vss_1v2.n633 17.0005
R841 vss_1v2.n41 vss_1v2.n2100 17.0005
R842 vss_1v2.n2101 vss_1v2.n41 17.0005
R843 vss_1v2.n2097 vss_1v2.n41 17.0005
R844 vss_1v2.n41 vss_1v2.n2096 17.0005
R845 vss_1v2.n41 vss_1v2.n317 17.0005
R846 vss_1v2.n2092 vss_1v2.n41 17.0005
R847 vss_1v2.n41 vss_1v2.n69 5.66506
R848 vss_1v2.n2090 vss_1v2.n41 17.0005
R849 vss_1v2.n796 vss_1v2.n41 17.0005
R850 vss_1v2.n41 vss_1v2.n795 17.0005
R851 vss_1v2.n2117 vss_1v2.n41 17.0005
R852 vss_1v2.n41 vss_1v2.n316 17.0005
R853 vss_1v2.n41 vss_1v2.n2121 17.0005
R854 vss_1v2.n142 vss_1v2.n41 8.49855
R855 vss_1v2.n142 vss_1v2.n2122 0.00590029
R856 vss_1v2.n397 vss_1v2.n276 0.0057562
R857 vss_1v2.n41 vss_1v2.n276 8.49862
R858 vss_1v2.n2123 vss_1v2.n41 17.0005
R859 vss_1v2.n41 vss_1v2.n765 17.0005
R860 vss_1v2.n41 vss_1v2.n767 17.0005
R861 vss_1v2.n41 vss_1v2.n277 17.0005
R862 vss_1v2.n278 vss_1v2.n41 8.49855
R863 vss_1v2.n112 vss_1v2.n41 8.49956
R864 vss_1v2.n729 vss_1v2.n41 17.0005
R865 vss_1v2.n2187 vss_1v2.n41 17.0005
R866 vss_1v2.n41 vss_1v2.n2186 17.0005
R867 vss_1v2.n176 vss_1v2.n174 0.00590029
R868 vss_1v2.n176 vss_1v2.n41 8.49855
R869 vss_1v2.n52 vss_1v2.n41 1.15655
R870 vss_1v2.n139 vss_1v2.n41 4.2462
R871 vss_1v2.n383 vss_1v2.n41 8.499
R872 vss_1v2.n383 vss_1v2.t309 0.00499053
R873 vss_1v2.n41 vss_1v2.n183 3.39859
R874 vss_1v2.n41 vss_1v2.n184 3.39962
R875 vss_1v2.n41 vss_1v2.n187 3.39911
R876 vss_1v2.n41 vss_1v2.n190 3.39711
R877 vss_1v2.n41 vss_1v2.n191 3.39981
R878 vss_1v2.n41 vss_1v2.n193 3.39937
R879 vss_1v2.n41 vss_1v2.n194 3.40624
R880 vss_1v2.n41 vss_1v2.n200 3.39808
R881 vss_1v2.n41 vss_1v2.n201 3.39827
R882 vss_1v2.n41 vss_1v2.n202 3.40003
R883 vss_1v2.n148 vss_1v2.n848 17.0005
R884 vss_1v2.n148 vss_1v2.n847 17.0005
R885 vss_1v2.n148 vss_1v2.n2183 17.0005
R886 vss_1v2.n397 vss_1v2.n148 17.0005
R887 vss_1v2.n2122 vss_1v2.n148 17.0005
R888 vss_1v2.n2108 vss_1v2.n148 17.0005
R889 vss_1v2.n2119 vss_1v2.n148 17.0005
R890 vss_1v2.n148 vss_1v2.n2118 17.0005
R891 vss_1v2.n148 vss_1v2.n793 17.0005
R892 vss_1v2.n148 vss_1v2.n797 17.0005
R893 vss_1v2.n155 vss_1v2.n148 5.66445
R894 vss_1v2.n155 vss_1v2.n154 0.00824997
R895 vss_1v2.n2091 vss_1v2.n148 17.0005
R896 vss_1v2.n148 vss_1v2.n2094 17.0005
R897 vss_1v2.n2095 vss_1v2.n148 17.0005
R898 vss_1v2.n148 vss_1v2.n772 17.0005
R899 vss_1v2.n148 vss_1v2.n773 17.0005
R900 vss_1v2.n2099 vss_1v2.n148 17.0005
R901 vss_1v2.n148 vss_1v2.n719 17.0005
R902 vss_1v2.n2192 vss_1v2.n148 17.0005
R903 vss_1v2.n169 vss_1v2.n168 0.00590029
R904 vss_1v2.n148 vss_1v2.n169 8.49855
R905 vss_1v2.n148 vss_1v2.n175 8.49956
R906 vss_1v2.n45 vss_1v2.n2188 17.0005
R907 vss_1v2.n45 vss_1v2.n728 17.0005
R908 vss_1v2.n114 vss_1v2.n115 0.00590029
R909 vss_1v2.n45 vss_1v2.n115 8.49855
R910 vss_1v2.n2189 vss_1v2.n45 17.0005
R911 vss_1v2.n45 vss_1v2.n2191 17.0005
R912 vss_1v2.n45 vss_1v2.n720 17.0005
R913 vss_1v2.n766 vss_1v2.n45 17.0005
R914 vss_1v2.n846 vss_1v2.n71 3.6281
R915 vss_1v2.n2184 vss_1v2.n45 17.0005
R916 vss_1v2.n1648 vss_1v2.t83 17.0005
R917 vss_1v2.t112 vss_1v2.n962 17.0005
R918 vss_1v2.n965 vss_1v2.t112 17.0005
R919 vss_1v2.n959 vss_1v2.t118 17.0005
R920 vss_1v2.t118 vss_1v2.n958 17.0005
R921 vss_1v2.n1630 vss_1v2.t74 17.0005
R922 vss_1v2.n1639 vss_1v2.t60 17.0005
R923 vss_1v2.t60 vss_1v2.n1638 17.0005
R924 vss_1v2.t74 vss_1v2.n1628 17.0005
R925 vss_1v2.t92 vss_1v2.t107 8.54878
R926 vss_1v2.t107 vss_1v2.t102 8.71439
R927 vss_1v2.t47 vss_1v2.n1208 17.0005
R928 vss_1v2.t47 vss_1v2.n1209 17.0005
R929 vss_1v2.t47 vss_1v2.n1210 17.0005
R930 vss_1v2.t44 vss_1v2.n1188 17.0005
R931 vss_1v2.t44 vss_1v2.n1189 17.0005
R932 vss_1v2.t44 vss_1v2.n1190 17.0005
R933 vss_1v2.n1985 vss_1v2.t10 17.0005
R934 vss_1v2.n1992 vss_1v2.t79 17.0005
R935 vss_1v2.t79 vss_1v2.n1990 17.0005
R936 vss_1v2.t10 vss_1v2.n1983 17.0005
R937 vss_1v2.n1154 vss_1v2.t177 17.0005
R938 vss_1v2.t177 vss_1v2.n1152 17.0005
R939 vss_1v2.n1617 vss_1v2.t57 17.0005
R940 vss_1v2.t57 vss_1v2.n1612 17.0005
R941 vss_1v2.t83 vss_1v2.n1646 17.0005
R942 vss_1v2.n917 vss_1v2.t152 17.0005
R943 vss_1v2.t152 vss_1v2.n916 17.0005
R944 vss_1v2.n908 vss_1v2.t185 17.0005
R945 vss_1v2.t185 vss_1v2.n906 17.0005
R946 vss_1v2.n877 vss_1v2.t161 17.0005
R947 vss_1v2.t161 vss_1v2.n876 17.0005
R948 vss_1v2.n868 vss_1v2.t194 17.0005
R949 vss_1v2.t194 vss_1v2.n866 17.0005
R950 vss_1v2.t173 vss_1v2.n891 17.0005
R951 vss_1v2.n894 vss_1v2.t173 17.0005
R952 vss_1v2.n900 vss_1v2.t169 17.0005
R953 vss_1v2.t169 vss_1v2.n898 17.0005
R954 vss_1v2.n887 vss_1v2.t181 17.0005
R955 vss_1v2.t181 vss_1v2.n886 17.0005
R956 vss_1v2.n880 vss_1v2.t202 17.0005
R957 vss_1v2.t202 vss_1v2.n878 17.0005
R958 vss_1v2.n727 vss_1v2.t190 17.0005
R959 vss_1v2.t190 vss_1v2.n726 17.0005
R960 vss_1v2.n716 vss_1v2.t198 17.0005
R961 vss_1v2.t198 vss_1v2.n715 17.0005
R962 vss_1v2.n2089 vss_1v2.t209 17.0005
R963 vss_1v2.t209 vss_1v2.n2088 17.0005
R964 vss_1v2.t213 vss_1v2.n2109 17.0005
R965 vss_1v2.n2112 vss_1v2.t213 17.0005
R966 vss_1v2.t222 vss_1v2.n672 17.0005
R967 vss_1v2.t222 vss_1v2.n673 17.0005
R968 vss_1v2.t222 vss_1v2.n674 17.0005
R969 vss_1v2.t220 vss_1v2.n692 17.0005
R970 vss_1v2.t220 vss_1v2.n693 17.0005
R971 vss_1v2.t220 vss_1v2.n694 17.0005
R972 vss_1v2.n1184 vss_1v2.t326 16.8954
R973 vss_1v2.t349 vss_1v2.n2194 16.8954
R974 vss_1v2.n1622 vss_1v2.t88 15.6272
R975 vss_1v2.n1642 vss_1v2.t58 15.6272
R976 vss_1v2.n1623 vss_1v2.t88 15.4225
R977 vss_1v2.n1632 vss_1v2.t75 15.3765
R978 vss_1v2.n1618 vss_1v2.t70 15.3138
R979 vss_1v2.t75 vss_1v2.n1631 15.3138
R980 vss_1v2.t70 vss_1v2.n1613 15.2115
R981 vss_1v2.n1640 vss_1v2.t58 15.1885
R982 vss_1v2.t110 vss_1v2.n963 15.1728
R983 vss_1v2.n966 vss_1v2.t110 15.1728
R984 vss_1v2.t117 vss_1v2.n956 15.1728
R985 vss_1v2.n957 vss_1v2.t117 15.1728
R986 vss_1v2.t93 vss_1v2.t107 7.59803
R987 vss_1v2.t107 vss_1v2.t101 7.56383
R988 vss_1v2.n1993 vss_1v2.t77 15.1728
R989 vss_1v2.n1986 vss_1v2.t95 15.1728
R990 vss_1v2.t77 vss_1v2.n1991 15.1728
R991 vss_1v2.t95 vss_1v2.n1984 15.1728
R992 vss_1v2.n1155 vss_1v2.t178 15.1728
R993 vss_1v2.t178 vss_1v2.n1153 15.1728
R994 vss_1v2.t186 vss_1v2.n907 15.1728
R995 vss_1v2.t150 vss_1v2.n914 15.1728
R996 vss_1v2.n915 vss_1v2.t150 15.1728
R997 vss_1v2.n909 vss_1v2.t186 15.1728
R998 vss_1v2.t195 vss_1v2.n867 15.1728
R999 vss_1v2.t160 vss_1v2.n874 15.1728
R1000 vss_1v2.n875 vss_1v2.t160 15.1728
R1001 vss_1v2.n869 vss_1v2.t195 15.1728
R1002 vss_1v2.t206 vss_1v2.n899 15.1728
R1003 vss_1v2.t172 vss_1v2.n892 15.1728
R1004 vss_1v2.n895 vss_1v2.t172 15.1728
R1005 vss_1v2.n901 vss_1v2.t206 15.1728
R1006 vss_1v2.t214 vss_1v2.n879 15.1728
R1007 vss_1v2.t180 vss_1v2.n884 15.1728
R1008 vss_1v2.n885 vss_1v2.t180 15.1728
R1009 vss_1v2.n881 vss_1v2.t214 15.1728
R1010 vss_1v2.t188 vss_1v2.n724 15.1728
R1011 vss_1v2.n725 vss_1v2.t188 15.1728
R1012 vss_1v2.t197 vss_1v2.n713 15.1728
R1013 vss_1v2.n714 vss_1v2.t197 15.1728
R1014 vss_1v2.t208 vss_1v2.n2086 15.1728
R1015 vss_1v2.n2087 vss_1v2.t208 15.1728
R1016 vss_1v2.t216 vss_1v2.n2110 15.1728
R1017 vss_1v2.n2113 vss_1v2.t216 15.1728
R1018 vss_1v2.t137 vss_1v2.n1266 15.1618
R1019 vss_1v2.n1267 vss_1v2.t137 15.1618
R1020 vss_1v2.t42 vss_1v2.n1111 15.1618
R1021 vss_1v2.n1112 vss_1v2.t42 15.1618
R1022 vss_1v2.t19 vss_1v2.n1054 15.1618
R1023 vss_1v2.n1055 vss_1v2.t19 15.1618
R1024 vss_1v2.n1889 vss_1v2.t14 15.1618
R1025 vss_1v2.t14 vss_1v2.n1888 15.1618
R1026 vss_1v2.t45 vss_1v2.n1517 15.1618
R1027 vss_1v2.n1519 vss_1v2.t45 15.1618
R1028 vss_1v2.n1656 vss_1v2.t33 15.1618
R1029 vss_1v2.t33 vss_1v2.n1653 15.1618
R1030 vss_1v2.n1907 vss_1v2.t11 15.1618
R1031 vss_1v2.t11 vss_1v2.n1017 15.1618
R1032 vss_1v2.t139 vss_1v2.n1151 15.1618
R1033 vss_1v2.n1165 vss_1v2.t139 15.1618
R1034 vss_1v2.n2082 vss_1v2.t232 15.1618
R1035 vss_1v2.t232 vss_1v2.n2081 15.1618
R1036 vss_1v2.t218 vss_1v2.n762 15.1618
R1037 vss_1v2.n763 vss_1v2.t218 15.1618
R1038 vss_1v2.t22 vss_1v2.n667 15.1618
R1039 vss_1v2.n668 vss_1v2.t22 15.1618
R1040 vss_1v2.t126 vss_1v2.n1954 15.1618
R1041 vss_1v2.n1955 vss_1v2.t126 15.1618
R1042 vss_1v2.t28 vss_1v2.n659 15.1618
R1043 vss_1v2.n663 vss_1v2.t28 15.1618
R1044 vss_1v2.n2210 vss_1v2.t128 15.1618
R1045 vss_1v2.t128 vss_1v2.n2209 15.1618
R1046 vss_1v2.t230 vss_1v2.n2204 15.1618
R1047 vss_1v2.t221 vss_1v2.n2200 15.1618
R1048 vss_1v2.n2201 vss_1v2.t221 15.1618
R1049 vss_1v2.n2205 vss_1v2.t230 15.1618
R1050 vss_1v2.n68 vss_1v2.n27 1.10768
R1051 vss_1v2.n1614 vss_1v2.n49 3.36755
R1052 vss_1v2.n1272 vss_1v2.t134 15.0005
R1053 vss_1v2.t134 vss_1v2.n1271 15.0005
R1054 vss_1v2.n1115 vss_1v2.t39 15.0005
R1055 vss_1v2.t39 vss_1v2.n1114 15.0005
R1056 vss_1v2.n1060 vss_1v2.t30 15.0005
R1057 vss_1v2.t30 vss_1v2.n1059 15.0005
R1058 vss_1v2.n1890 vss_1v2.t0 15.0005
R1059 vss_1v2.t0 vss_1v2.n1887 15.0005
R1060 vss_1v2.t84 vss_1v2.t85 15.0005
R1061 vss_1v2.t97 vss_1v2.t98 15.0005
R1062 vss_1v2.n1982 vss_1v2.t84 15.0005
R1063 vss_1v2.n1980 vss_1v2.t97 15.0005
R1064 vss_1v2.t55 vss_1v2.n1619 15.0005
R1065 vss_1v2.t82 vss_1v2.n1622 15.0005
R1066 vss_1v2.n1623 vss_1v2.t82 15.0005
R1067 vss_1v2.n1521 vss_1v2.t48 15.0005
R1068 vss_1v2.t48 vss_1v2.n1520 15.0005
R1069 vss_1v2.t66 vss_1v2.t65 15.0005
R1070 vss_1v2.t65 vss_1v2.n1527 15.0005
R1071 vss_1v2.t53 vss_1v2.t51 15.0005
R1072 vss_1v2.t51 vss_1v2.n1670 15.0005
R1073 vss_1v2.n968 vss_1v2.t113 15.0005
R1074 vss_1v2.t113 vss_1v2.n967 15.0005
R1075 vss_1v2.n955 vss_1v2.t121 15.0005
R1076 vss_1v2.t121 vss_1v2.n952 15.0005
R1077 vss_1v2.t63 vss_1v2.n1641 15.0005
R1078 vss_1v2.t72 vss_1v2.n1632 15.0005
R1079 vss_1v2.n1642 vss_1v2.t63 15.0005
R1080 vss_1v2.n1633 vss_1v2.t72 15.0005
R1081 vss_1v2.t115 vss_1v2.t107 7.50175
R1082 vss_1v2.t105 vss_1v2.t107 7.50175
R1083 vss_1v2.t107 vss_1v2.t90 7.45816
R1084 vss_1v2.t103 vss_1v2.t107 7.428
R1085 vss_1v2.t36 vss_1v2.n1657 15.0005
R1086 vss_1v2.n1658 vss_1v2.t36 15.0005
R1087 vss_1v2.t16 vss_1v2.n1908 15.0005
R1088 vss_1v2.n1909 vss_1v2.t16 15.0005
R1089 vss_1v2.t80 vss_1v2.n1994 15.0005
R1090 vss_1v2.t8 vss_1v2.n1987 15.0005
R1091 vss_1v2.n1995 vss_1v2.t80 15.0005
R1092 vss_1v2.n1988 vss_1v2.t8 15.0005
R1093 vss_1v2.t176 vss_1v2.n1159 15.0005
R1094 vss_1v2.n1160 vss_1v2.t176 15.0005
R1095 vss_1v2.t165 vss_1v2.t164 15.0005
R1096 vss_1v2.t164 vss_1v2.n1141 15.0005
R1097 vss_1v2.t156 vss_1v2.t155 15.0005
R1098 vss_1v2.t155 vss_1v2.n1227 15.0005
R1099 vss_1v2.t146 vss_1v2.t144 15.0005
R1100 vss_1v2.t144 vss_1v2.n1691 15.0005
R1101 vss_1v2.n1167 vss_1v2.t141 15.0005
R1102 vss_1v2.t141 vss_1v2.n1166 15.0005
R1103 vss_1v2.n1620 vss_1v2.t55 15.0005
R1104 vss_1v2.n911 vss_1v2.t184 15.0005
R1105 vss_1v2.n913 vss_1v2.t153 15.0005
R1106 vss_1v2.t153 vss_1v2.n905 15.0005
R1107 vss_1v2.t184 vss_1v2.n910 15.0005
R1108 vss_1v2.n871 vss_1v2.t193 15.0005
R1109 vss_1v2.n873 vss_1v2.t162 15.0005
R1110 vss_1v2.t162 vss_1v2.n865 15.0005
R1111 vss_1v2.t193 vss_1v2.n870 15.0005
R1112 vss_1v2.n904 vss_1v2.t167 15.0005
R1113 vss_1v2.n897 vss_1v2.t174 15.0005
R1114 vss_1v2.t174 vss_1v2.n896 15.0005
R1115 vss_1v2.t167 vss_1v2.n903 15.0005
R1116 vss_1v2.n890 vss_1v2.t201 15.0005
R1117 vss_1v2.n883 vss_1v2.t182 15.0005
R1118 vss_1v2.t182 vss_1v2.n882 15.0005
R1119 vss_1v2.t201 vss_1v2.n889 15.0005
R1120 vss_1v2.t227 vss_1v2.n2104 15.0005
R1121 vss_1v2.n2105 vss_1v2.t227 15.0005
R1122 vss_1v2.n771 vss_1v2.t203 15.0005
R1123 vss_1v2.t203 vss_1v2.n770 15.0005
R1124 vss_1v2.n723 vss_1v2.t191 15.0005
R1125 vss_1v2.t191 vss_1v2.n722 15.0005
R1126 vss_1v2.n712 vss_1v2.t199 15.0005
R1127 vss_1v2.t199 vss_1v2.n710 15.0005
R1128 vss_1v2.n2085 vss_1v2.t210 15.0005
R1129 vss_1v2.t210 vss_1v2.n2084 15.0005
R1130 vss_1v2.n2115 vss_1v2.t212 15.0005
R1131 vss_1v2.t212 vss_1v2.n2114 15.0005
R1132 vss_1v2.n2198 vss_1v2.t4 15.0005
R1133 vss_1v2.t4 vss_1v2.n2197 15.0005
R1134 vss_1v2.n1959 vss_1v2.t123 15.0005
R1135 vss_1v2.t123 vss_1v2.n1958 15.0005
R1136 vss_1v2.n665 vss_1v2.t24 15.0005
R1137 vss_1v2.t24 vss_1v2.n664 15.0005
R1138 vss_1v2.n2211 vss_1v2.t131 15.0005
R1139 vss_1v2.t131 vss_1v2.n2208 15.0005
R1140 vss_1v2.n2207 vss_1v2.t234 15.0005
R1141 vss_1v2.n2203 vss_1v2.t224 15.0005
R1142 vss_1v2.t224 vss_1v2.n2202 15.0005
R1143 vss_1v2.t234 vss_1v2.n2206 15.0005
R1144 vss_1v2.n1913 vss_1v2.n68 12277.8
R1145 vss_1v2.n1184 vss_1v2.t328 13.349
R1146 vss_1v2.n2194 vss_1v2.t355 13.349
R1147 vss_1v2.n1225 vss_1v2.n1204 12.678
R1148 vss_1v2.n709 vss_1v2.n688 12.678
R1149 vss_1v2.n65 vss_1v2.n27 2.0192
R1150 vss_1v2.n140 vss_1v2.n1916 7.62385
R1151 vss_1v2.n27 vss_1v2.n158 4.5559
R1152 vss_1v2.n27 vss_1v2.n66 4.76888
R1153 vss_1v2.n1226 vss_1v2.n1184 9.8299
R1154 vss_1v2.n2194 vss_1v2.n2193 9.8299
R1155 vss_1v2.t277 vss_1v2.n1531 9.70359
R1156 vss_1v2.t338 vss_1v2.n948 9.70359
R1157 vss_1v2.n1225 vss_1v2.n1224 9.70359
R1158 vss_1v2.n709 vss_1v2.n708 9.70359
R1159 vss_1v2.t357 vss_1v2.t359 9.67719
R1160 vss_1v2.t319 vss_1v2.t320 9.67719
R1161 vss_1v2.n1224 vss_1v2.n1223 9.03894
R1162 vss_1v2.n1222 vss_1v2.t35 9.03894
R1163 vss_1v2.n1204 vss_1v2.n1203 9.03894
R1164 vss_1v2.n1202 vss_1v2.t21 9.03894
R1165 vss_1v2.n688 vss_1v2.n687 9.03894
R1166 vss_1v2.n686 vss_1v2.t129 9.03894
R1167 vss_1v2.n708 vss_1v2.n707 9.03894
R1168 vss_1v2.n706 vss_1v2.t127 9.03894
R1169 vss_1v2.n1531 vss_1v2.n1538 9.0005
R1170 vss_1v2.t280 vss_1v2.n1537 9.0005
R1171 vss_1v2.t279 vss_1v2.n1534 9.0005
R1172 vss_1v2.n1514 vss_1v2.t319 9.0005
R1173 vss_1v2.n948 vss_1v2.n951 9.0005
R1174 vss_1v2.t336 vss_1v2.n950 9.0005
R1175 vss_1v2.t337 vss_1v2.n949 9.0005
R1176 vss_1v2.n1206 vss_1v2.n1205 9.0005
R1177 vss_1v2.n1221 vss_1v2.n1212 9.0005
R1178 vss_1v2.n1220 vss_1v2.n1219 9.0005
R1179 vss_1v2.n1218 vss_1v2.n1217 9.0005
R1180 vss_1v2.n1216 vss_1v2.n1215 9.0005
R1181 vss_1v2.n1214 vss_1v2.n1213 9.0005
R1182 vss_1v2.n1186 vss_1v2.n1185 9.0005
R1183 vss_1v2.n1201 vss_1v2.n1192 9.0005
R1184 vss_1v2.n1200 vss_1v2.n1199 9.0005
R1185 vss_1v2.n1198 vss_1v2.n1197 9.0005
R1186 vss_1v2.n1196 vss_1v2.n1195 9.0005
R1187 vss_1v2.n1194 vss_1v2.n1193 9.0005
R1188 vss_1v2.n670 vss_1v2.n669 9.0005
R1189 vss_1v2.n685 vss_1v2.n676 9.0005
R1190 vss_1v2.n684 vss_1v2.n683 9.0005
R1191 vss_1v2.n682 vss_1v2.n681 9.0005
R1192 vss_1v2.n680 vss_1v2.n679 9.0005
R1193 vss_1v2.n678 vss_1v2.n677 9.0005
R1194 vss_1v2.n690 vss_1v2.n689 9.0005
R1195 vss_1v2.n705 vss_1v2.n696 9.0005
R1196 vss_1v2.n704 vss_1v2.n703 9.0005
R1197 vss_1v2.n702 vss_1v2.n701 9.0005
R1198 vss_1v2.n700 vss_1v2.n699 9.0005
R1199 vss_1v2.n698 vss_1v2.n697 9.0005
R1200 vss_1v2.n38 vss_1v2.n1652 8.86693
R1201 vss_1v2.n45 vss_1v2.n71 1.3281
R1202 vss_1v2.n1223 vss_1v2.t47 8.50315
R1203 vss_1v2.t47 vss_1v2.n1222 8.50315
R1204 vss_1v2.n1203 vss_1v2.t44 8.50315
R1205 vss_1v2.t44 vss_1v2.n1202 8.50315
R1206 vss_1v2.t222 vss_1v2.n686 8.50315
R1207 vss_1v2.n687 vss_1v2.t222 8.50315
R1208 vss_1v2.n707 vss_1v2.t220 8.50315
R1209 vss_1v2.t220 vss_1v2.n706 8.50315
R1210 vss_1v2.n1679 vss_1v2.n39 8.50125
R1211 vss_1v2.n79 vss_1v2.n64 1.74779
R1212 vss_1v2.n1645 vss_1v2.n39 0.884057
R1213 vss_1v2.n38 vss_1v2.n359 0.884155
R1214 vss_1v2.n1914 vss_1v2.n18 0.618847
R1215 vss_1v2.n18 vss_1v2.n1003 2.12513
R1216 vss_1v2.n1974 vss_1v2.t107 0.894211
R1217 vss_1v2.t107 vss_1v2.t192 0.89503
R1218 vss_1v2.n1998 vss_1v2.n72 0.45989
R1219 vss_1v2.n27 vss_1v2.n28 0.18372
R1220 vss_1v2.n27 vss_1v2.n439 8.5005
R1221 vss_1v2.n27 vss_1v2.n430 8.5005
R1222 vss_1v2.n27 vss_1v2.n438 8.5005
R1223 vss_1v2.n27 vss_1v2.n431 8.5005
R1224 vss_1v2.n27 vss_1v2.n437 8.5005
R1225 vss_1v2.n27 vss_1v2.n432 8.5005
R1226 vss_1v2.n27 vss_1v2.n436 8.5005
R1227 vss_1v2.n27 vss_1v2.n433 8.5005
R1228 vss_1v2.n27 vss_1v2.n434 8.5005
R1229 vss_1v2.n27 vss_1v2.n257 8.5005
R1230 vss_1v2.n27 vss_1v2.n259 2.83095
R1231 vss_1v2.n259 vss_1v2.n256 0.00788008
R1232 vss_1v2.n259 vss_1v2.n260 0.0217169
R1233 vss_1v2.n261 vss_1v2.n260 0.00692249
R1234 vss_1v2.n27 vss_1v2.n261 4.24804
R1235 vss_1v2.n27 vss_1v2.n47 0.520786
R1236 vss_1v2.n27 vss_1v2.n64 4.41163
R1237 vss_1v2.n270 vss_1v2.n27 0.663952
R1238 vss_1v2.n271 vss_1v2.n268 0.00625694
R1239 vss_1v2.n268 vss_1v2.n27 4.24837
R1240 vss_1v2.n1892 vss_1v2.n27 8.5005
R1241 vss_1v2.n157 vss_1v2.n266 0.0104878
R1242 vss_1v2.n267 vss_1v2.n266 0.00846554
R1243 vss_1v2.n266 vss_1v2.n27 2.8309
R1244 vss_1v2.n264 vss_1v2.n27 8.5005
R1245 vss_1v2.n265 vss_1v2.n263 0.0168653
R1246 vss_1v2.n218 vss_1v2.n263 0.0142846
R1247 vss_1v2.n263 vss_1v2.n27 2.8309
R1248 vss_1v2.n1884 vss_1v2.n27 8.5005
R1249 vss_1v2.n1894 vss_1v2.n27 8.5005
R1250 vss_1v2.n1895 vss_1v2.n27 8.5005
R1251 vss_1v2.n1882 vss_1v2.n27 8.5005
R1252 vss_1v2.n1880 vss_1v2.n27 8.5005
R1253 vss_1v2.n1898 vss_1v2.n27 8.5005
R1254 vss_1v2.n1899 vss_1v2.n27 8.5005
R1255 vss_1v2.n1878 vss_1v2.n27 8.5005
R1256 vss_1v2.n1902 vss_1v2.n27 8.5005
R1257 vss_1v2.n1903 vss_1v2.n27 8.5005
R1258 vss_1v2.n1875 vss_1v2.n27 8.5005
R1259 vss_1v2.n1873 vss_1v2.n27 8.5005
R1260 vss_1v2.n1021 vss_1v2.n27 8.5005
R1261 vss_1v2.n1023 vss_1v2.n27 8.5005
R1262 vss_1v2.n1056 vss_1v2.n27 8.5005
R1263 vss_1v2.n1026 vss_1v2.n27 8.5005
R1264 vss_1v2.n1028 vss_1v2.n27 8.5005
R1265 vss_1v2.n1030 vss_1v2.n27 8.5005
R1266 vss_1v2.n1032 vss_1v2.n27 8.5005
R1267 vss_1v2.n1034 vss_1v2.n27 8.5005
R1268 vss_1v2.n1036 vss_1v2.n27 8.5005
R1269 vss_1v2.n1040 vss_1v2.n27 8.5005
R1270 vss_1v2.n1042 vss_1v2.n27 8.5005
R1271 vss_1v2.n1044 vss_1v2.n27 8.5005
R1272 vss_1v2.n1046 vss_1v2.n27 8.5005
R1273 vss_1v2.n1048 vss_1v2.n27 8.5005
R1274 vss_1v2.n1050 vss_1v2.n27 8.5005
R1275 vss_1v2.n1052 vss_1v2.n27 8.5005
R1276 vss_1v2.n1063 vss_1v2.n27 8.5005
R1277 vss_1v2.n1065 vss_1v2.n27 8.5005
R1278 vss_1v2.n1067 vss_1v2.n27 8.5005
R1279 vss_1v2.n1069 vss_1v2.n27 8.5005
R1280 vss_1v2.n1070 vss_1v2.n27 8.5005
R1281 vss_1v2.n1079 vss_1v2.n27 8.5005
R1282 vss_1v2.n1081 vss_1v2.n27 8.5005
R1283 vss_1v2.n163 vss_1v2.n27 4.24945
R1284 vss_1v2.n1083 vss_1v2.n27 8.5005
R1285 vss_1v2.n1085 vss_1v2.n27 8.5005
R1286 vss_1v2.n1087 vss_1v2.n27 8.5005
R1287 vss_1v2.n1089 vss_1v2.n27 8.5005
R1288 vss_1v2.n1091 vss_1v2.n27 8.5005
R1289 vss_1v2.n1093 vss_1v2.n27 8.5005
R1290 vss_1v2.n1097 vss_1v2.n27 8.5005
R1291 vss_1v2.n1099 vss_1v2.n27 8.5005
R1292 vss_1v2.n1101 vss_1v2.n27 8.5005
R1293 vss_1v2.n1103 vss_1v2.n27 8.5005
R1294 vss_1v2.n1105 vss_1v2.n27 8.5005
R1295 vss_1v2.n1107 vss_1v2.n27 8.5005
R1296 vss_1v2.n1109 vss_1v2.n27 8.5005
R1297 vss_1v2.n1118 vss_1v2.n27 8.5005
R1298 vss_1v2.n1120 vss_1v2.n27 8.5005
R1299 vss_1v2.n1122 vss_1v2.n27 8.5005
R1300 vss_1v2.n1179 vss_1v2.n27 8.5005
R1301 vss_1v2.n1180 vss_1v2.n27 8.5005
R1302 vss_1v2.n1231 vss_1v2.n27 8.5005
R1303 vss_1v2.n1233 vss_1v2.n27 8.5005
R1304 vss_1v2.n1268 vss_1v2.n27 8.5005
R1305 vss_1v2.n1236 vss_1v2.n27 8.5005
R1306 vss_1v2.n1238 vss_1v2.n27 8.5005
R1307 vss_1v2.n1240 vss_1v2.n27 8.5005
R1308 vss_1v2.n1242 vss_1v2.n27 8.5005
R1309 vss_1v2.n1244 vss_1v2.n27 8.5005
R1310 vss_1v2.n1246 vss_1v2.n27 8.5005
R1311 vss_1v2.n1248 vss_1v2.n27 8.5005
R1312 vss_1v2.n1250 vss_1v2.n27 8.5005
R1313 vss_1v2.n1252 vss_1v2.n27 8.5005
R1314 vss_1v2.n1254 vss_1v2.n27 8.5005
R1315 vss_1v2.n1256 vss_1v2.n27 8.5005
R1316 vss_1v2.n1258 vss_1v2.n27 8.5005
R1317 vss_1v2.n1260 vss_1v2.n27 8.5005
R1318 vss_1v2.n1262 vss_1v2.n27 8.5005
R1319 vss_1v2.n1264 vss_1v2.n27 8.5005
R1320 vss_1v2.n1274 vss_1v2.n27 8.5005
R1321 vss_1v2.n1277 vss_1v2.n27 8.5005
R1322 vss_1v2.n1279 vss_1v2.n27 8.5005
R1323 vss_1v2.n1325 vss_1v2.n27 8.5005
R1324 vss_1v2.n27 vss_1v2.n207 8.5005
R1325 vss_1v2.n27 vss_1v2.n210 4.24891
R1326 vss_1v2.n27 vss_1v2.n1688 8.5005
R1327 vss_1v2.n27 vss_1v2.n1698 8.5005
R1328 vss_1v2.n27 vss_1v2.n1699 8.5005
R1329 vss_1v2.n27 vss_1v2.n1701 8.5005
R1330 vss_1v2.n27 vss_1v2.n1703 8.5005
R1331 vss_1v2.n27 vss_1v2.n1704 8.5005
R1332 vss_1v2.n27 vss_1v2.n166 4.24974
R1333 vss_1v2.n27 vss_1v2.n120 4.24981
R1334 vss_1v2.n103 vss_1v2.n106 0.0141559
R1335 vss_1v2.n27 vss_1v2.n103 2.82735
R1336 vss_1v2.n103 vss_1v2.n102 0.0207601
R1337 vss_1v2.n27 vss_1v2.n122 4.24974
R1338 vss_1v2.n27 vss_1v2.n160 4.24981
R1339 vss_1v2.n27 vss_1v2.n1717 8.5005
R1340 vss_1v2.n27 vss_1v2.n1718 8.5005
R1341 vss_1v2.n27 vss_1v2.n1721 8.5005
R1342 vss_1v2.n27 vss_1v2.n1722 8.5005
R1343 vss_1v2.n27 vss_1v2.n1724 8.5005
R1344 vss_1v2.n27 vss_1v2.n1725 8.5005
R1345 vss_1v2.n27 vss_1v2.n1728 8.5005
R1346 vss_1v2.n27 vss_1v2.n427 8.5005
R1347 vss_1v2.n27 vss_1v2.n1731 8.5005
R1348 vss_1v2.n27 vss_1v2.n1732 8.5005
R1349 vss_1v2.n27 vss_1v2.n1735 8.5005
R1350 vss_1v2.n27 vss_1v2.n1736 8.5005
R1351 vss_1v2.n27 vss_1v2.n1739 8.5005
R1352 vss_1v2.n27 vss_1v2.n179 4.2496
R1353 vss_1v2.n27 vss_1v2.n390 8.5005
R1354 vss_1v2.n27 vss_1v2.n90 4.2496
R1355 vss_1v2.n27 vss_1v2.n1746 8.5005
R1356 vss_1v2.n27 vss_1v2.n67 0.5575
R1357 vss_1v2.n27 vss_1v2.n1327 8.5005
R1358 vss_1v2.n27 vss_1v2.n1686 8.5005
R1359 vss_1v2.n27 vss_1v2.n1705 8.5005
R1360 vss_1v2.n27 vss_1v2.n1706 8.5005
R1361 vss_1v2.n27 vss_1v2.n1707 8.5005
R1362 vss_1v2.n27 vss_1v2.n1708 8.5005
R1363 vss_1v2.n27 vss_1v2.n1709 8.5005
R1364 vss_1v2.n27 vss_1v2.n1710 8.5005
R1365 vss_1v2.n27 vss_1v2.n1711 8.5005
R1366 vss_1v2.n27 vss_1v2.n1712 8.5005
R1367 vss_1v2.n27 vss_1v2.n1713 8.5005
R1368 vss_1v2.n27 vss_1v2.n1714 8.5005
R1369 vss_1v2.n27 vss_1v2.n1715 8.5005
R1370 vss_1v2.n27 vss_1v2.n1716 8.5005
R1371 vss_1v2.n27 vss_1v2.n1719 8.5005
R1372 vss_1v2.n27 vss_1v2.n1720 8.5005
R1373 vss_1v2.n27 vss_1v2.n1726 8.5005
R1374 vss_1v2.n27 vss_1v2.n1727 8.5005
R1375 vss_1v2.n27 vss_1v2.n1729 8.5005
R1376 vss_1v2.n27 vss_1v2.n1730 8.5005
R1377 vss_1v2.n27 vss_1v2.n1733 8.5005
R1378 vss_1v2.n27 vss_1v2.n1734 8.5005
R1379 vss_1v2.n27 vss_1v2.n1737 8.5005
R1380 vss_1v2.n27 vss_1v2.n1738 8.5005
R1381 vss_1v2.n27 vss_1v2.n1740 8.5005
R1382 vss_1v2.n27 vss_1v2.n1741 8.5005
R1383 vss_1v2.n27 vss_1v2.n1742 8.5005
R1384 vss_1v2.n27 vss_1v2.n1743 8.5005
R1385 vss_1v2.n27 vss_1v2.n1744 8.5005
R1386 vss_1v2.n27 vss_1v2.n1745 8.5005
R1387 vss_1v2.n27 vss_1v2.n1747 8.5005
R1388 vss_1v2.n27 vss_1v2.n1748 8.5005
R1389 vss_1v2.n27 vss_1v2.n627 8.5005
R1390 vss_1v2.n27 vss_1v2.n116 4.24985
R1391 vss_1v2.n27 vss_1v2.n123 4.2497
R1392 vss_1v2.n105 vss_1v2.n109 0.00723311
R1393 vss_1v2.n27 vss_1v2.n105 2.83197
R1394 vss_1v2.n95 vss_1v2.n99 0.0072683
R1395 vss_1v2.n27 vss_1v2.n95 2.83196
R1396 vss_1v2.n27 vss_1v2.n93 4.2496
R1397 vss_1v2.n27 vss_1v2.n446 8.5005
R1398 vss_1v2.n27 vss_1v2.n569 8.5005
R1399 vss_1v2.n27 vss_1v2.n448 8.5005
R1400 vss_1v2.n27 vss_1v2.n567 8.5005
R1401 vss_1v2.n27 vss_1v2.n450 8.5005
R1402 vss_1v2.n27 vss_1v2.n565 8.5005
R1403 vss_1v2.n27 vss_1v2.n452 8.5005
R1404 vss_1v2.n27 vss_1v2.n563 8.5005
R1405 vss_1v2.n27 vss_1v2.n454 8.5005
R1406 vss_1v2.n27 vss_1v2.n455 8.5005
R1407 vss_1v2.n27 vss_1v2.n561 8.5005
R1408 vss_1v2.n27 vss_1v2.n456 8.5005
R1409 vss_1v2.n27 vss_1v2.n559 8.5005
R1410 vss_1v2.n27 vss_1v2.n458 8.5005
R1411 vss_1v2.n27 vss_1v2.n557 8.5005
R1412 vss_1v2.n27 vss_1v2.n460 8.5005
R1413 vss_1v2.n27 vss_1v2.n555 8.5005
R1414 vss_1v2.n27 vss_1v2.n462 8.5005
R1415 vss_1v2.n27 vss_1v2.n553 8.5005
R1416 vss_1v2.n27 vss_1v2.n464 8.5005
R1417 vss_1v2.n27 vss_1v2.n551 8.5005
R1418 vss_1v2.n27 vss_1v2.n466 8.5005
R1419 vss_1v2.n27 vss_1v2.n549 8.5005
R1420 vss_1v2.n27 vss_1v2.n468 8.5005
R1421 vss_1v2.n27 vss_1v2.n547 8.5005
R1422 vss_1v2.n27 vss_1v2.n470 8.5005
R1423 vss_1v2.n27 vss_1v2.n545 8.5005
R1424 vss_1v2.n27 vss_1v2.n472 8.5005
R1425 vss_1v2.n27 vss_1v2.n543 8.5005
R1426 vss_1v2.n27 vss_1v2.n474 8.5005
R1427 vss_1v2.n27 vss_1v2.n541 8.5005
R1428 vss_1v2.n27 vss_1v2.n476 8.5005
R1429 vss_1v2.n27 vss_1v2.n539 8.5005
R1430 vss_1v2.n27 vss_1v2.n478 8.5005
R1431 vss_1v2.n27 vss_1v2.n479 8.5005
R1432 vss_1v2.n27 vss_1v2.n537 8.5005
R1433 vss_1v2.n27 vss_1v2.n480 8.5005
R1434 vss_1v2.n27 vss_1v2.n535 8.5005
R1435 vss_1v2.n27 vss_1v2.n482 8.5005
R1436 vss_1v2.n27 vss_1v2.n533 8.5005
R1437 vss_1v2.n27 vss_1v2.n484 8.5005
R1438 vss_1v2.n27 vss_1v2.n531 8.5005
R1439 vss_1v2.n27 vss_1v2.n486 8.5005
R1440 vss_1v2.n27 vss_1v2.n529 8.5005
R1441 vss_1v2.n27 vss_1v2.n488 8.5005
R1442 vss_1v2.n27 vss_1v2.n527 8.5005
R1443 vss_1v2.n27 vss_1v2.n490 8.5005
R1444 vss_1v2.n27 vss_1v2.n525 8.5005
R1445 vss_1v2.n27 vss_1v2.n492 8.5005
R1446 vss_1v2.n27 vss_1v2.n523 8.5005
R1447 vss_1v2.n27 vss_1v2.n494 8.5005
R1448 vss_1v2.n27 vss_1v2.n521 8.5005
R1449 vss_1v2.n27 vss_1v2.n496 8.5005
R1450 vss_1v2.n27 vss_1v2.n519 8.5005
R1451 vss_1v2.n27 vss_1v2.n498 8.5005
R1452 vss_1v2.n27 vss_1v2.n517 8.5005
R1453 vss_1v2.n27 vss_1v2.n500 8.5005
R1454 vss_1v2.n27 vss_1v2.n515 8.5005
R1455 vss_1v2.n27 vss_1v2.n502 8.5005
R1456 vss_1v2.n27 vss_1v2.n513 8.5005
R1457 vss_1v2.n27 vss_1v2.n504 8.5005
R1458 vss_1v2.n27 vss_1v2.n511 8.5005
R1459 vss_1v2.n27 vss_1v2.n506 8.5005
R1460 vss_1v2.n27 vss_1v2.n13 0.125926
R1461 vss_1v2.n13 vss_1v2.n424 0.0333147
R1462 vss_1v2.n423 vss_1v2.n424 0.0207457
R1463 vss_1v2.n423 vss_1v2.n422 0.0136
R1464 vss_1v2.n27 vss_1v2.n423 2.83111
R1465 vss_1v2.n421 vss_1v2.n422 0.0207457
R1466 vss_1v2.n421 vss_1v2.n420 0.0136
R1467 vss_1v2.n27 vss_1v2.n421 2.83111
R1468 vss_1v2.n419 vss_1v2.n420 0.0207457
R1469 vss_1v2.n419 vss_1v2.n418 0.0136
R1470 vss_1v2.n27 vss_1v2.n419 2.83111
R1471 vss_1v2.n417 vss_1v2.n418 0.0207457
R1472 vss_1v2.n417 vss_1v2.n416 0.0136
R1473 vss_1v2.n27 vss_1v2.n417 2.83111
R1474 vss_1v2.n415 vss_1v2.n416 0.0207457
R1475 vss_1v2.n415 vss_1v2.n414 0.0136
R1476 vss_1v2.n27 vss_1v2.n415 2.83111
R1477 vss_1v2.n413 vss_1v2.n414 0.0207457
R1478 vss_1v2.n413 vss_1v2.n412 0.0136
R1479 vss_1v2.n27 vss_1v2.n413 2.83111
R1480 vss_1v2.n27 vss_1v2.n1423 8.5005
R1481 vss_1v2.n27 vss_1v2.n1414 8.5005
R1482 vss_1v2.n27 vss_1v2.n1412 8.5005
R1483 vss_1v2.n27 vss_1v2.n1408 8.5005
R1484 vss_1v2.n27 vss_1v2.n1406 8.5005
R1485 vss_1v2.n27 vss_1v2.n1402 8.5005
R1486 vss_1v2.n27 vss_1v2.n1400 8.5005
R1487 vss_1v2.n27 vss_1v2.n1396 8.5005
R1488 vss_1v2.n27 vss_1v2.n1394 8.5005
R1489 vss_1v2.n27 vss_1v2.n1390 8.5005
R1490 vss_1v2.n27 vss_1v2.n1388 8.5005
R1491 vss_1v2.n27 vss_1v2.n1384 8.5005
R1492 vss_1v2.n27 vss_1v2.n1382 8.5005
R1493 vss_1v2.n27 vss_1v2.n1379 8.5005
R1494 vss_1v2.n27 vss_1v2.n1377 8.5005
R1495 vss_1v2.n27 vss_1v2.n1373 8.5005
R1496 vss_1v2.n27 vss_1v2.n1371 8.5005
R1497 vss_1v2.n27 vss_1v2.n1367 8.5005
R1498 vss_1v2.n27 vss_1v2.n1365 8.5005
R1499 vss_1v2.n27 vss_1v2.n1361 8.5005
R1500 vss_1v2.n27 vss_1v2.n1359 8.5005
R1501 vss_1v2.n27 vss_1v2.n1355 8.5005
R1502 vss_1v2.n27 vss_1v2.n1353 8.5005
R1503 vss_1v2.n27 vss_1v2.n1350 8.5005
R1504 vss_1v2.n27 vss_1v2.n1348 8.5005
R1505 vss_1v2.n27 vss_1v2.n1344 8.5005
R1506 vss_1v2.n27 vss_1v2.n1342 8.5005
R1507 vss_1v2.n27 vss_1v2.n229 4.24891
R1508 vss_1v2.n27 vss_1v2.n128 8.5005
R1509 vss_1v2.n27 vss_1v2.n130 4.24891
R1510 vss_1v2.n27 vss_1v2.n1335 8.5005
R1511 vss_1v2.n27 vss_1v2.n1332 8.5005
R1512 vss_1v2.n27 vss_1v2.n410 8.5005
R1513 vss_1v2.n27 vss_1v2.n409 8.5005
R1514 vss_1v2.n27 vss_1v2.n626 8.5005
R1515 vss_1v2.n27 vss_1v2.n440 8.5005
R1516 vss_1v2.n27 vss_1v2.n575 8.5005
R1517 vss_1v2.n27 vss_1v2.n441 8.5005
R1518 vss_1v2.n27 vss_1v2.n574 8.5005
R1519 vss_1v2.n27 vss_1v2.n442 8.5005
R1520 vss_1v2.n27 vss_1v2.n573 8.5005
R1521 vss_1v2.n27 vss_1v2.n443 8.5005
R1522 vss_1v2.n27 vss_1v2.n572 8.5005
R1523 vss_1v2.n27 vss_1v2.n444 8.5005
R1524 vss_1v2.n27 vss_1v2.n571 8.5005
R1525 vss_1v2.n27 vss_1v2.n445 8.5005
R1526 vss_1v2.n27 vss_1v2.n570 8.5005
R1527 vss_1v2.n27 vss_1v2.n447 8.5005
R1528 vss_1v2.n27 vss_1v2.n568 8.5005
R1529 vss_1v2.n27 vss_1v2.n449 8.5005
R1530 vss_1v2.n27 vss_1v2.n566 8.5005
R1531 vss_1v2.n27 vss_1v2.n451 8.5005
R1532 vss_1v2.n27 vss_1v2.n564 8.5005
R1533 vss_1v2.n27 vss_1v2.n453 8.5005
R1534 vss_1v2.n27 vss_1v2.n562 8.5005
R1535 vss_1v2.n27 vss_1v2.n560 8.5005
R1536 vss_1v2.n27 vss_1v2.n457 8.5005
R1537 vss_1v2.n27 vss_1v2.n558 8.5005
R1538 vss_1v2.n27 vss_1v2.n459 8.5005
R1539 vss_1v2.n27 vss_1v2.n556 8.5005
R1540 vss_1v2.n27 vss_1v2.n461 8.5005
R1541 vss_1v2.n27 vss_1v2.n554 8.5005
R1542 vss_1v2.n27 vss_1v2.n463 8.5005
R1543 vss_1v2.n27 vss_1v2.n552 8.5005
R1544 vss_1v2.n27 vss_1v2.n465 8.5005
R1545 vss_1v2.n27 vss_1v2.n550 8.5005
R1546 vss_1v2.n27 vss_1v2.n467 8.5005
R1547 vss_1v2.n27 vss_1v2.n548 8.5005
R1548 vss_1v2.n27 vss_1v2.n469 8.5005
R1549 vss_1v2.n27 vss_1v2.n546 8.5005
R1550 vss_1v2.n27 vss_1v2.n471 8.5005
R1551 vss_1v2.n27 vss_1v2.n544 8.5005
R1552 vss_1v2.n27 vss_1v2.n473 8.5005
R1553 vss_1v2.n27 vss_1v2.n542 8.5005
R1554 vss_1v2.n27 vss_1v2.n475 8.5005
R1555 vss_1v2.n27 vss_1v2.n540 8.5005
R1556 vss_1v2.n27 vss_1v2.n477 8.5005
R1557 vss_1v2.n27 vss_1v2.n538 8.5005
R1558 vss_1v2.n27 vss_1v2.n536 8.5005
R1559 vss_1v2.n27 vss_1v2.n481 8.5005
R1560 vss_1v2.n27 vss_1v2.n534 8.5005
R1561 vss_1v2.n27 vss_1v2.n483 8.5005
R1562 vss_1v2.n27 vss_1v2.n532 8.5005
R1563 vss_1v2.n27 vss_1v2.n485 8.5005
R1564 vss_1v2.n27 vss_1v2.n530 8.5005
R1565 vss_1v2.n27 vss_1v2.n487 8.5005
R1566 vss_1v2.n27 vss_1v2.n528 8.5005
R1567 vss_1v2.n27 vss_1v2.n489 8.5005
R1568 vss_1v2.n27 vss_1v2.n526 8.5005
R1569 vss_1v2.n27 vss_1v2.n491 8.5005
R1570 vss_1v2.n27 vss_1v2.n524 8.5005
R1571 vss_1v2.n27 vss_1v2.n493 8.5005
R1572 vss_1v2.n27 vss_1v2.n522 8.5005
R1573 vss_1v2.n27 vss_1v2.n495 8.5005
R1574 vss_1v2.n27 vss_1v2.n520 8.5005
R1575 vss_1v2.n27 vss_1v2.n497 8.5005
R1576 vss_1v2.n27 vss_1v2.n518 8.5005
R1577 vss_1v2.n27 vss_1v2.n499 8.5005
R1578 vss_1v2.n27 vss_1v2.n516 8.5005
R1579 vss_1v2.n27 vss_1v2.n501 8.5005
R1580 vss_1v2.n27 vss_1v2.n514 8.5005
R1581 vss_1v2.n27 vss_1v2.n503 8.5005
R1582 vss_1v2.n27 vss_1v2.n512 8.5005
R1583 vss_1v2.n27 vss_1v2.n505 8.5005
R1584 vss_1v2.n27 vss_1v2.n510 8.5005
R1585 vss_1v2.n27 vss_1v2.n507 8.5005
R1586 vss_1v2.n27 vss_1v2.n509 8.5005
R1587 vss_1v2.n27 vss_1v2.n508 8.5005
R1588 vss_1v2.n27 vss_1v2.n1016 8.5005
R1589 vss_1v2.n27 vss_1v2.n1014 8.5005
R1590 vss_1v2.n27 vss_1v2.n1915 8.5005
R1591 vss_1v2.n27 vss_1v2.n1008 8.5005
R1592 vss_1v2.n27 vss_1v2.n1012 8.5005
R1593 vss_1v2.n27 vss_1v2.n1011 8.5005
R1594 vss_1v2.n27 vss_1v2.n1010 8.5005
R1595 vss_1v2.n27 vss_1v2.n1009 8.5005
R1596 vss_1v2.n27 vss_1v2.n318 8.5005
R1597 vss_1v2.n27 vss_1v2.t272 8.5005
R1598 vss_1v2.n27 vss_1v2.n1682 8.5005
R1599 vss_1v2.n27 vss_1v2.n1680 8.5005
R1600 vss_1v2.n27 vss_1v2.n1677 8.5005
R1601 vss_1v2.n27 vss_1v2.n1480 8.5005
R1602 vss_1v2.n27 vss_1v2.n1478 8.5005
R1603 vss_1v2.n27 vss_1v2.n1475 8.5005
R1604 vss_1v2.n27 vss_1v2.n1473 8.5005
R1605 vss_1v2.n27 vss_1v2.n1470 8.5005
R1606 vss_1v2.n27 vss_1v2.n1468 8.5005
R1607 vss_1v2.n27 vss_1v2.n1466 8.5005
R1608 vss_1v2.n27 vss_1v2.n1464 8.5005
R1609 vss_1v2.n27 vss_1v2.n1462 8.5005
R1610 vss_1v2.n27 vss_1v2.n1461 8.5005
R1611 vss_1v2.n27 vss_1v2.n1459 8.5005
R1612 vss_1v2.n27 vss_1v2.n1457 8.5005
R1613 vss_1v2.n27 vss_1v2.n1455 8.5005
R1614 vss_1v2.n27 vss_1v2.n1454 8.5005
R1615 vss_1v2.n27 vss_1v2.n1452 8.5005
R1616 vss_1v2.n27 vss_1v2.n1450 8.5005
R1617 vss_1v2.n27 vss_1v2.n1449 8.5005
R1618 vss_1v2.n27 vss_1v2.n1447 8.5005
R1619 vss_1v2.n27 vss_1v2.n1445 8.5005
R1620 vss_1v2.n27 vss_1v2.n1443 8.5005
R1621 vss_1v2.n27 vss_1v2.n1441 8.5005
R1622 vss_1v2.n27 vss_1v2.n1439 8.5005
R1623 vss_1v2.n27 vss_1v2.n1437 8.5005
R1624 vss_1v2.n27 vss_1v2.n1436 8.5005
R1625 vss_1v2.n27 vss_1v2.n1434 8.5005
R1626 vss_1v2.n27 vss_1v2.n1432 8.5005
R1627 vss_1v2.n27 vss_1v2.n1430 8.5005
R1628 vss_1v2.n27 vss_1v2.n1429 8.5005
R1629 vss_1v2.n27 vss_1v2.n1428 8.5005
R1630 vss_1v2.n27 vss_1v2.n1427 8.5005
R1631 vss_1v2.n27 vss_1v2.n1425 8.5005
R1632 vss_1v2.n27 vss_1v2.n1424 8.5005
R1633 vss_1v2.n27 vss_1v2.n1421 8.5005
R1634 vss_1v2.n27 vss_1v2.n1419 8.5005
R1635 vss_1v2.n27 vss_1v2.n1416 8.5005
R1636 vss_1v2.n27 vss_1v2.n1415 8.5005
R1637 vss_1v2.n27 vss_1v2.n1410 8.5005
R1638 vss_1v2.n27 vss_1v2.n1409 8.5005
R1639 vss_1v2.n27 vss_1v2.n1404 8.5005
R1640 vss_1v2.n27 vss_1v2.n1403 8.5005
R1641 vss_1v2.n27 vss_1v2.n1398 8.5005
R1642 vss_1v2.n27 vss_1v2.n1397 8.5005
R1643 vss_1v2.n27 vss_1v2.n1392 8.5005
R1644 vss_1v2.n27 vss_1v2.n1391 8.5005
R1645 vss_1v2.n27 vss_1v2.n1386 8.5005
R1646 vss_1v2.n27 vss_1v2.n1385 8.5005
R1647 vss_1v2.n27 vss_1v2.t299 8.5005
R1648 vss_1v2.n27 vss_1v2.n1380 8.5005
R1649 vss_1v2.n27 vss_1v2.n1375 8.5005
R1650 vss_1v2.n27 vss_1v2.n1374 8.5005
R1651 vss_1v2.n27 vss_1v2.n1369 8.5005
R1652 vss_1v2.n27 vss_1v2.n1368 8.5005
R1653 vss_1v2.n27 vss_1v2.n1363 8.5005
R1654 vss_1v2.n27 vss_1v2.n1362 8.5005
R1655 vss_1v2.n27 vss_1v2.n1357 8.5005
R1656 vss_1v2.n27 vss_1v2.n1356 8.5005
R1657 vss_1v2.n27 vss_1v2.t318 8.5005
R1658 vss_1v2.n27 vss_1v2.n1351 8.5005
R1659 vss_1v2.n27 vss_1v2.n1346 8.5005
R1660 vss_1v2.n27 vss_1v2.n1345 8.5005
R1661 vss_1v2.n27 vss_1v2.n1341 8.5005
R1662 vss_1v2.n27 vss_1v2.n1340 8.5005
R1663 vss_1v2.n27 vss_1v2.n1339 8.5005
R1664 vss_1v2.n27 vss_1v2.n1338 8.5005
R1665 vss_1v2.n27 vss_1v2.n1337 8.5005
R1666 vss_1v2.n27 vss_1v2.n1336 8.5005
R1667 vss_1v2.n27 vss_1v2.n1334 8.5005
R1668 vss_1v2.n27 vss_1v2.n1333 8.5005
R1669 vss_1v2.n27 vss_1v2.n1330 8.5005
R1670 vss_1v2.n27 vss_1v2.n1329 8.5005
R1671 vss_1v2.n1684 vss_1v2.n39 8.5005
R1672 vss_1v2.t363 vss_1v2.n35 0.125345
R1673 vss_1v2.n1477 vss_1v2.n39 8.5005
R1674 vss_1v2.n1472 vss_1v2.n39 8.5005
R1675 vss_1v2.n1606 vss_1v2.n39 8.5005
R1676 vss_1v2.n983 vss_1v2.n18 5.66504
R1677 vss_1v2.n977 vss_1v2.n18 5.667
R1678 vss_1v2.n18 vss_1v2.n347 3.39709
R1679 vss_1v2.n30 vss_1v2.n87 0.0163161
R1680 vss_1v2.n220 vss_1v2.n219 0.00589247
R1681 vss_1v2.n27 vss_1v2.n220 4.24855
R1682 vss_1v2.n27 vss_1v2.n580 8.5005
R1683 vss_1v2.n27 vss_1v2.n85 2.12258
R1684 vss_1v2.n85 vss_1v2.n408 0.00628968
R1685 vss_1v2.n27 vss_1v2.n585 8.5005
R1686 vss_1v2.n27 vss_1v2.n588 8.5005
R1687 vss_1v2.n27 vss_1v2.n589 8.5005
R1688 vss_1v2.n27 vss_1v2.n388 8.5005
R1689 vss_1v2.n27 vss_1v2.n387 8.5005
R1690 vss_1v2.n27 vss_1v2.n594 8.5005
R1691 vss_1v2.n27 vss_1v2.n406 4.24863
R1692 vss_1v2.n27 vss_1v2.n596 8.5005
R1693 vss_1v2.n27 vss_1v2.n599 8.5005
R1694 vss_1v2.n224 vss_1v2.n222 0.00589247
R1695 vss_1v2.n27 vss_1v2.n224 4.24855
R1696 vss_1v2.n27 vss_1v2.n602 8.5005
R1697 vss_1v2.n27 vss_1v2.n132 4.24902
R1698 vss_1v2.n27 vss_1v2.n607 8.5005
R1699 vss_1v2.n27 vss_1v2.n125 4.24902
R1700 vss_1v2.n27 vss_1v2.n610 8.5005
R1701 vss_1v2.n27 vss_1v2.n613 8.5005
R1702 vss_1v2.n27 vss_1v2.n385 8.5005
R1703 vss_1v2.n27 vss_1v2.n384 8.5005
R1704 vss_1v2.n27 vss_1v2.n614 8.5005
R1705 vss_1v2.n27 vss_1v2.n405 8.5005
R1706 vss_1v2.n27 vss_1v2.n615 8.5005
R1707 vss_1v2.n27 vss_1v2.n616 8.5005
R1708 vss_1v2.n27 vss_1v2.n618 8.5005
R1709 vss_1v2.n27 vss_1v2.n620 8.5005
R1710 vss_1v2.n27 vss_1v2.n621 8.5005
R1711 vss_1v2.n27 vss_1v2.n622 8.5005
R1712 vss_1v2.n27 vss_1v2.n623 8.5005
R1713 vss_1v2.n27 vss_1v2.n624 8.5005
R1714 vss_1v2.n27 vss_1v2.n576 8.5005
R1715 vss_1v2.n27 vss_1v2.n577 8.5005
R1716 vss_1v2.n27 vss_1v2.n578 8.5005
R1717 vss_1v2.n27 vss_1v2.n579 8.5005
R1718 vss_1v2.n27 vss_1v2.n581 8.5005
R1719 vss_1v2.n27 vss_1v2.n582 8.5005
R1720 vss_1v2.n27 vss_1v2.n583 8.5005
R1721 vss_1v2.n27 vss_1v2.n584 8.5005
R1722 vss_1v2.n27 vss_1v2.n586 8.5005
R1723 vss_1v2.n27 vss_1v2.n587 8.5005
R1724 vss_1v2.n27 vss_1v2.n590 8.5005
R1725 vss_1v2.n27 vss_1v2.n591 8.5005
R1726 vss_1v2.n27 vss_1v2.n592 8.5005
R1727 vss_1v2.n27 vss_1v2.n593 8.5005
R1728 vss_1v2.n27 vss_1v2.n597 8.5005
R1729 vss_1v2.n27 vss_1v2.n598 8.5005
R1730 vss_1v2.n27 vss_1v2.n600 8.5005
R1731 vss_1v2.n27 vss_1v2.n601 8.5005
R1732 vss_1v2.n27 vss_1v2.n603 8.5005
R1733 vss_1v2.n27 vss_1v2.n604 8.5005
R1734 vss_1v2.n27 vss_1v2.n605 8.5005
R1735 vss_1v2.n27 vss_1v2.n606 8.5005
R1736 vss_1v2.n27 vss_1v2.n608 8.5005
R1737 vss_1v2.n27 vss_1v2.n609 8.5005
R1738 vss_1v2.n27 vss_1v2.n611 8.5005
R1739 vss_1v2.n27 vss_1v2.n612 8.5005
R1740 vss_1v2.n27 vss_1v2.n625 8.5005
R1741 vss_1v2.n70 vss_1v2.n13 0.770334
R1742 vss_1v2.n148 vss_1v2.n70 0.0657855
R1743 vss_1v2.n13 vss_1v2.n76 1.09043
R1744 vss_1v2.n79 vss_1v2.n1072 8.499
R1745 vss_1v2.n79 vss_1v2.n1074 8.499
R1746 vss_1v2.n79 vss_1v2.n1075 8.499
R1747 vss_1v2.n275 vss_1v2.n41 3.3947
R1748 vss_1v2.n139 vss_1v2.n138 0.00519401
R1749 vss_1v2.n1952 vss_1v2.n41 8.499
R1750 vss_1v2.n315 vss_1v2.n41 4.24602
R1751 vss_1v2.n41 vss_1v2.n44 0.959912
R1752 vss_1v2.n79 vss_1v2.n1128 8.49855
R1753 vss_1v2.n401 vss_1v2.n72 8.49855
R1754 vss_1v2.n398 vss_1v2.n148 8.49855
R1755 vss_1v2.n79 vss_1v2.n1029 8.49837
R1756 vss_1v2.n45 vss_1v2.n13 0.568592
R1757 vss_1v2.n211 vss_1v2.n38 8.47769
R1758 vss_1v2.n1674 vss_1v2.n38 8.47769
R1759 vss_1v2.n38 vss_1v2.n1673 8.47769
R1760 vss_1v2.t107 vss_1v2.n137 8.47769
R1761 vss_1v2.n273 vss_1v2.n31 0.188155
R1762 vss_1v2.n272 vss_1v2.t107 5.62647
R1763 vss_1v2.t107 vss_1v2.n21 0.685236
R1764 vss_1v2.t107 vss_1v2.n1976 8.46745
R1765 vss_1v2.t47 vss_1v2.n1207 8.46606
R1766 vss_1v2.t47 vss_1v2.n1211 8.46606
R1767 vss_1v2.t44 vss_1v2.n1187 8.46606
R1768 vss_1v2.t44 vss_1v2.n1191 8.46606
R1769 vss_1v2.t222 vss_1v2.n671 8.46606
R1770 vss_1v2.t222 vss_1v2.n675 8.46606
R1771 vss_1v2.t220 vss_1v2.n691 8.46606
R1772 vss_1v2.t220 vss_1v2.n695 8.46606
R1773 vss_1v2.n194 vss_1v2.n595 7.79976
R1774 vss_1v2.n58 vss_1v2.n39 1.03479
R1775 vss_1v2.n1526 vss_1v2.t68 7.50051
R1776 vss_1v2.n1669 vss_1v2.t61 7.50051
R1777 vss_1v2.n1978 vss_1v2.t86 7.48208
R1778 vss_1v2.t99 vss_1v2.n1981 7.48208
R1779 vss_1v2.t170 vss_1v2.n1140 7.48208
R1780 vss_1v2.n1183 vss_1v2.t158 7.48208
R1781 vss_1v2.n1690 vss_1v2.t148 7.48208
R1782 vss_1v2.n27 vss_1v2.n140 4.88196
R1783 vss_1v2.n1010 vss_1v2.n379 6.65048
R1784 vss_1v2.n1011 vss_1v2.n380 6.65048
R1785 vss_1v2.n1008 vss_1v2.n1007 6.22145
R1786 vss_1v2.n1723 vss_1v2.n1297 6.13633
R1787 vss_1v2.n158 vss_1v2.n1687 6.46088
R1788 vss_1v2.n1686 vss_1v2.n1685 6.03044
R1789 vss_1v2.n1554 vss_1v2.t371 6.00694
R1790 vss_1v2.n1662 vss_1v2.n1511 5.91198
R1791 vss_1v2.n1614 vss_1v2.n38 5.85963
R1792 vss_1v2.n206 vss_1v2.n612 5.71855
R1793 vss_1v2.n205 vss_1v2.n611 5.71855
R1794 vss_1v2.n203 vss_1v2.n608 5.71855
R1795 vss_1v2.n202 vss_1v2.n606 5.71855
R1796 vss_1v2.n201 vss_1v2.n605 5.71855
R1797 vss_1v2.n200 vss_1v2.n604 5.71855
R1798 vss_1v2.n199 vss_1v2.n603 5.71855
R1799 vss_1v2.n197 vss_1v2.n600 5.71855
R1800 vss_1v2.n196 vss_1v2.n598 5.71855
R1801 vss_1v2.n195 vss_1v2.n597 5.71855
R1802 vss_1v2.t145 vss_1v2.n38 0.879206
R1803 vss_1v2.n1938 vss_1v2.n18 2.12564
R1804 vss_1v2.n1696 vss_1v2.n15 2.42921
R1805 vss_1v2.n1972 vss_1v2.n18 2.12585
R1806 vss_1v2.n1015 vss_1v2.n18 3.39893
R1807 vss_1v2.n1997 vss_1v2.n45 2.12497
R1808 vss_1v2.n79 vss_1v2.n1077 5.66596
R1809 vss_1v2.n79 vss_1v2.n1076 5.66423
R1810 vss_1v2.t381 vss_1v2.n1916 5.66141
R1811 vss_1v2.n1916 vss_1v2.n941 5.66141
R1812 vss_1v2.n213 vss_1v2.n15 5.65766
R1813 vss_1v2.n40 vss_1v2.n39 0.262479
R1814 vss_1v2.n1915 vss_1v2.n1914 5.5779
R1815 vss_1v2.n1014 vss_1v2.n346 5.5779
R1816 vss_1v2.n1016 vss_1v2.n347 5.5779
R1817 vss_1v2.n1723 vss_1v2.n1300 5.51254
R1818 vss_1v2.n204 vss_1v2.t23 5.40665
R1819 vss_1v2.n1439 vss_1v2.n364 5.36339
R1820 vss_1v2.n1450 vss_1v2.n370 5.36339
R1821 vss_1v2.n1452 vss_1v2.n371 5.36339
R1822 vss_1v2.n1455 vss_1v2.n373 5.36339
R1823 vss_1v2.n1457 vss_1v2.n374 5.36339
R1824 vss_1v2.n49 vss_1v2.n135 3.07467
R1825 vss_1v2.n193 vss_1v2.n593 5.30269
R1826 vss_1v2.n192 vss_1v2.n592 5.30269
R1827 vss_1v2.n191 vss_1v2.n591 5.30269
R1828 vss_1v2.n190 vss_1v2.n590 5.30269
R1829 vss_1v2.n188 vss_1v2.n586 5.30269
R1830 vss_1v2.n187 vss_1v2.n584 5.30269
R1831 vss_1v2.n186 vss_1v2.n583 5.30269
R1832 vss_1v2.n185 vss_1v2.n582 5.30269
R1833 vss_1v2.n184 vss_1v2.n581 5.30269
R1834 vss_1v2.n182 vss_1v2.n578 5.30269
R1835 vss_1v2.n181 vss_1v2.n577 5.30269
R1836 vss_1v2.n41 vss_1v2.n29 0.0704333
R1837 vss_1v2.n294 vss_1v2.n524 5.14887
R1838 vss_1v2.n295 vss_1v2.n491 5.14887
R1839 vss_1v2.n297 vss_1v2.n489 5.14887
R1840 vss_1v2.n298 vss_1v2.n528 5.14887
R1841 vss_1v2.n304 vss_1v2.n534 5.14887
R1842 vss_1v2.n307 vss_1v2.n478 5.14887
R1843 vss_1v2.n1466 vss_1v2.n59 5.50577
R1844 vss_1v2.n63 vss_1v2.n39 2.73749
R1845 vss_1v2.n1595 vss_1v2.n1434 4.93436
R1846 vss_1v2.n39 vss_1v2.n60 2.67265
R1847 vss_1v2.n1627 vss_1v2.n1511 4.86494
R1848 vss_1v2.n1510 vss_1v2.n39 4.79062
R1849 vss_1v2.n1556 vss_1v2.t369 4.71984
R1850 vss_1v2.n1592 vss_1v2.n1591 4.71984
R1851 vss_1v2.n1645 vss_1v2.t373 4.71984
R1852 vss_1v2.t377 vss_1v2.n366 4.71984
R1853 vss_1v2.n1462 vss_1v2.n57 4.89033
R1854 vss_1v2.n29 vss_1v2.t25 6.65579
R1855 vss_1v2.n1012 vss_1v2.n1006 4.50533
R1856 vss_1v2.n1012 vss_1v2.t323 4.50533
R1857 vss_1v2.n356 vss_1v2.n289 4.50533
R1858 vss_1v2.n357 vss_1v2.n291 4.50533
R1859 vss_1v2.t239 vss_1v2.n300 4.50533
R1860 vss_1v2.n312 vss_1v2.t248 4.50533
R1861 vss_1v2.n774 vss_1v2.t250 4.50533
R1862 vss_1v2.n1636 vss_1v2.n177 4.4225
R1863 vss_1v2.n1644 vss_1v2.n1625 4.4225
R1864 vss_1v2.n79 vss_1v2.n225 0.0961181
R1865 vss_1v2.t270 vss_1v2.n141 4.39807
R1866 vss_1v2.n1630 vss_1v2.n1629 4.34962
R1867 vss_1v2.n243 vss_1v2.n1330 4.29081
R1868 vss_1v2.n245 vss_1v2.n1336 4.29081
R1869 vss_1v2.n241 vss_1v2.n1339 4.29081
R1870 vss_1v2.t292 vss_1v2.n1351 4.29081
R1871 vss_1v2.t294 vss_1v2.n1357 4.29081
R1872 vss_1v2.n1421 vss_1v2.t368 4.29081
R1873 vss_1v2.n1427 vss_1v2.t370 4.29081
R1874 vss_1v2.t378 vss_1v2.n1447 4.29081
R1875 vss_1v2.n1939 vss_1v2.n293 4.29081
R1876 vss_1v2.t241 vss_1v2.n532 4.29081
R1877 vss_1v2.t245 vss_1v2.n538 4.29081
R1878 vss_1v2.t247 vss_1v2.n475 4.29081
R1879 vss_1v2.t249 vss_1v2.n544 4.29081
R1880 vss_1v2.n80 vss_1v2.n1324 3.40401
R1881 vss_1v2.n426 vss_1v2.n79 4.25125
R1882 vss_1v2.n1973 vss_1v2.n18 0.893792
R1883 vss_1v2.n79 vss_1v2.n143 0.649615
R1884 vss_1v2.n79 vss_1v2.n1282 3.40012
R1885 vss_1v2.n79 vss_1v2.n1283 4.2505
R1886 vss_1v2.n79 vss_1v2.n1284 4.2505
R1887 vss_1v2.n79 vss_1v2.n1285 4.2505
R1888 vss_1v2.n79 vss_1v2.n1286 4.2505
R1889 vss_1v2.n79 vss_1v2.n1287 4.2505
R1890 vss_1v2.n79 vss_1v2.n1288 4.2505
R1891 vss_1v2.n79 vss_1v2.n1289 4.2505
R1892 vss_1v2.n79 vss_1v2.n1290 4.2505
R1893 vss_1v2.n81 vss_1v2.n1291 3.40084
R1894 vss_1v2.n79 vss_1v2.n1292 4.2505
R1895 vss_1v2.n79 vss_1v2.n1293 4.2505
R1896 vss_1v2.n79 vss_1v2.n1297 4.2505
R1897 vss_1v2.n79 vss_1v2.n1301 4.2505
R1898 vss_1v2.n79 vss_1v2.n1304 4.2505
R1899 vss_1v2.n79 vss_1v2.n1305 4.2505
R1900 vss_1v2.n79 vss_1v2.n1307 3.39783
R1901 vss_1v2.n79 vss_1v2.n1308 4.2505
R1902 vss_1v2.n79 vss_1v2.n1311 4.2505
R1903 vss_1v2.n79 vss_1v2.n1312 4.2505
R1904 vss_1v2.n79 vss_1v2.n1314 4.2505
R1905 vss_1v2.n79 vss_1v2.n1316 4.2505
R1906 vss_1v2.n79 vss_1v2.n1317 4.2505
R1907 vss_1v2.n79 vss_1v2.n1318 4.2505
R1908 vss_1v2.n79 vss_1v2.n1319 4.2505
R1909 vss_1v2.n79 vss_1v2.n1322 4.2505
R1910 vss_1v2.n79 vss_1v2.n1323 4.2505
R1911 vss_1v2.n1685 vss_1v2.n73 3.40332
R1912 vss_1v2.n1683 vss_1v2.n72 4.2505
R1913 vss_1v2.n1681 vss_1v2.n72 4.2505
R1914 vss_1v2.n1678 vss_1v2.n72 4.2505
R1915 vss_1v2.n1481 vss_1v2.n72 4.2505
R1916 vss_1v2.n1479 vss_1v2.n72 4.2505
R1917 vss_1v2.n1474 vss_1v2.n72 4.2505
R1918 vss_1v2.n1471 vss_1v2.n72 4.2505
R1919 vss_1v2.n1469 vss_1v2.n72 4.2505
R1920 vss_1v2.n1467 vss_1v2.n72 4.2505
R1921 vss_1v2.n1465 vss_1v2.n72 4.2505
R1922 vss_1v2.n1463 vss_1v2.n72 4.2505
R1923 vss_1v2.n1607 vss_1v2.n72 4.2505
R1924 vss_1v2.n1460 vss_1v2.n72 4.2505
R1925 vss_1v2.n1458 vss_1v2.n72 4.2505
R1926 vss_1v2.n1453 vss_1v2.n72 4.2505
R1927 vss_1v2.n1451 vss_1v2.n72 4.2505
R1928 vss_1v2.n1546 vss_1v2.n72 4.2505
R1929 vss_1v2.n1448 vss_1v2.n72 4.2505
R1930 vss_1v2.n1446 vss_1v2.n72 4.2505
R1931 vss_1v2.n1444 vss_1v2.n72 4.2505
R1932 vss_1v2.n1442 vss_1v2.n72 4.2505
R1933 vss_1v2.n1440 vss_1v2.n72 4.2505
R1934 vss_1v2.n1596 vss_1v2.n72 4.2505
R1935 vss_1v2.n1435 vss_1v2.n72 4.2505
R1936 vss_1v2.n1433 vss_1v2.n72 4.2505
R1937 vss_1v2.n1431 vss_1v2.n72 4.2505
R1938 vss_1v2.n1624 vss_1v2.n72 4.2505
R1939 vss_1v2.n1551 vss_1v2.n72 4.2505
R1940 vss_1v2.n1593 vss_1v2.n72 4.2505
R1941 vss_1v2.n1553 vss_1v2.n72 4.2505
R1942 vss_1v2.n1426 vss_1v2.n72 4.2505
R1943 vss_1v2.n1555 vss_1v2.n72 4.2505
R1944 vss_1v2.n1420 vss_1v2.n72 4.2505
R1945 vss_1v2.t367 vss_1v2.n72 4.2505
R1946 vss_1v2.n1482 vss_1v2.n72 4.2505
R1947 vss_1v2.n1483 vss_1v2.n72 4.2505
R1948 vss_1v2.t365 vss_1v2.n72 4.2505
R1949 vss_1v2.n1484 vss_1v2.n72 4.2505
R1950 vss_1v2.n1485 vss_1v2.n72 4.2505
R1951 vss_1v2.t362 vss_1v2.n72 4.2505
R1952 vss_1v2.n1487 vss_1v2.n72 4.2505
R1953 vss_1v2.n1488 vss_1v2.n72 4.2505
R1954 vss_1v2.n1561 vss_1v2.n72 3.40001
R1955 vss_1v2.n1586 vss_1v2.n72 4.2505
R1956 vss_1v2.n1489 vss_1v2.n72 4.2505
R1957 vss_1v2.n1490 vss_1v2.n72 4.2505
R1958 vss_1v2.n1584 vss_1v2.n72 4.2505
R1959 vss_1v2.n1491 vss_1v2.n72 4.2505
R1960 vss_1v2.n1582 vss_1v2.n72 4.2505
R1961 vss_1v2.n1565 vss_1v2.n72 4.2505
R1962 vss_1v2.n1493 vss_1v2.n72 4.2505
R1963 vss_1v2.n1494 vss_1v2.n72 4.2505
R1964 vss_1v2.n1567 vss_1v2.n72 4.2505
R1965 vss_1v2.n1495 vss_1v2.n72 4.2505
R1966 vss_1v2.n1496 vss_1v2.n72 4.2505
R1967 vss_1v2.n1569 vss_1v2.n72 4.2505
R1968 vss_1v2.n1497 vss_1v2.n72 4.2505
R1969 vss_1v2.n1498 vss_1v2.n72 4.2505
R1970 vss_1v2.n1499 vss_1v2.n72 4.2505
R1971 vss_1v2.n1577 vss_1v2.n72 4.2505
R1972 vss_1v2.n1500 vss_1v2.n72 4.2505
R1973 vss_1v2.n1501 vss_1v2.n72 4.2505
R1974 vss_1v2.n1502 vss_1v2.n72 4.2505
R1975 vss_1v2.n1503 vss_1v2.n72 4.2505
R1976 vss_1v2.n1573 vss_1v2.n72 4.2505
R1977 vss_1v2.n1328 vss_1v2.n72 4.2505
R1978 vss_1v2.n148 vss_1v2.n2185 4.2505
R1979 vss_1v2.n148 vss_1v2.n845 4.2505
R1980 vss_1v2.n148 vss_1v2.n844 4.2505
R1981 vss_1v2.n148 vss_1v2.n843 4.2505
R1982 vss_1v2.n148 vss_1v2.n842 4.2505
R1983 vss_1v2.n148 vss_1v2.n841 4.2505
R1984 vss_1v2.n148 vss_1v2.n840 4.2505
R1985 vss_1v2.n148 vss_1v2.n839 4.2505
R1986 vss_1v2.n148 vss_1v2.n837 4.2505
R1987 vss_1v2.n148 vss_1v2.n835 4.2505
R1988 vss_1v2.n148 vss_1v2.n833 4.2505
R1989 vss_1v2.n148 vss_1v2.n831 4.2505
R1990 vss_1v2.n148 vss_1v2.n829 4.2505
R1991 vss_1v2.n148 vss_1v2.n827 4.2505
R1992 vss_1v2.n148 vss_1v2.n149 0.00259864
R1993 vss_1v2.n148 vss_1v2.n823 4.2505
R1994 vss_1v2.n148 vss_1v2.n821 4.2505
R1995 vss_1v2.n148 vss_1v2.n819 4.2505
R1996 vss_1v2.n148 vss_1v2.n817 4.2505
R1997 vss_1v2.n148 vss_1v2.n314 4.2505
R1998 vss_1v2.n148 vss_1v2.n312 4.2505
R1999 vss_1v2.n148 vss_1v2.n310 4.2505
R2000 vss_1v2.n148 vss_1v2.n308 4.2505
R2001 vss_1v2.n148 vss_1v2.n306 4.2505
R2002 vss_1v2.n148 vss_1v2.n304 4.2505
R2003 vss_1v2.n148 vss_1v2.n302 4.2505
R2004 vss_1v2.n148 vss_1v2.n300 4.2505
R2005 vss_1v2.n148 vss_1v2.n298 4.2505
R2006 vss_1v2.n148 vss_1v2.n296 4.2505
R2007 vss_1v2.n148 vss_1v2.n294 4.2505
R2008 vss_1v2.n148 vss_1v2.n292 4.2505
R2009 vss_1v2.n148 vss_1v2.n290 4.2505
R2010 vss_1v2.n148 vss_1v2.n288 4.2505
R2011 vss_1v2.n148 vss_1v2.n286 4.2505
R2012 vss_1v2.n148 vss_1v2.n284 4.2505
R2013 vss_1v2.n148 vss_1v2.n282 4.2505
R2014 vss_1v2.n148 vss_1v2.n280 4.2505
R2015 vss_1v2.n148 vss_1v2.n792 4.2505
R2016 vss_1v2.n148 vss_1v2.n791 4.2505
R2017 vss_1v2.n148 vss_1v2.n790 4.2505
R2018 vss_1v2.n148 vss_1v2.n789 4.2505
R2019 vss_1v2.n148 vss_1v2.n788 4.2505
R2020 vss_1v2.n148 vss_1v2.n787 4.2505
R2021 vss_1v2.n148 vss_1v2.n786 4.2505
R2022 vss_1v2.n148 vss_1v2.n785 4.2505
R2023 vss_1v2.n148 vss_1v2.n784 4.2505
R2024 vss_1v2.n148 vss_1v2.n783 4.2505
R2025 vss_1v2.n148 vss_1v2.n782 4.2505
R2026 vss_1v2.n148 vss_1v2.n781 4.2505
R2027 vss_1v2.n148 vss_1v2.n780 4.2505
R2028 vss_1v2.n148 vss_1v2.n779 4.2505
R2029 vss_1v2.n148 vss_1v2.n778 4.2505
R2030 vss_1v2.n148 vss_1v2.n777 4.2505
R2031 vss_1v2.n148 vss_1v2.n776 4.2505
R2032 vss_1v2.n148 vss_1v2.n775 4.2505
R2033 vss_1v2.n148 vss_1v2.n774 4.2505
R2034 vss_1v2.n148 vss_1v2.n313 4.2505
R2035 vss_1v2.n148 vss_1v2.n311 4.2505
R2036 vss_1v2.n144 vss_1v2.n309 3.39887
R2037 vss_1v2.n148 vss_1v2.n307 4.2505
R2038 vss_1v2.n148 vss_1v2.n305 4.2505
R2039 vss_1v2.n148 vss_1v2.n303 4.2505
R2040 vss_1v2.n148 vss_1v2.n301 4.2505
R2041 vss_1v2.n148 vss_1v2.n299 4.2505
R2042 vss_1v2.n148 vss_1v2.n297 4.2505
R2043 vss_1v2.n148 vss_1v2.n295 4.2505
R2044 vss_1v2.n148 vss_1v2.n293 4.2505
R2045 vss_1v2.n148 vss_1v2.n291 4.2505
R2046 vss_1v2.n148 vss_1v2.n289 4.2505
R2047 vss_1v2.n148 vss_1v2.n287 4.2505
R2048 vss_1v2.n148 vss_1v2.n285 4.2505
R2049 vss_1v2.n148 vss_1v2.n283 4.2505
R2050 vss_1v2.n148 vss_1v2.n281 4.2505
R2051 vss_1v2.n148 vss_1v2.n279 4.2505
R2052 vss_1v2.n764 vss_1v2.n45 4.2505
R2053 vss_1v2.n41 vss_1v2.n181 3.39574
R2054 vss_1v2.n41 vss_1v2.n182 3.39589
R2055 vss_1v2.n41 vss_1v2.n185 3.39987
R2056 vss_1v2.n41 vss_1v2.n186 3.39604
R2057 vss_1v2.n41 vss_1v2.n188 3.39619
R2058 vss_1v2.n41 vss_1v2.n189 3.39635
R2059 vss_1v2.n41 vss_1v2.n192 3.399
R2060 vss_1v2.n41 vss_1v2.n195 3.3986
R2061 vss_1v2.n41 vss_1v2.n196 3.39875
R2062 vss_1v2.n41 vss_1v2.n197 3.39745
R2063 vss_1v2.n41 vss_1v2.n198 3.39696
R2064 vss_1v2.n41 vss_1v2.n199 3.39891
R2065 vss_1v2.n41 vss_1v2.n203 3.39907
R2066 vss_1v2.n41 vss_1v2.n204 3.39923
R2067 vss_1v2.n41 vss_1v2.n205 3.39939
R2068 vss_1v2.n41 vss_1v2.n206 3.39955
R2069 vss_1v2.n148 vss_1v2.n846 4.2505
R2070 vss_1v2.n148 vss_1v2.n2184 4.2505
R2071 vss_1v2.n27 vss_1v2.n1697 4.24855
R2072 vss_1v2.n27 vss_1v2.n1700 4.24855
R2073 vss_1v2.n27 vss_1v2.n1702 4.24855
R2074 vss_1v2.n27 vss_1v2.n1418 4.24855
R2075 vss_1v2.n27 vss_1v2.n617 4.24855
R2076 vss_1v2.n27 vss_1v2.n619 4.24855
R2077 vss_1v2.n1886 vss_1v2.n27 4.24837
R2078 vss_1v2.n1038 vss_1v2.n27 4.24837
R2079 vss_1v2.n1095 vss_1v2.n27 4.24837
R2080 vss_1v2.n27 vss_1v2.n435 4.24829
R2081 vss_1v2.n1475 vss_1v2.n55 4.87727
R2082 vss_1v2.n1013 vss_1v2.n1005 4.15775
R2083 vss_1v2.n1512 vss_1v2.n38 4.11285
R2084 vss_1v2.n1629 vss_1v2.n1625 4.0925
R2085 vss_1v2.n1509 vss_1v2.n1329 4.0763
R2086 vss_1v2.n1570 vss_1v2.t290 4.0763
R2087 vss_1v2.n1600 vss_1v2.n1459 4.0763
R2088 vss_1v2.n1008 vss_1v2.t380 4.0763
R2089 vss_1v2.n64 vss_1v2.n1324 5.12634
R2090 vss_1v2.n1748 vss_1v2.n1323 4.05512
R2091 vss_1v2.n1747 vss_1v2.n1322 4.05512
R2092 vss_1v2.n1744 vss_1v2.n1318 4.05512
R2093 vss_1v2.n1743 vss_1v2.n1317 4.05512
R2094 vss_1v2.n1742 vss_1v2.n1316 4.05512
R2095 vss_1v2.n1741 vss_1v2.n1315 4.05512
R2096 vss_1v2.n1740 vss_1v2.n1314 4.05512
R2097 vss_1v2.n1738 vss_1v2.n1312 4.05512
R2098 vss_1v2.n1737 vss_1v2.n1311 4.05512
R2099 vss_1v2.n1734 vss_1v2.n1308 4.05512
R2100 vss_1v2.n1730 vss_1v2.n1305 4.05512
R2101 vss_1v2.n1729 vss_1v2.n1304 4.05512
R2102 vss_1v2.n1727 vss_1v2.n1301 4.05512
R2103 vss_1v2.n1726 vss_1v2.n1300 4.05512
R2104 vss_1v2.n1651 vss_1v2.n1650 4.0205
R2105 vss_1v2.t268 vss_1v2.n288 3.96904
R2106 vss_1v2.n1682 vss_1v2.n61 4.61102
R2107 vss_1v2.n60 vss_1v2.n318 4.61101
R2108 vss_1v2.t278 vss_1v2.n367 3.86178
R2109 vss_1v2.n1599 vss_1v2.n369 3.86178
R2110 vss_1v2.n1913 vss_1v2.n381 3.86178
R2111 vss_1v2.n1934 vss_1v2.n310 3.86178
R2112 vss_1v2.n2185 vss_1v2.n626 3.86178
R2113 vss_1v2.n195 vss_1v2.n595 3.84911
R2114 vss_1v2.n1468 vss_1v2.t265 3.75452
R2115 vss_1v2.n2184 vss_1v2.n625 3.74322
R2116 vss_1v2.n244 vss_1v2.t284 3.64726
R2117 vss_1v2.n242 vss_1v2.t287 3.64726
R2118 vss_1v2.n246 vss_1v2.t289 3.64726
R2119 vss_1v2.n240 vss_1v2.t291 3.64726
R2120 vss_1v2.n248 vss_1v2.t293 3.64726
R2121 vss_1v2.n1581 vss_1v2.n360 3.64726
R2122 vss_1v2.n1594 vss_1v2.n1429 3.64726
R2123 vss_1v2.n1552 vss_1v2.t372 3.64726
R2124 vss_1v2.t375 vss_1v2.t73 3.64726
R2125 vss_1v2.t243 vss_1v2.t91 3.64726
R2126 vss_1v2.n1947 vss_1v2.t246 3.64726
R2127 vss_1v2.n1720 vss_1v2.n1296 3.63926
R2128 vss_1v2.n1719 vss_1v2.n1293 3.63926
R2129 vss_1v2.n1716 vss_1v2.n1292 3.63926
R2130 vss_1v2.n1714 vss_1v2.n1290 3.63926
R2131 vss_1v2.n1713 vss_1v2.n1289 3.63926
R2132 vss_1v2.n1712 vss_1v2.n1288 3.63926
R2133 vss_1v2.n1711 vss_1v2.n1287 3.63926
R2134 vss_1v2.n1710 vss_1v2.n1286 3.63926
R2135 vss_1v2.n1708 vss_1v2.n1284 3.63926
R2136 vss_1v2.n1707 vss_1v2.n1283 3.63926
R2137 vss_1v2.n1706 vss_1v2.n1282 3.63926
R2138 vss_1v2.n1705 vss_1v2.n1281 3.63926
R2139 vss_1v2.n27 vss_1v2.n143 2.92544
R2140 vss_1v2.t29 vss_1v2.n579 3.63926
R2141 vss_1v2.t327 vss_1v2.n1307 3.53529
R2142 vss_1v2.t325 vss_1v2.n1291 3.53529
R2143 vss_1v2.n198 vss_1v2.t348 3.53529
R2144 vss_1v2.n189 vss_1v2.t351 3.53529
R2145 vss_1v2.n1594 vss_1v2.n1593 3.43275
R2146 vss_1v2.n1480 vss_1v2.n54 3.86959
R2147 vss_1v2.n1972 vss_1v2.n283 3.43275
R2148 vss_1v2.n351 vss_1v2.n284 3.43275
R2149 vss_1v2.n352 vss_1v2.n285 3.43275
R2150 vss_1v2.n354 vss_1v2.n287 3.43275
R2151 vss_1v2.n1937 vss_1v2.n487 3.43275
R2152 vss_1v2.t335 vss_1v2.n485 3.43275
R2153 vss_1v2.n1945 vss_1v2.n303 3.43275
R2154 vss_1v2.n819 vss_1v2.n469 3.43275
R2155 vss_1v2.n777 vss_1v2.n550 3.43275
R2156 vss_1v2.n825 vss_1v2.n463 3.43275
R2157 vss_1v2.n779 vss_1v2.n554 3.43275
R2158 vss_1v2.n780 vss_1v2.n556 3.43275
R2159 vss_1v2.n829 vss_1v2.n459 3.43275
R2160 vss_1v2.n831 vss_1v2.n457 3.43275
R2161 vss_1v2.n782 vss_1v2.n560 3.43275
R2162 vss_1v2.n835 vss_1v2.n453 3.43275
R2163 vss_1v2.n785 vss_1v2.n566 3.43275
R2164 vss_1v2.n840 vss_1v2.n447 3.43275
R2165 vss_1v2.n841 vss_1v2.n445 3.43275
R2166 vss_1v2.n789 vss_1v2.n572 3.43275
R2167 vss_1v2.n844 vss_1v2.n442 3.43275
R2168 vss_1v2.n791 vss_1v2.n574 3.43275
R2169 vss_1v2.n792 vss_1v2.n575 3.43275
R2170 vss_1v2.n2185 vss_1v2.n440 3.43275
R2171 vss_1v2.n1720 vss_1v2.n1297 3.43133
R2172 vss_1v2.n1719 vss_1v2.n1296 3.43133
R2173 vss_1v2.n1716 vss_1v2.n1293 3.43133
R2174 vss_1v2.n1715 vss_1v2.n1292 3.43133
R2175 vss_1v2.n1714 vss_1v2.n1291 3.43133
R2176 vss_1v2.n1713 vss_1v2.n1290 3.43133
R2177 vss_1v2.n1712 vss_1v2.n1289 3.43133
R2178 vss_1v2.n1711 vss_1v2.n1288 3.43133
R2179 vss_1v2.n1710 vss_1v2.n1287 3.43133
R2180 vss_1v2.n1709 vss_1v2.n1286 3.43133
R2181 vss_1v2.n1708 vss_1v2.n1285 3.43133
R2182 vss_1v2.n1707 vss_1v2.n1284 3.43133
R2183 vss_1v2.n1705 vss_1v2.n1282 3.43133
R2184 vss_1v2.n143 vss_1v2.n1281 2.09809
R2185 vss_1v2.n65 vss_1v2.t273 3.87236
R2186 vss_1v2.n72 vss_1v2.n73 0.00375095
R2187 vss_1v2.n846 vss_1v2.n625 3.32736
R2188 vss_1v2.n27 vss_1v2.n71 4.01076
R2189 vss_1v2.n42 vss_1v2.n41 1.68614
R2190 vss_1v2.n1579 vss_1v2.n1345 3.21823
R2191 vss_1v2.n249 vss_1v2.n1492 3.21823
R2192 vss_1v2.n237 vss_1v2.n1491 3.21823
R2193 vss_1v2.n236 vss_1v2.n1490 3.21823
R2194 vss_1v2.n251 vss_1v2.n1489 3.21823
R2195 vss_1v2.n1561 vss_1v2.n252 3.21823
R2196 vss_1v2.n234 vss_1v2.n1488 3.21823
R2197 vss_1v2.n253 vss_1v2.n1487 3.21823
R2198 vss_1v2.t364 vss_1v2.n1484 3.21823
R2199 vss_1v2.n232 vss_1v2.n1483 3.21823
R2200 vss_1v2.t366 vss_1v2.n1482 3.21823
R2201 vss_1v2.n359 vss_1v2.n1610 3.21823
R2202 vss_1v2.n1549 vss_1v2.n1441 3.21823
R2203 vss_1v2.t151 vss_1v2.n376 3.21823
R2204 vss_1v2.n1478 vss_1v2.n1477 3.21823
R2205 vss_1v2.n1684 vss_1v2.t78 3.21823
R2206 vss_1v2.n1974 vss_1v2.n972 3.21823
R2207 vss_1v2.t252 vss_1v2.n819 3.21823
R2208 vss_1v2.n320 vss_1v2.n776 3.21823
R2209 vss_1v2.t254 vss_1v2.n777 3.21823
R2210 vss_1v2.n324 vss_1v2.n825 3.21823
R2211 vss_1v2.n325 vss_1v2.n779 3.21823
R2212 vss_1v2.n326 vss_1v2.n827 3.21823
R2213 vss_1v2.n328 vss_1v2.n829 3.21823
R2214 vss_1v2.n329 vss_1v2.n781 3.21823
R2215 vss_1v2.n331 vss_1v2.n782 3.21823
R2216 vss_1v2.n332 vss_1v2.n833 3.21823
R2217 vss_1v2.t256 vss_1v2.n56 3.38872
R2218 vss_1v2.n1013 vss_1v2.t379 3.08517
R2219 vss_1v2.n1748 vss_1v2.n1324 3.01547
R2220 vss_1v2.n1747 vss_1v2.n1323 3.01547
R2221 vss_1v2.n1745 vss_1v2.n1322 3.01547
R2222 vss_1v2.n1744 vss_1v2.n1319 3.01547
R2223 vss_1v2.n1743 vss_1v2.n1318 3.01547
R2224 vss_1v2.n1741 vss_1v2.n1316 3.01547
R2225 vss_1v2.n1740 vss_1v2.n1315 3.01547
R2226 vss_1v2.n1738 vss_1v2.n1314 3.01547
R2227 vss_1v2.n1737 vss_1v2.n1312 3.01547
R2228 vss_1v2.n1734 vss_1v2.n1311 3.01547
R2229 vss_1v2.n1733 vss_1v2.n1308 3.01547
R2230 vss_1v2.n1730 vss_1v2.n1307 3.01547
R2231 vss_1v2.n1729 vss_1v2.n1305 3.01547
R2232 vss_1v2.n1727 vss_1v2.n1304 3.01547
R2233 vss_1v2.n1726 vss_1v2.n1301 3.01547
R2234 vss_1v2.n1566 vss_1v2.t295 3.00372
R2235 vss_1v2.n238 vss_1v2.n1368 3.00372
R2236 vss_1v2.n249 vss_1v2.n1369 3.00372
R2237 vss_1v2.n250 vss_1v2.n1375 3.00372
R2238 vss_1v2.n236 vss_1v2.n1380 3.00372
R2239 vss_1v2.n235 vss_1v2.n1385 3.00372
R2240 vss_1v2.n252 vss_1v2.n1386 3.00372
R2241 vss_1v2.n234 vss_1v2.n1391 3.00372
R2242 vss_1v2.n233 vss_1v2.n1397 3.00372
R2243 vss_1v2.n254 vss_1v2.n1398 3.00372
R2244 vss_1v2.n255 vss_1v2.n1404 3.00372
R2245 vss_1v2.n231 vss_1v2.n1415 3.00372
R2246 vss_1v2.n1557 vss_1v2.t367 3.00372
R2247 vss_1v2.n359 vss_1v2.n1416 3.00372
R2248 vss_1v2.n1997 vss_1v2.n345 3.00372
R2249 vss_1v2.n349 vss_1v2.n280 3.00372
R2250 vss_1v2.n350 vss_1v2.n281 3.00372
R2251 vss_1v2.n1003 vss_1v2.n282 3.00372
R2252 vss_1v2.t251 vss_1v2.n546 3.00372
R2253 vss_1v2.n1950 vss_1v2.n775 3.00372
R2254 vss_1v2.t255 vss_1v2.n552 3.00372
R2255 vss_1v2.n1926 vss_1v2.n562 3.00372
R2256 vss_1v2.n27 vss_1v2.n1723 3.00271
R2257 vss_1v2.n27 vss_1v2.n595 3.00271
R2258 vss_1v2.n27 vss_1v2.n1013 2.92343
R2259 vss_1v2.n1606 vss_1v2.t264 2.89646
R2260 vss_1v2.n1472 vss_1v2.t266 2.89646
R2261 vss_1v2.n348 vss_1v2.t238 2.89646
R2262 vss_1v2.n973 vss_1v2.t269 2.89646
R2263 vss_1v2.t260 vss_1v2.n296 2.89646
R2264 vss_1v2.n1588 vss_1v2.n1392 2.7892
R2265 vss_1v2.n1559 vss_1v2.n233 2.7892
R2266 vss_1v2.n1590 vss_1v2.t366 2.7892
R2267 vss_1v2.t368 vss_1v2.n1420 2.7892
R2268 vss_1v2.t370 vss_1v2.n1426 2.7892
R2269 vss_1v2.t372 vss_1v2.n1551 2.7892
R2270 vss_1v2.n1680 vss_1v2.n1679 2.7892
R2271 vss_1v2.t272 vss_1v2.n1684 2.7892
R2272 vss_1v2.n1913 vss_1v2.n66 3.05238
R2273 vss_1v2.t258 vss_1v2.n358 2.7892
R2274 vss_1v2.n1963 vss_1v2.n323 2.7892
R2275 vss_1v2.n65 vss_1v2.n1916 18.8783
R2276 vss_1v2.t324 vss_1v2.n942 2.72667
R2277 vss_1v2.t324 vss_1v2.n943 2.72667
R2278 vss_1v2.t324 vss_1v2.n1996 2.72667
R2279 vss_1v2.t324 vss_1v2.n1989 2.72667
R2280 vss_1v2.t262 vss_1v2.n1454 2.68194
R2281 vss_1v2.t236 vss_1v2.n508 2.68194
R2282 vss_1v2.t149 vss_1v2.n1334 2.57469
R2283 vss_1v2.n1566 vss_1v2.n1565 2.57469
R2284 vss_1v2.t59 vss_1v2.n1485 2.57469
R2285 vss_1v2.t283 vss_1v2.n372 2.57469
R2286 vss_1v2.n1933 vss_1v2.n313 2.57469
R2287 vss_1v2.n1933 vss_1v2.n473 2.57469
R2288 vss_1v2.t253 vss_1v2.t106 2.57469
R2289 vss_1v2.n1930 vss_1v2.n823 2.57469
R2290 vss_1v2.t109 vss_1v2.n823 2.57469
R2291 vss_1v2.n1964 vss_1v2.n461 2.57469
R2292 vss_1v2.n1966 vss_1v2.n835 2.57469
R2293 vss_1v2.n1969 vss_1v2.n843 2.57469
R2294 vss_1v2.t1 vss_1v2.n1319 2.49565
R2295 vss_1v2.t17 vss_1v2.n1283 2.49565
R2296 vss_1v2.n42 vss_1v2.t5 1.23796
R2297 vss_1v2.n2217 vss_1v2 2.37044
R2298 vss_1v2.n1580 vss_1v2.n239 2.36017
R2299 vss_1v2.n1592 vss_1v2.n1425 2.36017
R2300 vss_1v2.n1550 vss_1v2.t374 2.36017
R2301 vss_1v2.n1679 vss_1v2.t154 2.36017
R2302 vss_1v2.n1946 vss_1v2.t244 2.36017
R2303 vss_1v2.n1924 vss_1v2.t358 2.36017
R2304 vss_1v2.n61 vss_1v2.n1678 1.64381
R2305 vss_1v2.t348 vss_1v2.n601 2.18375
R2306 vss_1v2.n1571 vss_1v2.t62 2.14566
R2307 vss_1v2.n345 vss_1v2.n509 2.14566
R2308 vss_1v2.n348 vss_1v2.n507 2.14566
R2309 vss_1v2.n349 vss_1v2.n510 2.14566
R2310 vss_1v2.n350 vss_1v2.n505 2.14566
R2311 vss_1v2.n1003 vss_1v2.n512 2.14566
R2312 vss_1v2.t274 vss_1v2.n286 2.14566
R2313 vss_1v2.t275 vss_1v2.n526 2.14566
R2314 vss_1v2.n1946 vss_1v2.n306 2.14566
R2315 vss_1v2.n310 vss_1v2.n477 2.14566
R2316 vss_1v2.n311 vss_1v2.n540 2.14566
R2317 vss_1v2.n313 vss_1v2.n542 2.14566
R2318 vss_1v2.n314 vss_1v2.n473 2.14566
R2319 vss_1v2.n817 vss_1v2.n471 2.14566
R2320 vss_1v2.n1932 vss_1v2.n548 2.14566
R2321 vss_1v2.n1968 vss_1v2.n571 2.14566
R2322 vss_1v2.n1603 vss_1v2.n39 2.11207
R2323 vss_1v2.n18 vss_1v2.n1918 2.11201
R2324 vss_1v2.n1649 vss_1v2.n1648 2.09363
R2325 vss_1v2.n1539 vss_1v2.n15 2.07969
R2326 vss_1v2.n216 vss_1v2.n225 1.37997
R2327 vss_1v2.n1470 vss_1v2.n63 4.87729
R2328 vss_1v2.n1709 vss_1v2.t12 1.97583
R2329 vss_1v2.n79 vss_1v2.n214 1.94918
R2330 vss_1v2.t145 vss_1v2.n1508 1.93114
R2331 vss_1v2.n1573 vss_1v2.n243 1.93114
R2332 vss_1v2.n244 vss_1v2.n1503 1.93114
R2333 vss_1v2.n242 vss_1v2.n1501 1.93114
R2334 vss_1v2.t288 vss_1v2.n1500 1.93114
R2335 vss_1v2.n246 vss_1v2.n1499 1.93114
R2336 vss_1v2.t290 vss_1v2.n1498 1.93114
R2337 vss_1v2.n247 vss_1v2.n1497 1.93114
R2338 vss_1v2.n1569 vss_1v2.n240 1.93114
R2339 vss_1v2.t292 vss_1v2.n1496 1.93114
R2340 vss_1v2.n1580 vss_1v2.t318 1.93114
R2341 vss_1v2.n239 vss_1v2.n1495 1.93114
R2342 vss_1v2.t294 vss_1v2.n1494 1.93114
R2343 vss_1v2.n360 vss_1v2.n1493 1.93114
R2344 vss_1v2.n1582 vss_1v2.t296 1.93114
R2345 vss_1v2.n1563 vss_1v2.n251 1.93114
R2346 vss_1v2.t300 vss_1v2.n1586 1.93114
R2347 vss_1v2.t56 vss_1v2.n1409 1.93114
R2348 vss_1v2.n1550 vss_1v2.n1436 1.93114
R2349 vss_1v2.n1473 vss_1v2.t282 1.93114
R2350 vss_1v2.t273 vss_1v2.n1006 1.93114
R2351 vss_1v2.t301 vss_1v2.n780 1.93114
R2352 vss_1v2.t305 vss_1v2.n783 1.93114
R2353 vss_1v2.n334 vss_1v2.n784 1.93114
R2354 vss_1v2.n334 vss_1v2.n451 1.93114
R2355 vss_1v2.t307 vss_1v2.n837 1.93114
R2356 vss_1v2.t307 vss_1v2.n566 1.93114
R2357 vss_1v2.n335 vss_1v2.n449 1.93114
R2358 vss_1v2.n336 vss_1v2.n839 1.93114
R2359 vss_1v2.n336 vss_1v2.n568 1.93114
R2360 vss_1v2.t310 vss_1v2.n786 1.93114
R2361 vss_1v2.t310 vss_1v2.n447 1.93114
R2362 vss_1v2.n337 vss_1v2.n840 1.93114
R2363 vss_1v2.n337 vss_1v2.n570 1.93114
R2364 vss_1v2.n338 vss_1v2.n787 1.93114
R2365 vss_1v2.t312 vss_1v2.n841 1.93114
R2366 vss_1v2.t312 vss_1v2.n571 1.93114
R2367 vss_1v2.n339 vss_1v2.n788 1.93114
R2368 vss_1v2.n339 vss_1v2.n444 1.93114
R2369 vss_1v2.n340 vss_1v2.n572 1.93114
R2370 vss_1v2.t314 vss_1v2.n789 1.93114
R2371 vss_1v2.n341 vss_1v2.n843 1.93114
R2372 vss_1v2.n341 vss_1v2.n573 1.93114
R2373 vss_1v2.n342 vss_1v2.n442 1.93114
R2374 vss_1v2.n343 vss_1v2.n791 1.93114
R2375 vss_1v2.n343 vss_1v2.n441 1.93114
R2376 vss_1v2.n344 vss_1v2.n845 1.93114
R2377 vss_1v2.n344 vss_1v2.n575 1.93114
R2378 vss_1v2.t192 vss_1v2.n792 1.93114
R2379 vss_1v2.n66 vss_1v2.n39 0.982756
R2380 vss_1v2.n1601 vss_1v2.n39 1.87338
R2381 vss_1v2.n18 vss_1v2.n1004 1.87336
R2382 vss_1v2.n1650 vss_1v2.n1649 1.8605
R2383 vss_1v2.t81 vss_1v2.t270 1.82388
R2384 vss_1v2.t9 vss_1v2.t236 1.82388
R2385 vss_1v2.n194 vss_1v2.n593 1.7679
R2386 vss_1v2.n193 vss_1v2.n592 1.7679
R2387 vss_1v2.n192 vss_1v2.n591 1.7679
R2388 vss_1v2.n191 vss_1v2.n590 1.7679
R2389 vss_1v2.n190 vss_1v2.n587 1.7679
R2390 vss_1v2.t351 vss_1v2.n587 1.7679
R2391 vss_1v2.n189 vss_1v2.n586 1.7679
R2392 vss_1v2.n188 vss_1v2.n584 1.7679
R2393 vss_1v2.n187 vss_1v2.n583 1.7679
R2394 vss_1v2.n186 vss_1v2.n582 1.7679
R2395 vss_1v2.n185 vss_1v2.n581 1.7679
R2396 vss_1v2.n184 vss_1v2.n579 1.7679
R2397 vss_1v2.n183 vss_1v2.n578 1.7679
R2398 vss_1v2.n182 vss_1v2.n577 1.7679
R2399 vss_1v2.n181 vss_1v2.n576 1.7679
R2400 vss_1v2.n1677 vss_1v2.n58 3.49493
R2401 vss_1v2.n1578 vss_1v2.n1577 1.71662
R2402 vss_1v2.n1564 vss_1v2.t276 1.71662
R2403 vss_1v2.n1558 vss_1v2.t365 1.71662
R2404 vss_1v2.n1556 vss_1v2.n1555 1.71662
R2405 vss_1v2.n1645 vss_1v2.n1624 1.71662
R2406 vss_1v2.n1431 vss_1v2.n361 1.71662
R2407 vss_1v2.n1433 vss_1v2.n362 1.71662
R2408 vss_1v2.n1435 vss_1v2.n363 1.71662
R2409 vss_1v2.n1438 vss_1v2.n365 1.71662
R2410 vss_1v2.n1442 vss_1v2.n367 1.71662
R2411 vss_1v2.n1444 vss_1v2.n368 1.71662
R2412 vss_1v2.n1446 vss_1v2.n369 1.71662
R2413 vss_1v2.n1448 vss_1v2.n370 1.71662
R2414 vss_1v2.n1451 vss_1v2.n372 1.71662
R2415 vss_1v2.n1453 vss_1v2.n373 1.71662
R2416 vss_1v2.n1545 vss_1v2.n374 1.71662
R2417 vss_1v2.n1456 vss_1v2.n53 2.40286
R2418 vss_1v2.n1460 vss_1v2.n57 2.11614
R2419 vss_1v2.n1608 vss_1v2.n1607 1.71662
R2420 vss_1v2.n1915 vss_1v2.n346 1.71662
R2421 vss_1v2.n1014 vss_1v2.n347 1.71662
R2422 vss_1v2.n1016 vss_1v2.n1015 1.71662
R2423 vss_1v2.n221 vss_1v2.n508 1.71662
R2424 vss_1v2.n974 vss_1v2.n509 1.71662
R2425 vss_1v2.n976 vss_1v2.n510 1.71662
R2426 vss_1v2.n978 vss_1v2.n512 1.71662
R2427 vss_1v2.n1972 vss_1v2.n503 1.71662
R2428 vss_1v2.n979 vss_1v2.n503 1.71662
R2429 vss_1v2.n980 vss_1v2.n514 1.71662
R2430 vss_1v2.n352 vss_1v2.n501 1.71662
R2431 vss_1v2.n981 vss_1v2.n501 1.71662
R2432 vss_1v2.n353 vss_1v2.n516 1.71662
R2433 vss_1v2.n354 vss_1v2.n499 1.71662
R2434 vss_1v2.n983 vss_1v2.n499 1.71662
R2435 vss_1v2.n984 vss_1v2.n518 1.71662
R2436 vss_1v2.n985 vss_1v2.n497 1.71662
R2437 vss_1v2.n1940 vss_1v2.n291 1.71662
R2438 vss_1v2.n986 vss_1v2.n292 1.71662
R2439 vss_1v2.n987 vss_1v2.n293 1.71662
R2440 vss_1v2.n988 vss_1v2.n294 1.71662
R2441 vss_1v2.n989 vss_1v2.n295 1.71662
R2442 vss_1v2.n990 vss_1v2.n296 1.71662
R2443 vss_1v2.n991 vss_1v2.n297 1.71662
R2444 vss_1v2.n993 vss_1v2.n299 1.71662
R2445 vss_1v2.n1937 vss_1v2.n299 1.71662
R2446 vss_1v2.n994 vss_1v2.n300 1.71662
R2447 vss_1v2.n995 vss_1v2.n301 1.71662
R2448 vss_1v2.n301 vss_1v2.t335 1.71662
R2449 vss_1v2.n996 vss_1v2.n302 1.71662
R2450 vss_1v2.n998 vss_1v2.n304 1.71662
R2451 vss_1v2.n1000 vss_1v2.n306 1.71662
R2452 vss_1v2.n1001 vss_1v2.n307 1.71662
R2453 vss_1v2.n1002 vss_1v2.n308 1.71662
R2454 vss_1v2.n1973 vss_1v2.n309 1.71662
R2455 vss_1v2.n1948 vss_1v2.n475 1.71662
R2456 vss_1v2.n1949 vss_1v2.n774 1.71662
R2457 vss_1v2.n1951 vss_1v2.n821 1.71662
R2458 vss_1v2.t304 vss_1v2.n454 1.71662
R2459 vss_1v2.n833 vss_1v2.t304 1.71662
R2460 vss_1v2.t306 vss_1v2.n564 1.71662
R2461 vss_1v2.n784 vss_1v2.t306 1.71662
R2462 vss_1v2.n1925 vss_1v2.n451 1.71662
R2463 vss_1v2.n1925 vss_1v2.n837 1.71662
R2464 vss_1v2.t308 vss_1v2.n449 1.71662
R2465 vss_1v2.n839 vss_1v2.t308 1.71662
R2466 vss_1v2.t311 vss_1v2.n570 1.71662
R2467 vss_1v2.n787 vss_1v2.t311 1.71662
R2468 vss_1v2.t313 vss_1v2.n444 1.71662
R2469 vss_1v2.n842 vss_1v2.t313 1.71662
R2470 vss_1v2.n1922 vss_1v2.n842 1.71662
R2471 vss_1v2.t315 vss_1v2.n573 1.71662
R2472 vss_1v2.n790 vss_1v2.t315 1.71662
R2473 vss_1v2.t317 vss_1v2.n441 1.71662
R2474 vss_1v2.n1970 vss_1v2.n440 1.71662
R2475 vss_1v2.n1515 vss_1v2.n1514 1.69247
R2476 vss_1v2.n156 vss_1v2.t3 1.6714
R2477 vss_1v2.n666 vss_1v2.t27 1.67136
R2478 vss_1v2.n1270 vss_1v2.t136 1.67135
R2479 vss_1v2.n1058 vss_1v2.t32 1.67135
R2480 vss_1v2.n1957 vss_1v2.t125 1.67135
R2481 vss_1v2.t235 vss_1v2.n26 1.67135
R2482 vss_1v2.n1113 vss_1v2.t41 1.67129
R2483 vss_1v2.t133 vss_1v2.n2212 1.67129
R2484 vss_1v2.t13 vss_1v2.n1017 1.67126
R2485 vss_1v2.n1888 vss_1v2.t2 1.67122
R2486 vss_1v2.n2210 vss_1v2.t130 1.67122
R2487 vss_1v2.n2205 vss_1v2.t231 1.67122
R2488 vss_1v2.n2082 vss_1v2.t229 1.67121
R2489 vss_1v2.n1267 vss_1v2.t135 1.67118
R2490 vss_1v2.n763 vss_1v2.t204 1.67118
R2491 vss_1v2.t7 vss_1v2.n667 1.67118
R2492 vss_1v2.n2199 vss_1v2.t6 1.67118
R2493 vss_1v2.n24 vss_1v2.t226 1.67118
R2494 vss_1v2.n1112 vss_1v2.t40 1.67114
R2495 vss_1v2.n1522 vss_1v2.t50 1.67114
R2496 vss_1v2.n1656 vss_1v2.t34 1.67114
R2497 vss_1v2.n1910 vss_1v2.t18 1.67114
R2498 vss_1v2.t140 vss_1v2.n1151 1.67114
R2499 vss_1v2.n1955 vss_1v2.t124 1.67114
R2500 vss_1v2.n1055 vss_1v2.t20 1.67107
R2501 vss_1v2.n1655 vss_1v2.t38 1.67107
R2502 vss_1v2.n1168 vss_1v2.t143 1.67107
R2503 vss_1v2.n2103 vss_1v2.t228 1.67107
R2504 vss_1v2.n769 vss_1v2.t205 1.67107
R2505 vss_1v2.t26 vss_1v2.n659 1.67107
R2506 vss_1v2.t223 vss_1v2.n2200 1.67107
R2507 vss_1v2.t46 vss_1v2.n1517 1.67091
R2508 vss_1v2.n1519 vss_1v2.t46 1.66919
R2509 vss_1v2.t20 vss_1v2.n1054 1.66913
R2510 vss_1v2.n1659 vss_1v2.t38 1.66913
R2511 vss_1v2.n1164 vss_1v2.t143 1.66913
R2512 vss_1v2.n2106 vss_1v2.t228 1.66913
R2513 vss_1v2.n173 vss_1v2.t205 1.66913
R2514 vss_1v2.n663 vss_1v2.t26 1.66913
R2515 vss_1v2.n2201 vss_1v2.t223 1.66913
R2516 vss_1v2.t40 vss_1v2.n1111 1.66909
R2517 vss_1v2.n1518 vss_1v2.t50 1.66909
R2518 vss_1v2.t34 vss_1v2.n1653 1.66909
R2519 vss_1v2.n1906 vss_1v2.t18 1.66909
R2520 vss_1v2.n1165 vss_1v2.t140 1.66909
R2521 vss_1v2.t124 vss_1v2.n1954 1.66909
R2522 vss_1v2.t135 vss_1v2.n1266 1.66904
R2523 vss_1v2.t204 vss_1v2.n762 1.66904
R2524 vss_1v2.n668 vss_1v2.t7 1.66904
R2525 vss_1v2.n2196 vss_1v2.t6 1.66904
R2526 vss_1v2.t226 vss_1v2.n25 1.66904
R2527 vss_1v2.n1907 vss_1v2.t13 1.669
R2528 vss_1v2.t229 vss_1v2.n2081 1.66899
R2529 vss_1v2.n1116 vss_1v2.t41 1.66895
R2530 vss_1v2.n22 vss_1v2.t133 1.66895
R2531 vss_1v2.n1889 vss_1v2.t2 1.66892
R2532 vss_1v2.n2209 vss_1v2.t130 1.66892
R2533 vss_1v2.t231 vss_1v2.n2204 1.66892
R2534 vss_1v2.n1273 vss_1v2.t136 1.6689
R2535 vss_1v2.n1061 vss_1v2.t32 1.6689
R2536 vss_1v2.n1960 vss_1v2.t125 1.6689
R2537 vss_1v2.n23 vss_1v2.t235 1.6689
R2538 vss_1v2.n662 vss_1v2.t27 1.66884
R2539 vss_1v2.t3 vss_1v2.n1891 1.66879
R2540 vss_1v2.t15 vss_1v2.n1317 1.66393
R2541 vss_1v2.t12 vss_1v2.n1285 1.66393
R2542 vss_1v2.n183 vss_1v2.t29 1.66393
R2543 vss_1v2.t269 vss_1v2.n290 1.60937
R2544 vss_1v2.n1745 vss_1v2.t1 1.55997
R2545 vss_1v2.n1572 vss_1v2.t286 1.50211
R2546 vss_1v2.n1576 vss_1v2.n245 1.50211
R2547 vss_1v2.n1571 vss_1v2.n1338 1.50211
R2548 vss_1v2.n1589 vss_1v2.n1403 1.50211
R2549 vss_1v2.n1589 vss_1v2.t364 1.50211
R2550 vss_1v2.n1558 vss_1v2.n255 1.50211
R2551 vss_1v2.n1445 vss_1v2.t278 1.50211
R2552 vss_1v2.n1599 vss_1v2.n1449 1.50211
R2553 vss_1v2.t154 vss_1v2.n377 1.50211
R2554 vss_1v2.n977 vss_1v2.t168 1.50211
R2555 vss_1v2.t187 vss_1v2.n514 1.50211
R2556 vss_1v2.n1951 vss_1v2.n321 1.50211
R2557 vss_1v2.t302 vss_1v2.n781 1.50211
R2558 vss_1v2.n1921 vss_1v2.n342 1.50211
R2559 vss_1v2.t189 vss_1v2.t316 1.50211
R2560 vss_1v2.n38 vss_1v2.n1486 1.44381
R2561 vss_1v2.t107 vss_1v2.n971 1.44381
R2562 vss_1v2.n59 vss_1v2.n1463 1.2392
R2563 vss_1v2.n62 vss_1v2.n1465 1.23936
R2564 vss_1v2.n216 vss_1v2.n1515 1.42952
R2565 vss_1v2.n110 vss_1v2.n27 1.40733
R2566 vss_1v2.n1531 vss_1v2.t280 1.40668
R2567 vss_1v2.t280 vss_1v2.t279 1.40668
R2568 vss_1v2.n948 vss_1v2.t336 1.40668
R2569 vss_1v2.t336 vss_1v2.t337 1.40668
R2570 vss_1v2.t264 vss_1v2.n1464 1.39485
R2571 vss_1v2.n949 vss_1v2.n147 1.38459
R2572 vss_1v2.n951 vss_1v2.n145 1.38459
R2573 vss_1v2.n950 vss_1v2.n146 1.38393
R2574 vss_1v2.n1534 vss_1v2.n51 1.44423
R2575 vss_1v2.n1537 vss_1v2.n43 1.45266
R2576 vss_1v2.n1538 vss_1v2.n74 1.43131
R2577 vss_1v2.n1534 vss_1v2.n1533 1.37412
R2578 vss_1v2.n1537 vss_1v2.n1536 1.37412
R2579 vss_1v2.n1538 vss_1v2.n100 1.39367
R2580 vss_1v2.n950 vss_1v2.n70 1.41215
R2581 vss_1v2.n951 vss_1v2.n76 1.38685
R2582 vss_1v2.n74 vss_1v2.n13 0.666805
R2583 vss_1v2.n51 vss_1v2.n13 0.532773
R2584 vss_1v2.n43 vss_1v2.n13 0.443212
R2585 vss_1v2.n1742 vss_1v2.t15 1.35204
R2586 vss_1v2.n42 vss_1v2.n612 2.07812
R2587 vss_1v2.n206 vss_1v2.n611 1.35204
R2588 vss_1v2.n205 vss_1v2.n609 1.35204
R2589 vss_1v2.n204 vss_1v2.n608 1.35204
R2590 vss_1v2.n203 vss_1v2.n606 1.35204
R2591 vss_1v2.n202 vss_1v2.n605 1.35204
R2592 vss_1v2.n201 vss_1v2.n604 1.35204
R2593 vss_1v2.n200 vss_1v2.n603 1.35204
R2594 vss_1v2.n199 vss_1v2.n601 1.35204
R2595 vss_1v2.n198 vss_1v2.n600 1.35204
R2596 vss_1v2.n197 vss_1v2.n598 1.35204
R2597 vss_1v2.n196 vss_1v2.n597 1.35204
R2598 vss_1v2.n1511 vss_1v2.n1510 1.35117
R2599 vss_1v2.n1615 vss_1v2.n1611 1.3405
R2600 vss_1v2.n1643 vss_1v2.n1635 1.3405
R2601 vss_1v2.n39 vss_1v2.n35 0.921371
R2602 vss_1v2.n1905 vss_1v2.n78 1.33053
R2603 vss_1v2.n1869 vss_1v2.n1774 1.29461
R2604 vss_1v2.n2174 vss_1v2.n2173 1.29461
R2605 vss_1v2.t324 vss_1v2.t271 1.29171
R2606 vss_1v2.n1568 vss_1v2.n1567 1.28759
R2607 vss_1v2.t296 vss_1v2.n238 1.28759
R2608 vss_1v2.t298 vss_1v2.n250 1.28759
R2609 vss_1v2.n1547 vss_1v2.n1546 1.28759
R2610 vss_1v2.t282 vss_1v2.n1472 1.28759
R2611 vss_1v2.t323 vss_1v2.n1005 1.28759
R2612 vss_1v2.n353 vss_1v2.t274 1.28759
R2613 vss_1v2.n1942 vss_1v2.n292 1.28759
R2614 vss_1v2.n1943 vss_1v2.n298 1.28759
R2615 vss_1v2.n1934 vss_1v2.n540 1.28759
R2616 vss_1v2.n972 vss_1v2.n817 1.28759
R2617 vss_1v2.n1932 vss_1v2.n776 1.28759
R2618 vss_1v2.n1965 vss_1v2.n558 1.28759
R2619 vss_1v2.t303 vss_1v2.n330 1.28759
R2620 vss_1v2.n333 vss_1v2.t305 1.28759
R2621 vss_1v2.n1966 vss_1v2.n564 1.28759
R2622 vss_1v2.n1967 vss_1v2.n785 1.28759
R2623 vss_1v2.n1968 vss_1v2.n788 1.28759
R2624 vss_1v2.t111 vss_1v2.n443 1.28759
R2625 vss_1v2.n86 vss_1v2.n27 0.639912
R2626 vss_1v2.n2214 vss_1v2.n217 0.00889112
R2627 vss_1v2.n217 vss_1v2.n27 0.639912
R2628 vss_1v2.n86 vss_1v2.n2216 0.00889112
R2629 vss_1v2.n2174 vss_1v2.n94 1.28621
R2630 vss_1v2.n2175 vss_1v2.n99 1.28621
R2631 vss_1v2.n2176 vss_1v2.n104 1.28621
R2632 vss_1v2.n2177 vss_1v2.n109 1.28621
R2633 vss_1v2.n2178 vss_1v2.n124 1.28621
R2634 vss_1v2.n2179 vss_1v2.n403 1.28621
R2635 vss_1v2.n2180 vss_1v2.n117 1.28621
R2636 vss_1v2.n2182 vss_1v2.n2181 1.28621
R2637 vss_1v2.n850 vss_1v2.n849 1.28621
R2638 vss_1v2.n2076 vss_1v2.n2075 1.28621
R2639 vss_1v2.n2078 vss_1v2.n2077 1.28621
R2640 vss_1v2.n2080 vss_1v2.n2079 1.28621
R2641 vss_1v2.n2126 vss_1v2.n2125 1.28621
R2642 vss_1v2.n2128 vss_1v2.n2127 1.28621
R2643 vss_1v2.n2130 vss_1v2.n2129 1.28621
R2644 vss_1v2.n2132 vss_1v2.n2131 1.28621
R2645 vss_1v2.n2133 vss_1v2.n405 1.28621
R2646 vss_1v2.n2135 vss_1v2.n2134 1.28621
R2647 vss_1v2.n2136 vss_1v2.n386 1.28621
R2648 vss_1v2.n2138 vss_1v2.n2137 1.28621
R2649 vss_1v2.n2140 vss_1v2.n2139 1.28621
R2650 vss_1v2.n2141 vss_1v2.n126 1.28621
R2651 vss_1v2.n2143 vss_1v2.n2142 1.28621
R2652 vss_1v2.n2144 vss_1v2.n133 1.28621
R2653 vss_1v2.n2146 vss_1v2.n2145 1.28621
R2654 vss_1v2.n2147 vss_1v2.n222 1.28621
R2655 vss_1v2.n2149 vss_1v2.n2148 1.28621
R2656 vss_1v2.n2151 vss_1v2.n2150 1.28621
R2657 vss_1v2.n2152 vss_1v2.n407 1.28621
R2658 vss_1v2.n2154 vss_1v2.n2153 1.28621
R2659 vss_1v2.n2155 vss_1v2.n389 1.28621
R2660 vss_1v2.n2157 vss_1v2.n2156 1.28621
R2661 vss_1v2.n2159 vss_1v2.n2158 1.28621
R2662 vss_1v2.n2160 vss_1v2.n408 1.28621
R2663 vss_1v2.n84 vss_1v2.n82 0.639912
R2664 vss_1v2.n2162 vss_1v2.n84 0.00889112
R2665 vss_1v2.n2164 vss_1v2.n2163 1.28621
R2666 vss_1v2.n2165 vss_1v2.n219 1.28621
R2667 vss_1v2.n2046 vss_1v2.n87 1.28621
R2668 vss_1v2.n2213 vss_1v2.n27 1.28621
R2669 vss_1v2.n111 vss_1v2.n1872 1.28621
R2670 vss_1v2.n1750 vss_1v2.n1749 1.28621
R2671 vss_1v2.n1805 vss_1v2.n1804 1.28621
R2672 vss_1v2.n1806 vss_1v2.n89 1.28621
R2673 vss_1v2.n1807 vss_1v2.n391 1.28621
R2674 vss_1v2.n1808 vss_1v2.n178 1.28621
R2675 vss_1v2.n1810 vss_1v2.n1809 1.28621
R2676 vss_1v2.n1812 vss_1v2.n1811 1.28621
R2677 vss_1v2.n1814 vss_1v2.n1813 1.28621
R2678 vss_1v2.n1815 vss_1v2.n428 1.28621
R2679 vss_1v2.n1816 vss_1v2.n1728 1.28621
R2680 vss_1v2.n1818 vss_1v2.n1817 1.28621
R2681 vss_1v2.n1820 vss_1v2.n1819 1.28621
R2682 vss_1v2.n1822 vss_1v2.n1821 1.28621
R2683 vss_1v2.n1824 vss_1v2.n1823 1.28621
R2684 vss_1v2.n1825 vss_1v2.n159 1.28621
R2685 vss_1v2.n1826 vss_1v2.n392 1.28621
R2686 vss_1v2.n1827 vss_1v2.n121 1.28621
R2687 vss_1v2.n1828 vss_1v2.n102 1.28621
R2688 vss_1v2.n1829 vss_1v2.n106 1.28621
R2689 vss_1v2.n1830 vss_1v2.n119 1.28621
R2690 vss_1v2.n1831 vss_1v2.n429 1.28621
R2691 vss_1v2.n1832 vss_1v2.n165 1.28621
R2692 vss_1v2.n1834 vss_1v2.n1833 1.28621
R2693 vss_1v2.n1836 vss_1v2.n1835 1.28621
R2694 vss_1v2.n1838 vss_1v2.n1837 1.28621
R2695 vss_1v2.n1840 vss_1v2.n1839 1.28621
R2696 vss_1v2.n1843 vss_1v2.n1842 1.28621
R2697 vss_1v2.n1845 vss_1v2.n1844 1.28621
R2698 vss_1v2.n1847 vss_1v2.n1846 1.28621
R2699 vss_1v2.n1849 vss_1v2.n1848 1.28621
R2700 vss_1v2.n1852 vss_1v2.n1851 1.28621
R2701 vss_1v2.n1853 vss_1v2.n209 1.28621
R2702 vss_1v2.n1856 vss_1v2.n1855 1.28621
R2703 vss_1v2.n1857 vss_1v2.n411 1.28621
R2704 vss_1v2.n1860 vss_1v2.n1859 1.28621
R2705 vss_1v2.n1863 vss_1v2.n1862 1.28621
R2706 vss_1v2.n1864 vss_1v2.n131 1.28621
R2707 vss_1v2.n1867 vss_1v2.n1866 1.28621
R2708 vss_1v2.n1774 vss_1v2.n230 1.28621
R2709 vss_1v2.n1872 vss_1v2.n1871 1.28621
R2710 vss_1v2.n1751 vss_1v2.n1750 1.28621
R2711 vss_1v2.n1805 vss_1v2.n1803 1.28621
R2712 vss_1v2.n1806 vss_1v2.n1802 1.28621
R2713 vss_1v2.n1807 vss_1v2.n1801 1.28621
R2714 vss_1v2.n1808 vss_1v2.n1800 1.28621
R2715 vss_1v2.n1810 vss_1v2.n1799 1.28621
R2716 vss_1v2.n1812 vss_1v2.n1798 1.28621
R2717 vss_1v2.n1814 vss_1v2.n1797 1.28621
R2718 vss_1v2.n1815 vss_1v2.n1796 1.28621
R2719 vss_1v2.n1816 vss_1v2.n1795 1.28621
R2720 vss_1v2.n1818 vss_1v2.n1757 1.28621
R2721 vss_1v2.n1820 vss_1v2.n1794 1.28621
R2722 vss_1v2.n1822 vss_1v2.n1793 1.28621
R2723 vss_1v2.n1824 vss_1v2.n1759 1.28621
R2724 vss_1v2.n1825 vss_1v2.n1792 1.28621
R2725 vss_1v2.n1826 vss_1v2.n1791 1.28621
R2726 vss_1v2.n1827 vss_1v2.n1790 1.28621
R2727 vss_1v2.n1828 vss_1v2.n1789 1.28621
R2728 vss_1v2.n1829 vss_1v2.n1762 1.28621
R2729 vss_1v2.n1830 vss_1v2.n1788 1.28621
R2730 vss_1v2.n1831 vss_1v2.n1787 1.28621
R2731 vss_1v2.n1832 vss_1v2.n1764 1.28621
R2732 vss_1v2.n1834 vss_1v2.n1786 1.28621
R2733 vss_1v2.n1836 vss_1v2.n1785 1.28621
R2734 vss_1v2.n1838 vss_1v2.n1766 1.28621
R2735 vss_1v2.n1840 vss_1v2.n1784 1.28621
R2736 vss_1v2.n1843 vss_1v2.n1783 1.28621
R2737 vss_1v2.n1845 vss_1v2.n1768 1.28621
R2738 vss_1v2.n1847 vss_1v2.n1782 1.28621
R2739 vss_1v2.n1849 vss_1v2.n1781 1.28621
R2740 vss_1v2.n1852 vss_1v2.n1770 1.28621
R2741 vss_1v2.n1853 vss_1v2.n1780 1.28621
R2742 vss_1v2.n1856 vss_1v2.n1779 1.28621
R2743 vss_1v2.n1857 vss_1v2.n1778 1.28621
R2744 vss_1v2.n1860 vss_1v2.n1777 1.28621
R2745 vss_1v2.n1863 vss_1v2.n1776 1.28621
R2746 vss_1v2.n1864 vss_1v2.n1775 1.28621
R2747 vss_1v2.n1868 vss_1v2.n1867 1.28621
R2748 vss_1v2.n1871 vss_1v2.n1870 1.28621
R2749 vss_1v2.n1870 vss_1v2.n1757 1.28621
R2750 vss_1v2.n1870 vss_1v2.n1759 1.28621
R2751 vss_1v2.n1870 vss_1v2.n1762 1.28621
R2752 vss_1v2.n1870 vss_1v2.n1764 1.28621
R2753 vss_1v2.n1870 vss_1v2.n1766 1.28621
R2754 vss_1v2.n1870 vss_1v2.n1768 1.28621
R2755 vss_1v2.n1870 vss_1v2.n1770 1.28621
R2756 vss_1v2.n2172 vss_1v2.n2171 1.28621
R2757 vss_1v2.n2171 vss_1v2.n86 1.29461
R2758 vss_1v2.n2216 vss_1v2.n628 1.28621
R2759 vss_1v2.n2215 vss_1v2.n629 1.28621
R2760 vss_1v2.n2214 vss_1v2.n630 1.28621
R2761 vss_1v2.n2213 vss_1v2.n631 1.28621
R2762 vss_1v2.n2045 vss_1v2.n632 1.28621
R2763 vss_1v2.n2167 vss_1v2.n2046 1.28621
R2764 vss_1v2.n2166 vss_1v2.n2165 1.28621
R2765 vss_1v2.n2164 vss_1v2.n2047 1.28621
R2766 vss_1v2.n2162 vss_1v2.n2048 1.28621
R2767 vss_1v2.n2161 vss_1v2.n2049 1.28621
R2768 vss_1v2.n2160 vss_1v2.n2050 1.28621
R2769 vss_1v2.n2159 vss_1v2.n2051 1.28621
R2770 vss_1v2.n2157 vss_1v2.n2052 1.28621
R2771 vss_1v2.n2155 vss_1v2.n2053 1.28621
R2772 vss_1v2.n2154 vss_1v2.n2054 1.28621
R2773 vss_1v2.n2152 vss_1v2.n2055 1.28621
R2774 vss_1v2.n2151 vss_1v2.n2056 1.28621
R2775 vss_1v2.n2149 vss_1v2.n2057 1.28621
R2776 vss_1v2.n2147 vss_1v2.n2058 1.28621
R2777 vss_1v2.n2146 vss_1v2.n2059 1.28621
R2778 vss_1v2.n2144 vss_1v2.n2060 1.28621
R2779 vss_1v2.n2143 vss_1v2.n2061 1.28621
R2780 vss_1v2.n2141 vss_1v2.n2062 1.28621
R2781 vss_1v2.n2140 vss_1v2.n2063 1.28621
R2782 vss_1v2.n2138 vss_1v2.n2064 1.28621
R2783 vss_1v2.n2136 vss_1v2.n2065 1.28621
R2784 vss_1v2.n2135 vss_1v2.n2066 1.28621
R2785 vss_1v2.n2133 vss_1v2.n2067 1.28621
R2786 vss_1v2.n2132 vss_1v2.n2068 1.28621
R2787 vss_1v2.n2130 vss_1v2.n2069 1.28621
R2788 vss_1v2.n2128 vss_1v2.n2070 1.28621
R2789 vss_1v2.n2126 vss_1v2.n2071 1.28621
R2790 vss_1v2.n2080 vss_1v2.n2072 1.28621
R2791 vss_1v2.n2078 vss_1v2.n2073 1.28621
R2792 vss_1v2.n2076 vss_1v2.n2074 1.28621
R2793 vss_1v2.n2029 vss_1v2.n850 1.28621
R2794 vss_1v2.n2181 vss_1v2.n851 1.28621
R2795 vss_1v2.n2180 vss_1v2.n852 1.28621
R2796 vss_1v2.n2179 vss_1v2.n853 1.28621
R2797 vss_1v2.n2178 vss_1v2.n854 1.28621
R2798 vss_1v2.n2177 vss_1v2.n855 1.28621
R2799 vss_1v2.n2176 vss_1v2.n856 1.28621
R2800 vss_1v2.n2175 vss_1v2.n857 1.28621
R2801 vss_1v2.n1912 vss_1v2.n1911 1.2766
R2802 vss_1v2.n37 vss_1v2.n1543 0.470741
R2803 vss_1v2.n13 vss_1v2.n1977 1.26525
R2804 vss_1v2.n13 vss_1v2.n1979 1.26525
R2805 vss_1v2.n270 vss_1v2.n1912 1.26317
R2806 vss_1v2.n1533 vss_1v2.n1532 1.26116
R2807 vss_1v2.n100 vss_1v2.n98 1.01646
R2808 vss_1v2.n1536 vss_1v2.n1535 1.26116
R2809 vss_1v2.t265 vss_1v2.n62 1.75163
R2810 vss_1v2.n2098 vss_1v2.n146 1.25441
R2811 vss_1v2.n794 vss_1v2.n147 1.25378
R2812 vss_1v2.n145 vss_1v2.n730 1.25378
R2813 vss_1v2.n225 vss_1v2.n1071 1.28023
R2814 vss_1v2.n77 vss_1v2.n1181 1.23446
R2815 vss_1v2.n38 vss_1v2.n33 1.1441
R2816 vss_1v2.n77 vss_1v2.n1230 1.2246
R2817 vss_1v2.n1874 vss_1v2.n78 1.22327
R2818 vss_1v2.n13 vss_1v2.n135 1.2105
R2819 vss_1v2.t267 vss_1v2.n516 1.18034
R2820 vss_1v2.n1541 vss_1v2.n15 1.13588
R2821 vss_1v2.n37 vss_1v2.n36 1.28177
R2822 vss_1v2.n1226 vss_1v2.n1225 1.1291
R2823 vss_1v2.n2193 vss_1v2.n709 1.1291
R2824 vss_1v2.n216 vss_1v2.n1522 1.09683
R2825 vss_1v2.n1655 vss_1v2.n1654 1.09683
R2826 vss_1v2.n216 vss_1v2.n1659 1.09683
R2827 vss_1v2.n1329 vss_1v2.n1328 1.07308
R2828 vss_1v2.n1508 vss_1v2.n1330 1.07308
R2829 vss_1v2.n1503 vss_1v2.n1334 1.07308
R2830 vss_1v2.t286 vss_1v2.t52 1.07308
R2831 vss_1v2.n1502 vss_1v2.n1336 1.07308
R2832 vss_1v2.n1575 vss_1v2.n1337 1.07308
R2833 vss_1v2.n1501 vss_1v2.n1338 1.07308
R2834 vss_1v2.n1500 vss_1v2.n1339 1.07308
R2835 vss_1v2.n1577 vss_1v2.n1340 1.07308
R2836 vss_1v2.n1499 vss_1v2.n1341 1.07308
R2837 vss_1v2.n1498 vss_1v2.n1345 1.07308
R2838 vss_1v2.n1579 vss_1v2.n247 1.07308
R2839 vss_1v2.n1497 vss_1v2.n1346 1.07308
R2840 vss_1v2.n1569 vss_1v2.n1351 1.07308
R2841 vss_1v2.n1495 vss_1v2.n1356 1.07308
R2842 vss_1v2.n1567 vss_1v2.n1357 1.07308
R2843 vss_1v2.n1494 vss_1v2.n1362 1.07308
R2844 vss_1v2.n1493 vss_1v2.n1363 1.07308
R2845 vss_1v2.n1565 vss_1v2.n1368 1.07308
R2846 vss_1v2.n1492 vss_1v2.n1374 1.07308
R2847 vss_1v2.n1491 vss_1v2.n1375 1.07308
R2848 vss_1v2.n1585 vss_1v2.t298 1.07308
R2849 vss_1v2.n1584 vss_1v2.n1380 1.07308
R2850 vss_1v2.n1490 vss_1v2.t299 1.07308
R2851 vss_1v2.n1489 vss_1v2.n1385 1.07308
R2852 vss_1v2.n1587 vss_1v2.n235 1.07308
R2853 vss_1v2.n1586 vss_1v2.n1386 1.07308
R2854 vss_1v2.n1488 vss_1v2.n1392 1.07308
R2855 vss_1v2.n1487 vss_1v2.n1397 1.07308
R2856 vss_1v2.n1485 vss_1v2.n1403 1.07308
R2857 vss_1v2.n1484 vss_1v2.n1404 1.07308
R2858 vss_1v2.n232 vss_1v2.t56 1.07308
R2859 vss_1v2.n1483 vss_1v2.n1410 1.07308
R2860 vss_1v2.n1482 vss_1v2.n1415 1.07308
R2861 vss_1v2.n1610 vss_1v2.n1419 1.07308
R2862 vss_1v2.t374 vss_1v2.n362 1.07308
R2863 vss_1v2.t73 vss_1v2.n363 1.07308
R2864 vss_1v2.t376 vss_1v2.n365 1.07308
R2865 vss_1v2.n1549 vss_1v2.t376 1.07308
R2866 vss_1v2.n1440 vss_1v2.t76 1.07308
R2867 vss_1v2.n1544 vss_1v2.n1461 1.07308
R2868 vss_1v2.n1608 vss_1v2.n1606 1.07308
R2869 vss_1v2.n1015 vss_1v2.t9 1.07308
R2870 vss_1v2.t96 vss_1v2.n507 1.07308
R2871 vss_1v2.t94 vss_1v2.n303 1.07308
R2872 vss_1v2.n1945 vss_1v2.t242 1.07308
R2873 vss_1v2.n1928 vss_1v2.n327 1.07308
R2874 vss_1v2.n1927 vss_1v2.t303 1.07308
R2875 vss_1v2.n1923 vss_1v2.n338 1.07308
R2876 vss_1v2.t316 vss_1v2.t114 1.07308
R2877 vss_1v2.n1563 vss_1v2.t299 1.07308
R2878 vss_1v2.t362 vss_1v2.n1398 1.07308
R2879 vss_1v2.t365 vss_1v2.n1409 1.07308
R2880 vss_1v2.t367 vss_1v2.n1416 1.07308
R2881 vss_1v2.n1496 vss_1v2.t318 1.07308
R2882 vss_1v2.n2217 vss_1v2.n27 1.04745
R2883 vss_1v2.n1696 vss_1v2.n158 0.558115
R2884 vss_1v2.n1687 vss_1v2.n1686 1.04015
R2885 vss_1v2.n1685 vss_1v2.n1327 1.04015
R2886 vss_1v2.n16 vss_1v2.n31 1.05347
R2887 vss_1v2.t324 vss_1v2.n135 0.9905
R2888 vss_1v2.n1648 vss_1v2.n1647 0.979551
R2889 vss_1v2.n1639 vss_1v2.n1626 0.941738
R2890 vss_1v2.n1706 vss_1v2.t17 0.936181
R2891 vss_1v2.t359 vss_1v2.n16 9.41655
R2892 vss_1v2.n1622 vss_1v2.n1611 0.933833
R2893 vss_1v2.n1643 vss_1v2.n1642 0.933833
R2894 vss_1v2.n1911 vss_1v2.n425 0.875763
R2895 vss_1v2.n216 vss_1v2.n212 0.860333
R2896 vss_1v2.n1574 vss_1v2.n1573 0.858562
R2897 vss_1v2.t52 vss_1v2.n1502 0.858562
R2898 vss_1v2.n1585 vss_1v2.n1584 0.858562
R2899 vss_1v2.n1562 vss_1v2.n1561 0.858562
R2900 vss_1v2.n1597 vss_1v2.n1596 0.858562
R2901 vss_1v2.n1597 vss_1v2.n364 0.858562
R2902 vss_1v2.n1548 vss_1v2.n368 0.858562
R2903 vss_1v2.n1935 vss_1v2.n999 0.858562
R2904 vss_1v2.n1935 vss_1v2.n305 0.858562
R2905 vss_1v2.n305 vss_1v2.t243 0.858562
R2906 vss_1v2.n308 vss_1v2.t245 0.858562
R2907 vss_1v2.n1947 vss_1v2.n309 0.858562
R2908 vss_1v2.n311 vss_1v2.t247 0.858562
R2909 vss_1v2.n314 vss_1v2.t249 0.858562
R2910 vss_1v2.n1930 vss_1v2.n465 0.858562
R2911 vss_1v2.n1964 vss_1v2.n827 0.858562
R2912 vss_1v2.n1927 vss_1v2.n831 0.858562
R2913 vss_1v2.n1923 vss_1v2.n445 0.858562
R2914 vss_1v2.n1969 vss_1v2.n443 0.858562
R2915 vss_1v2.t114 vss_1v2.n844 0.858562
R2916 vss_1v2.n1920 vss_1v2.t317 0.858562
R2917 vss_1v2.n1920 vss_1v2.n845 0.858562
R2918 vss_1v2.n38 vss_1v2.n34 0.851847
R2919 vss_1v2.t107 vss_1v2.n17 0.851847
R2920 vss_1v2.n1615 vss_1v2.n1614 0.819389
R2921 vss_1v2.n1652 vss_1v2.n1611 0.819389
R2922 vss_1v2.n1635 vss_1v2.n1627 0.819389
R2923 vss_1v2.n1644 vss_1v2.n1643 0.819389
R2924 vss_1v2.n1510 vss_1v2.n38 0.814739
R2925 vss_1v2.n1636 vss_1v2.n1625 0.8045
R2926 vss_1v2.n394 vss_1v2.t363 0.158692
R2927 vss_1v2.n396 vss_1v2.t240 0.158069
R2928 vss_1v2.n1609 vss_1v2.n1560 0.79004
R2929 vss_1v2.n2218 vss_1v2 0.78524
R2930 vss_1v2.n1971 vss_1v2.n382 0.760723
R2931 vss_1v2.n1647 vss_1v2.n1611 0.758278
R2932 vss_1v2.n1643 vss_1v2.n1626 0.758278
R2933 vss_1v2 vss_1v2.n2218 0.740821
R2934 vss_1v2.t25 vss_1v2.n576 0.728252
R2935 vss_1v2.t107 vss_1v2.n16 0.293431
R2936 vss_1v2.n56 vss_1v2.n1458 2.11614
R2937 vss_1v2.n1542 vss_1v2.n15 0.6568
R2938 vss_1v2.n38 vss_1v2.n37 0.273595
R2939 vss_1v2.n425 vss_1v2.n81 0.648919
R2940 vss_1v2.t284 vss_1v2.n1333 0.644047
R2941 vss_1v2.t287 vss_1v2.n1337 0.644047
R2942 vss_1v2.t62 vss_1v2.t288 0.644047
R2943 vss_1v2.t289 vss_1v2.n1340 0.644047
R2944 vss_1v2.t291 vss_1v2.n1346 0.644047
R2945 vss_1v2.t293 vss_1v2.n1356 0.644047
R2946 vss_1v2.n1568 vss_1v2.n248 0.644047
R2947 vss_1v2.n1581 vss_1v2.n1362 0.644047
R2948 vss_1v2.t295 vss_1v2.n1363 0.644047
R2949 vss_1v2.n1583 vss_1v2.n1369 0.644047
R2950 vss_1v2.t276 vss_1v2.n1374 0.644047
R2951 vss_1v2.n1564 vss_1v2.n237 0.644047
R2952 vss_1v2.n254 vss_1v2.t59 0.644047
R2953 vss_1v2.t369 vss_1v2.n1424 0.644047
R2954 vss_1v2.t371 vss_1v2.n1428 0.644047
R2955 vss_1v2.n1552 vss_1v2.n1430 0.644047
R2956 vss_1v2.t373 vss_1v2.n1432 0.644047
R2957 vss_1v2.n1437 vss_1v2.t375 0.644047
R2958 vss_1v2.t76 vss_1v2.n366 0.644047
R2959 vss_1v2.t78 vss_1v2.n378 0.644047
R2960 vss_1v2.n1009 vss_1v2.n379 0.644047
R2961 vss_1v2.n1010 vss_1v2.n380 0.644047
R2962 vss_1v2.n1011 vss_1v2.n381 0.644047
R2963 vss_1v2.t379 vss_1v2.n1007 0.644047
R2964 vss_1v2.n975 vss_1v2.t96 0.644047
R2965 vss_1v2.n355 vss_1v2.n518 0.644047
R2966 vss_1v2.n356 vss_1v2.n497 0.644047
R2967 vss_1v2.n973 vss_1v2.n520 0.644047
R2968 vss_1v2.n357 vss_1v2.n495 0.644047
R2969 vss_1v2.n358 vss_1v2.n522 0.644047
R2970 vss_1v2.n1938 vss_1v2.n493 0.644047
R2971 vss_1v2.n997 vss_1v2.t94 0.644047
R2972 vss_1v2.t242 vss_1v2.n483 0.644047
R2973 vss_1v2.t91 vss_1v2.n481 0.644047
R2974 vss_1v2.t244 vss_1v2.n536 0.644047
R2975 vss_1v2.t246 vss_1v2.n477 0.644047
R2976 vss_1v2.t248 vss_1v2.n542 0.644047
R2977 vss_1v2.t250 vss_1v2.n471 0.644047
R2978 vss_1v2.n1974 vss_1v2.n546 0.644047
R2979 vss_1v2.n319 vss_1v2.n469 0.644047
R2980 vss_1v2.t252 vss_1v2.n548 0.644047
R2981 vss_1v2.n320 vss_1v2.n467 0.644047
R2982 vss_1v2.n321 vss_1v2.n550 0.644047
R2983 vss_1v2.t254 vss_1v2.n465 0.644047
R2984 vss_1v2.n322 vss_1v2.t109 0.644047
R2985 vss_1v2.n322 vss_1v2.n552 0.644047
R2986 vss_1v2.n323 vss_1v2.n463 0.644047
R2987 vss_1v2.n325 vss_1v2.n461 0.644047
R2988 vss_1v2.n326 vss_1v2.n556 0.644047
R2989 vss_1v2.n327 vss_1v2.n459 0.644047
R2990 vss_1v2.n328 vss_1v2.n558 0.644047
R2991 vss_1v2.n329 vss_1v2.n457 0.644047
R2992 vss_1v2.n330 vss_1v2.n560 0.644047
R2993 vss_1v2.n331 vss_1v2.n454 0.644047
R2994 vss_1v2.n332 vss_1v2.n562 0.644047
R2995 vss_1v2.n333 vss_1v2.n453 0.644047
R2996 vss_1v2.n1967 vss_1v2.n335 0.644047
R2997 vss_1v2.t358 vss_1v2.n786 0.644047
R2998 vss_1v2.t314 vss_1v2.t111 0.644047
R2999 vss_1v2.n1965 vss_1v2.t302 0.644047
R3000 vss_1v2.n1870 vss_1v2.n1752 0.639912
R3001 vss_1v2.n1870 vss_1v2.n1753 0.639912
R3002 vss_1v2.n1870 vss_1v2.n1754 0.639912
R3003 vss_1v2.n1870 vss_1v2.n1755 0.639912
R3004 vss_1v2.n1870 vss_1v2.n1756 0.639912
R3005 vss_1v2.n1870 vss_1v2.n1758 0.639912
R3006 vss_1v2.n1870 vss_1v2.n1760 0.639912
R3007 vss_1v2.n1870 vss_1v2.n1761 0.639912
R3008 vss_1v2.n1870 vss_1v2.n1763 0.639912
R3009 vss_1v2.n1870 vss_1v2.n1765 0.639912
R3010 vss_1v2.n1870 vss_1v2.n1767 0.639912
R3011 vss_1v2.n1870 vss_1v2.n1769 0.639912
R3012 vss_1v2.n1870 vss_1v2.n1771 0.639912
R3013 vss_1v2.n1870 vss_1v2.n1772 0.639912
R3014 vss_1v2.n1870 vss_1v2.n1773 0.639912
R3015 vss_1v2.n1870 vss_1v2.n1869 0.639912
R3016 vss_1v2.n2172 vss_1v2.n2170 0.639912
R3017 vss_1v2.n2172 vss_1v2.n2169 0.639912
R3018 vss_1v2.n2172 vss_1v2.n2168 0.639912
R3019 vss_1v2.n2172 vss_1v2.n2044 0.639912
R3020 vss_1v2.n2172 vss_1v2.n2043 0.639912
R3021 vss_1v2.n2172 vss_1v2.n2042 0.639912
R3022 vss_1v2.n2172 vss_1v2.n2041 0.639912
R3023 vss_1v2.n2172 vss_1v2.n2040 0.639912
R3024 vss_1v2.n2172 vss_1v2.n2039 0.639912
R3025 vss_1v2.n2172 vss_1v2.n2038 0.639912
R3026 vss_1v2.n2172 vss_1v2.n2037 0.639912
R3027 vss_1v2.n2172 vss_1v2.n2036 0.639912
R3028 vss_1v2.n2172 vss_1v2.n2035 0.639912
R3029 vss_1v2.n2172 vss_1v2.n2034 0.639912
R3030 vss_1v2.n2172 vss_1v2.n2033 0.639912
R3031 vss_1v2.n2172 vss_1v2.n2032 0.639912
R3032 vss_1v2.n2172 vss_1v2.n2031 0.639912
R3033 vss_1v2.n2172 vss_1v2.n2030 0.639912
R3034 vss_1v2.n2172 vss_1v2.n2028 0.639912
R3035 vss_1v2.n2172 vss_1v2.n2027 0.639912
R3036 vss_1v2.n2172 vss_1v2.n2026 0.639912
R3037 vss_1v2.n2173 vss_1v2.n2172 0.639912
R3038 vss_1v2.n1650 vss_1v2.n1623 0.629071
R3039 vss_1v2.n1616 vss_1v2.n1615 0.6205
R3040 vss_1v2.n1635 vss_1v2.n1634 0.6205
R3041 vss_1v2.n1997 vss_1v2.n148 0.587177
R3042 vss_1v2.n1696 vss_1v2.n72 0.567568
R3043 vss_1v2.n1632 vss_1v2.n1625 0.5605
R3044 vss_1v2.t107 vss_1v2.t338 0.563547
R3045 vss_1v2.n1540 vss_1v2.t277 0.554167
R3046 vss_1v2.t266 vss_1v2.n375 0.536789
R3047 vss_1v2.n982 vss_1v2.t267 0.536789
R3048 vss_1v2.n355 vss_1v2.t268 0.536789
R3049 vss_1v2.n970 vss_1v2.t357 0.534
R3050 vss_1v2.t320 vss_1v2.n1513 0.534
R3051 vss_1v2.t240 vss_1v2.n1931 0.530933
R3052 vss_1v2.n970 vss_1v2.n17 0.525696
R3053 vss_1v2.n1513 vss_1v2.n34 0.522539
R3054 vss_1v2.n1733 vss_1v2.t327 0.520323
R3055 vss_1v2.n20 vss_1v2.t237 0.0288487
R3056 vss_1v2.n2218 vss_1v2.n2217 0.508575
R3057 vss_1v2.n426 vss_1v2.n425 0.457509
R3058 vss_1v2.n1650 vss_1v2.n36 0.451724
R3059 vss_1v2.n1652 vss_1v2.n1651 0.451724
R3060 vss_1v2.n1505 vss_1v2.n34 0.451208
R3061 vss_1v2.n1953 vss_1v2.n17 0.448051
R3062 vss_1v2.n1576 vss_1v2.n1575 0.429531
R3063 vss_1v2.n1583 vss_1v2.n1582 0.429531
R3064 vss_1v2.n1559 vss_1v2.t362 0.429531
R3065 vss_1v2.n1554 vss_1v2.n1553 0.429531
R3066 vss_1v2.n1595 vss_1v2.n361 0.429531
R3067 vss_1v2.n1598 vss_1v2.t377 0.429531
R3068 vss_1v2.n1547 vss_1v2.n371 0.429531
R3069 vss_1v2.n1544 vss_1v2.t256 0.429531
R3070 vss_1v2.n1467 vss_1v2.n63 1.53517
R3071 vss_1v2.n1469 vss_1v2.n375 0.429531
R3072 vss_1v2.n1471 vss_1v2.n55 1.5352
R3073 vss_1v2.n1474 vss_1v2.n376 0.429531
R3074 vss_1v2.n1476 vss_1v2.n54 2.1627
R3075 vss_1v2.n1479 vss_1v2.n58 2.308
R3076 vss_1v2.n1481 vss_1v2.n377 0.429531
R3077 vss_1v2.n1681 vss_1v2.n378 0.429531
R3078 vss_1v2.n1683 vss_1v2.n60 1.64383
R3079 vss_1v2.n1998 vss_1v2.n141 0.429531
R3080 vss_1v2.n1009 vss_1v2.t81 0.429531
R3081 vss_1v2.n1997 vss_1v2.n221 0.429531
R3082 vss_1v2.n974 vss_1v2.n279 0.429531
R3083 vss_1v2.n975 vss_1v2.n280 0.429531
R3084 vss_1v2.n976 vss_1v2.n281 0.429531
R3085 vss_1v2.n977 vss_1v2.n282 0.429531
R3086 vss_1v2.n978 vss_1v2.n283 0.429531
R3087 vss_1v2.n979 vss_1v2.n284 0.429531
R3088 vss_1v2.n980 vss_1v2.n285 0.429531
R3089 vss_1v2.n981 vss_1v2.n286 0.429531
R3090 vss_1v2.n982 vss_1v2.n287 0.429531
R3091 vss_1v2.n983 vss_1v2.n288 0.429531
R3092 vss_1v2.n984 vss_1v2.n289 0.429531
R3093 vss_1v2.n985 vss_1v2.n290 0.429531
R3094 vss_1v2.n1940 vss_1v2.n520 0.429531
R3095 vss_1v2.n986 vss_1v2.n495 0.429531
R3096 vss_1v2.n1942 vss_1v2.t258 0.429531
R3097 vss_1v2.n987 vss_1v2.n522 0.429531
R3098 vss_1v2.n988 vss_1v2.n493 0.429531
R3099 vss_1v2.n989 vss_1v2.n524 0.429531
R3100 vss_1v2.n990 vss_1v2.n491 0.429531
R3101 vss_1v2.n991 vss_1v2.n526 0.429531
R3102 vss_1v2.n992 vss_1v2.n489 0.429531
R3103 vss_1v2.n1943 vss_1v2.n992 0.429531
R3104 vss_1v2.n993 vss_1v2.n528 0.429531
R3105 vss_1v2.n994 vss_1v2.n487 0.429531
R3106 vss_1v2.n1944 vss_1v2.n530 0.429531
R3107 vss_1v2.n995 vss_1v2.n530 0.429531
R3108 vss_1v2.n996 vss_1v2.n485 0.429531
R3109 vss_1v2.n1936 vss_1v2.n302 0.429531
R3110 vss_1v2.n1936 vss_1v2.t241 0.429531
R3111 vss_1v2.n997 vss_1v2.n532 0.429531
R3112 vss_1v2.n998 vss_1v2.n483 0.429531
R3113 vss_1v2.n999 vss_1v2.n534 0.429531
R3114 vss_1v2.n1000 vss_1v2.n481 0.429531
R3115 vss_1v2.n1001 vss_1v2.n536 0.429531
R3116 vss_1v2.n1002 vss_1v2.n478 0.429531
R3117 vss_1v2.n1973 vss_1v2.n538 0.429531
R3118 vss_1v2.n1948 vss_1v2.n312 0.429531
R3119 vss_1v2.n1949 vss_1v2.n544 0.429531
R3120 vss_1v2.n775 vss_1v2.t251 0.429531
R3121 vss_1v2.t106 vss_1v2.n467 0.429531
R3122 vss_1v2.n821 vss_1v2.t253 0.429531
R3123 vss_1v2.n778 vss_1v2.t255 0.429531
R3124 vss_1v2.n1963 vss_1v2.n778 0.429531
R3125 vss_1v2.n1929 vss_1v2.n554 0.429531
R3126 vss_1v2.n1926 vss_1v2.n783 0.429531
R3127 vss_1v2.n1924 vss_1v2.n568 0.429531
R3128 vss_1v2.n1921 vss_1v2.n790 0.429531
R3129 vss_1v2.t189 vss_1v2.n574 0.429531
R3130 vss_1v2.n1514 vss_1v2.n1512 0.42792
R3131 vss_1v2.t147 vss_1v2.n1689 0.42675
R3132 vss_1v2.n1182 vss_1v2.t157 0.42675
R3133 vss_1v2.n1142 vss_1v2.t166 0.42675
R3134 vss_1v2.n1651 vss_1v2.n1621 0.418051
R3135 vss_1v2.n1512 vss_1v2.n1511 0.41792
R3136 vss_1v2.n2025 vss_1v2.n2024 0.401261
R3137 vss_1v2.n1543 vss_1v2.n1542 0.384567
R3138 vss_1v2.n1982 vss_1v2.n1978 0.383506
R3139 vss_1v2.n1691 vss_1v2.n1690 0.383506
R3140 vss_1v2.n1981 vss_1v2.n1980 0.383506
R3141 vss_1v2.t85 vss_1v2.n1978 0.383506
R3142 vss_1v2.t98 vss_1v2.n1981 0.383506
R3143 vss_1v2.n1690 vss_1v2.t146 0.383506
R3144 vss_1v2.n1141 vss_1v2.n1140 0.383506
R3145 vss_1v2.n1227 vss_1v2.n1183 0.383506
R3146 vss_1v2.n1183 vss_1v2.t156 0.383506
R3147 vss_1v2.t165 vss_1v2.n1140 0.383506
R3148 vss_1v2.n1637 vss_1v2.n1636 0.3725
R3149 vss_1v2.n1980 vss_1v2.n1979 0.371005
R3150 vss_1v2.n1982 vss_1v2.n1977 0.371005
R3151 vss_1v2.t98 vss_1v2.n1979 0.371005
R3152 vss_1v2.n1977 vss_1v2.t85 0.371005
R3153 vss_1v2.n39 vss_1v2.t324 1.27882
R3154 vss_1v2.n1542 vss_1v2.n32 0.356102
R3155 vss_1v2.n1668 vss_1v2.t54 0.351125
R3156 vss_1v2.n1525 vss_1v2.t67 0.351125
R3157 vss_1v2.n1670 vss_1v2.n1669 0.346643
R3158 vss_1v2.t108 vss_1v2.t107 7.67408
R3159 vss_1v2.n1669 vss_1v2.t53 0.346643
R3160 vss_1v2.n1527 vss_1v2.n1526 0.346643
R3161 vss_1v2.n1526 vss_1v2.t66 0.346643
R3162 vss_1v2.t119 vss_1v2.t107 7.67408
R3163 vss_1v2.t240 vss_1v2.n971 0.344984
R3164 vss_1v2.n1486 vss_1v2.t363 0.343811
R3165 vss_1v2.n1999 vss_1v2.n859 0.338669
R3166 vss_1v2.n2023 vss_1v2.n7 0.338669
R3167 vss_1v2.n2022 vss_1v2.n2021 0.333833
R3168 vss_1v2.n2020 vss_1v2.n864 0.333833
R3169 vss_1v2.n2018 vss_1v2.n2017 0.333833
R3170 vss_1v2.n2016 vss_1v2.n2015 0.333833
R3171 vss_1v2.n2013 vss_1v2.n2012 0.333833
R3172 vss_1v2.n2011 vss_1v2.n2010 0.333833
R3173 vss_1v2.n2008 vss_1v2.n2007 0.333833
R3174 vss_1v2.n2006 vss_1v2.n2005 0.333833
R3175 vss_1v2.n2003 vss_1v2.n2002 0.333833
R3176 vss_1v2.n2001 vss_1v2.n2000 0.333833
R3177 vss_1v2.n1619 vss_1v2.n1618 0.313833
R3178 vss_1v2.n1619 vss_1v2.n1616 0.313833
R3179 vss_1v2.n1634 vss_1v2.n1633 0.313833
R3180 vss_1v2.n1633 vss_1v2.n1631 0.313833
R3181 vss_1v2.n1513 vss_1v2.n1486 0.313802
R3182 vss_1v2.n971 vss_1v2.n970 0.31263
R3183 vss_1v2.t23 vss_1v2.n609 0.312394
R3184 vss_1v2.n1911 vss_1v2.n1910 0.293833
R3185 vss_1v2.n48 vss_1v2.n2199 0.654793
R3186 vss_1v2.n40 vss_1v2.t271 0.306233
R3187 vss_1v2.n1541 vss_1v2.n1540 0.249871
R3188 vss_1v2.n1275 vss_1v2.n1273 0.238833
R3189 vss_1v2.n1270 vss_1v2.n1269 0.238833
R3190 vss_1v2.n1117 vss_1v2.n1116 0.238833
R3191 vss_1v2.n1113 vss_1v2.n162 0.238833
R3192 vss_1v2.n1062 vss_1v2.n1061 0.238833
R3193 vss_1v2.n1058 vss_1v2.n1057 0.238833
R3194 vss_1v2.n1891 vss_1v2.n1877 0.238833
R3195 vss_1v2.n157 vss_1v2.n156 0.238833
R3196 vss_1v2.n1518 vss_1v2.n96 0.238833
R3197 vss_1v2.n1528 vss_1v2.t67 0.238833
R3198 vss_1v2.n1525 vss_1v2.n1524 0.238833
R3199 vss_1v2.n1672 vss_1v2.t54 0.238833
R3200 vss_1v2.n1668 vss_1v2.n1507 0.238833
R3201 vss_1v2.n1906 vss_1v2.n1905 0.238833
R3202 vss_1v2.n1158 vss_1v2.n1157 0.238833
R3203 vss_1v2.n1163 vss_1v2.n1161 0.238833
R3204 vss_1v2.t166 vss_1v2.n150 0.238833
R3205 vss_1v2.n1143 vss_1v2.n1142 0.238833
R3206 vss_1v2.n1228 vss_1v2.t157 0.238833
R3207 vss_1v2.n1182 vss_1v2.n171 0.238833
R3208 vss_1v2.n108 vss_1v2.t147 0.238833
R3209 vss_1v2.n1693 vss_1v2.n1689 0.238833
R3210 vss_1v2.n1169 vss_1v2.n1168 0.238833
R3211 vss_1v2.n1164 vss_1v2.n1163 0.238833
R3212 vss_1v2.n13 vss_1v2.n1 0.238833
R3213 vss_1v2.n912 vss_1v2.n13 0.238833
R3214 vss_1v2.n13 vss_1v2.n2 0.238833
R3215 vss_1v2.n13 vss_1v2.n3 0.238833
R3216 vss_1v2.n13 vss_1v2.n4 0.238833
R3217 vss_1v2.n872 vss_1v2.n13 0.238833
R3218 vss_1v2.n13 vss_1v2.n6 0.238833
R3219 vss_1v2.n13 vss_1v2.n5 0.238833
R3220 vss_1v2.n13 vss_1v2.n8 0.238833
R3221 vss_1v2.n13 vss_1v2.n9 0.238833
R3222 vss_1v2.n893 vss_1v2.n13 0.238833
R3223 vss_1v2.n902 vss_1v2.n13 0.238833
R3224 vss_1v2.n13 vss_1v2.n11 0.238833
R3225 vss_1v2.n13 vss_1v2.n10 0.238833
R3226 vss_1v2.n13 vss_1v2.n12 0.238833
R3227 vss_1v2.n888 vss_1v2.n13 0.238833
R3228 vss_1v2.n2103 vss_1v2.n2102 0.238833
R3229 vss_1v2.n2107 vss_1v2.n2106 0.238833
R3230 vss_1v2.n174 vss_1v2.n173 0.238833
R3231 vss_1v2.n769 vss_1v2.n768 0.238833
R3232 vss_1v2.n2190 vss_1v2.n721 0.238833
R3233 vss_1v2.n114 vss_1v2.n113 0.238833
R3234 vss_1v2.n711 vss_1v2.n168 0.238833
R3235 vss_1v2.n718 vss_1v2.n717 0.238833
R3236 vss_1v2.n2093 vss_1v2.n2083 0.238833
R3237 vss_1v2.n154 vss_1v2.n153 0.238833
R3238 vss_1v2.n2120 vss_1v2.n2116 0.238833
R3239 vss_1v2.n2111 vss_1v2.n2107 0.238833
R3240 vss_1v2.n2196 vss_1v2.n2195 0.238833
R3241 vss_1v2.n1961 vss_1v2.n1960 0.238833
R3242 vss_1v2.n1957 vss_1v2.n1956 0.238833
R3243 vss_1v2.n262 vss_1v2.n666 0.238833
R3244 vss_1v2.n662 vss_1v2.n661 0.238833
R3245 vss_1v2.n2212 vss_1v2.n27 0.23937
R3246 vss_1v2.n27 vss_1v2.n22 0.238833
R3247 vss_1v2.n27 vss_1v2.n23 0.238833
R3248 vss_1v2.n27 vss_1v2.n24 0.238833
R3249 vss_1v2.n27 vss_1v2.n25 0.238833
R3250 vss_1v2.n27 vss_1v2.n26 0.238833
R3251 vss_1v2.n1004 vss_1v2.t381 0.238648
R3252 vss_1v2.n1543 vss_1v2.n1541 0.233803
R3253 vss_1v2.n1601 vss_1v2.n941 0.224374
R3254 vss_1v2.t145 vss_1v2.n1509 0.215016
R3255 vss_1v2.n1574 vss_1v2.n1333 0.215016
R3256 vss_1v2.n1572 vss_1v2.t149 0.215016
R3257 vss_1v2.n1578 vss_1v2.n241 0.215016
R3258 vss_1v2.n1570 vss_1v2.n1341 0.215016
R3259 vss_1v2.n1587 vss_1v2.t300 0.215016
R3260 vss_1v2.n1562 vss_1v2.n1391 0.215016
R3261 vss_1v2.n1588 vss_1v2.n253 0.215016
R3262 vss_1v2.n1590 vss_1v2.n1410 0.215016
R3263 vss_1v2.n1557 vss_1v2.n231 0.215016
R3264 vss_1v2.n1420 vss_1v2.n1419 0.215016
R3265 vss_1v2.n1555 vss_1v2.n1421 0.215016
R3266 vss_1v2.n1591 vss_1v2.n1424 0.215016
R3267 vss_1v2.n1426 vss_1v2.n1425 0.215016
R3268 vss_1v2.n1553 vss_1v2.n1427 0.215016
R3269 vss_1v2.n1593 vss_1v2.n1428 0.215016
R3270 vss_1v2.n1551 vss_1v2.n1429 0.215016
R3271 vss_1v2.n1624 vss_1v2.n1430 0.215016
R3272 vss_1v2.n1432 vss_1v2.n1431 0.215016
R3273 vss_1v2.n1434 vss_1v2.n1433 0.215016
R3274 vss_1v2.n1436 vss_1v2.n1435 0.215016
R3275 vss_1v2.n1596 vss_1v2.n1437 0.215016
R3276 vss_1v2.n1439 vss_1v2.n1438 0.215016
R3277 vss_1v2.n1441 vss_1v2.n1440 0.215016
R3278 vss_1v2.n1598 vss_1v2.n1443 0.215016
R3279 vss_1v2.n1443 vss_1v2.n1442 0.215016
R3280 vss_1v2.n1445 vss_1v2.n1444 0.215016
R3281 vss_1v2.n1548 vss_1v2.t378 0.215016
R3282 vss_1v2.n1447 vss_1v2.n1446 0.215016
R3283 vss_1v2.n1449 vss_1v2.n1448 0.215016
R3284 vss_1v2.n1546 vss_1v2.n1450 0.215016
R3285 vss_1v2.n1452 vss_1v2.n1451 0.215016
R3286 vss_1v2.n1454 vss_1v2.n1453 0.215016
R3287 vss_1v2.n1545 vss_1v2.n1455 0.215016
R3288 vss_1v2.n1457 vss_1v2.n1456 0.215016
R3289 vss_1v2.n1600 vss_1v2.n53 0.473497
R3290 vss_1v2.n1459 vss_1v2.n1458 0.215016
R3291 vss_1v2.n1461 vss_1v2.n1460 0.215016
R3292 vss_1v2.n1607 vss_1v2.n1462 0.215016
R3293 vss_1v2.n1464 vss_1v2.n1463 0.215016
R3294 vss_1v2.n1466 vss_1v2.n1465 0.215016
R3295 vss_1v2.n1468 vss_1v2.n1467 0.215016
R3296 vss_1v2.n1470 vss_1v2.n1469 0.215016
R3297 vss_1v2.n1473 vss_1v2.n1471 0.215016
R3298 vss_1v2.n1475 vss_1v2.n1474 0.215016
R3299 vss_1v2.n1477 vss_1v2.t151 0.215016
R3300 vss_1v2.n1478 vss_1v2.n1476 0.215016
R3301 vss_1v2.n1480 vss_1v2.n1479 0.215016
R3302 vss_1v2.n1677 vss_1v2.n1481 0.215016
R3303 vss_1v2.n1680 vss_1v2.n1678 0.215016
R3304 vss_1v2.n1682 vss_1v2.n1681 0.215016
R3305 vss_1v2.n1998 vss_1v2.n318 0.215016
R3306 vss_1v2.t168 vss_1v2.n505 0.215016
R3307 vss_1v2.n351 vss_1v2.t187 0.215016
R3308 vss_1v2.n1939 vss_1v2.n1938 0.215016
R3309 vss_1v2.n1944 vss_1v2.t239 0.215016
R3310 vss_1v2.n1950 vss_1v2.n319 0.215016
R3311 vss_1v2.n1929 vss_1v2.n324 0.215016
R3312 vss_1v2.n1928 vss_1v2.t301 0.215016
R3313 vss_1v2.n1922 vss_1v2.n340 0.215016
R3314 vss_1v2.n1970 vss_1v2.t192 0.215016
R3315 vss_1v2.t272 vss_1v2.n1683 0.215016
R3316 vss_1v2.n1631 vss_1v2.n1630 0.213625
R3317 vss_1v2.n1634 vss_1v2.n1628 0.213625
R3318 vss_1v2.n1629 vss_1v2.n1628 0.213625
R3319 vss_1v2.n1985 vss_1v2.n1984 0.213625
R3320 vss_1v2.n1986 vss_1v2.n1985 0.213625
R3321 vss_1v2.n1992 vss_1v2.n1991 0.213625
R3322 vss_1v2.n1993 vss_1v2.n1992 0.213625
R3323 vss_1v2.n1996 vss_1v2.n1990 0.213625
R3324 vss_1v2.n1990 vss_1v2.n942 0.213625
R3325 vss_1v2.n1989 vss_1v2.n1983 0.213625
R3326 vss_1v2.n1983 vss_1v2.n943 0.213625
R3327 vss_1v2.n1154 vss_1v2.n1153 0.213625
R3328 vss_1v2.n1155 vss_1v2.n1154 0.213625
R3329 vss_1v2.n1161 vss_1v2.n1152 0.213625
R3330 vss_1v2.n1158 vss_1v2.n1152 0.213625
R3331 vss_1v2.n1649 vss_1v2.n1646 0.213625
R3332 vss_1v2.n1647 vss_1v2.n1646 0.213625
R3333 vss_1v2.n2 vss_1v2.n917 0.213625
R3334 vss_1v2.n917 vss_1v2.n912 0.213625
R3335 vss_1v2.n916 vss_1v2.n915 0.213625
R3336 vss_1v2.n916 vss_1v2.n914 0.213625
R3337 vss_1v2.n909 vss_1v2.n908 0.213625
R3338 vss_1v2.n908 vss_1v2.n907 0.213625
R3339 vss_1v2.n906 vss_1v2.n3 0.213625
R3340 vss_1v2.n1 vss_1v2.n906 0.213625
R3341 vss_1v2.n6 vss_1v2.n877 0.213625
R3342 vss_1v2.n877 vss_1v2.n872 0.213625
R3343 vss_1v2.n876 vss_1v2.n875 0.213625
R3344 vss_1v2.n876 vss_1v2.n874 0.213625
R3345 vss_1v2.n869 vss_1v2.n868 0.213625
R3346 vss_1v2.n868 vss_1v2.n867 0.213625
R3347 vss_1v2.n866 vss_1v2.n5 0.213625
R3348 vss_1v2.n4 vss_1v2.n866 0.213625
R3349 vss_1v2.n893 vss_1v2.n891 0.213625
R3350 vss_1v2.n9 vss_1v2.n891 0.213625
R3351 vss_1v2.n895 vss_1v2.n894 0.213625
R3352 vss_1v2.n894 vss_1v2.n892 0.213625
R3353 vss_1v2.n901 vss_1v2.n900 0.213625
R3354 vss_1v2.n900 vss_1v2.n899 0.213625
R3355 vss_1v2.n902 vss_1v2.n898 0.213625
R3356 vss_1v2.n8 vss_1v2.n898 0.213625
R3357 vss_1v2.n12 vss_1v2.n887 0.213625
R3358 vss_1v2.n887 vss_1v2.n10 0.213625
R3359 vss_1v2.n886 vss_1v2.n885 0.213625
R3360 vss_1v2.n886 vss_1v2.n884 0.213625
R3361 vss_1v2.n881 vss_1v2.n880 0.213625
R3362 vss_1v2.n880 vss_1v2.n879 0.213625
R3363 vss_1v2.n888 vss_1v2.n878 0.213625
R3364 vss_1v2.n11 vss_1v2.n878 0.213625
R3365 vss_1v2.n113 vss_1v2.n727 0.213625
R3366 vss_1v2.n727 vss_1v2.n721 0.213625
R3367 vss_1v2.n726 vss_1v2.n725 0.213625
R3368 vss_1v2.n726 vss_1v2.n724 0.213625
R3369 vss_1v2.n717 vss_1v2.n716 0.213625
R3370 vss_1v2.n716 vss_1v2.n711 0.213625
R3371 vss_1v2.n715 vss_1v2.n714 0.213625
R3372 vss_1v2.n715 vss_1v2.n713 0.213625
R3373 vss_1v2.n153 vss_1v2.n2089 0.213625
R3374 vss_1v2.n2089 vss_1v2.n2083 0.213625
R3375 vss_1v2.n2088 vss_1v2.n2087 0.213625
R3376 vss_1v2.n2088 vss_1v2.n2086 0.213625
R3377 vss_1v2.n2111 vss_1v2.n2109 0.213625
R3378 vss_1v2.n2116 vss_1v2.n2109 0.213625
R3379 vss_1v2.n2113 vss_1v2.n2112 0.213625
R3380 vss_1v2.n2112 vss_1v2.n2110 0.213625
R3381 vss_1v2.n1620 vss_1v2.n1613 0.21152
R3382 vss_1v2.n1621 vss_1v2.n1620 0.21152
R3383 vss_1v2.n1627 vss_1v2.n39 5.8592
R3384 vss_1v2.n1641 vss_1v2.n1640 0.1885
R3385 vss_1v2.n1641 vss_1v2.n1637 0.1885
R3386 vss_1v2.n38 vss_1v2.n35 2.41332
R3387 vss_1v2.t240 vss_1v2.n18 0.716207
R3388 vss_1v2.n964 vss_1v2.n962 0.175813
R3389 vss_1v2.n969 vss_1v2.n962 0.175813
R3390 vss_1v2.n966 vss_1v2.n965 0.175813
R3391 vss_1v2.n965 vss_1v2.n963 0.175813
R3392 vss_1v2.n960 vss_1v2.n959 0.175813
R3393 vss_1v2.n959 vss_1v2.n954 0.175813
R3394 vss_1v2.n958 vss_1v2.n957 0.175813
R3395 vss_1v2.n958 vss_1v2.n956 0.175813
R3396 vss_1v2.n1640 vss_1v2.n1639 0.175813
R3397 vss_1v2.n1638 vss_1v2.n1626 0.175813
R3398 vss_1v2.n1638 vss_1v2.n1637 0.175813
R3399 vss_1v2.n1617 vss_1v2.n1613 0.175813
R3400 vss_1v2.n1618 vss_1v2.n1617 0.175813
R3401 vss_1v2.n1621 vss_1v2.n1612 0.175813
R3402 vss_1v2.n1616 vss_1v2.n1612 0.175813
R3403 vss_1v2.t67 vss_1v2.t66 0.172833
R3404 vss_1v2.n1527 vss_1v2.n1525 0.172833
R3405 vss_1v2.t54 vss_1v2.t53 0.172833
R3406 vss_1v2.n1670 vss_1v2.n1668 0.172833
R3407 vss_1v2.n968 vss_1v2.n963 0.172833
R3408 vss_1v2.n969 vss_1v2.n968 0.172833
R3409 vss_1v2.n967 vss_1v2.n966 0.172833
R3410 vss_1v2.n967 vss_1v2.n964 0.172833
R3411 vss_1v2.n956 vss_1v2.n955 0.172833
R3412 vss_1v2.n955 vss_1v2.n954 0.172833
R3413 vss_1v2.n957 vss_1v2.n952 0.172833
R3414 vss_1v2.n960 vss_1v2.n952 0.172833
R3415 vss_1v2.n1994 vss_1v2.n1993 0.172833
R3416 vss_1v2.n1994 vss_1v2.n942 0.172833
R3417 vss_1v2.n1987 vss_1v2.n943 0.172833
R3418 vss_1v2.n1987 vss_1v2.n1986 0.172833
R3419 vss_1v2.n1995 vss_1v2.n1991 0.172833
R3420 vss_1v2.n1996 vss_1v2.n1995 0.172833
R3421 vss_1v2.n1989 vss_1v2.n1988 0.172833
R3422 vss_1v2.n1988 vss_1v2.n1984 0.172833
R3423 vss_1v2.n1159 vss_1v2.n1158 0.172833
R3424 vss_1v2.n1159 vss_1v2.n1155 0.172833
R3425 vss_1v2.n1161 vss_1v2.n1160 0.172833
R3426 vss_1v2.n1160 vss_1v2.n1153 0.172833
R3427 vss_1v2.t166 vss_1v2.t165 0.172833
R3428 vss_1v2.n1142 vss_1v2.n1141 0.172833
R3429 vss_1v2.t157 vss_1v2.t156 0.172833
R3430 vss_1v2.n1227 vss_1v2.n1182 0.172833
R3431 vss_1v2.t147 vss_1v2.t146 0.172833
R3432 vss_1v2.n1691 vss_1v2.n1689 0.172833
R3433 vss_1v2.n1 vss_1v2.n911 0.172833
R3434 vss_1v2.n911 vss_1v2.n907 0.172833
R3435 vss_1v2.n914 vss_1v2.n913 0.172833
R3436 vss_1v2.n913 vss_1v2.n912 0.172833
R3437 vss_1v2.n915 vss_1v2.n905 0.172833
R3438 vss_1v2.n2 vss_1v2.n905 0.172833
R3439 vss_1v2.n910 vss_1v2.n3 0.172833
R3440 vss_1v2.n910 vss_1v2.n909 0.172833
R3441 vss_1v2.n4 vss_1v2.n871 0.172833
R3442 vss_1v2.n871 vss_1v2.n867 0.172833
R3443 vss_1v2.n874 vss_1v2.n873 0.172833
R3444 vss_1v2.n873 vss_1v2.n872 0.172833
R3445 vss_1v2.n875 vss_1v2.n865 0.172833
R3446 vss_1v2.n6 vss_1v2.n865 0.172833
R3447 vss_1v2.n870 vss_1v2.n5 0.172833
R3448 vss_1v2.n870 vss_1v2.n869 0.172833
R3449 vss_1v2.n8 vss_1v2.n904 0.172833
R3450 vss_1v2.n904 vss_1v2.n899 0.172833
R3451 vss_1v2.n897 vss_1v2.n892 0.172833
R3452 vss_1v2.n9 vss_1v2.n897 0.172833
R3453 vss_1v2.n896 vss_1v2.n895 0.172833
R3454 vss_1v2.n896 vss_1v2.n893 0.172833
R3455 vss_1v2.n903 vss_1v2.n902 0.172833
R3456 vss_1v2.n903 vss_1v2.n901 0.172833
R3457 vss_1v2.n11 vss_1v2.n890 0.172833
R3458 vss_1v2.n890 vss_1v2.n879 0.172833
R3459 vss_1v2.n884 vss_1v2.n883 0.172833
R3460 vss_1v2.n883 vss_1v2.n10 0.172833
R3461 vss_1v2.n885 vss_1v2.n882 0.172833
R3462 vss_1v2.n12 vss_1v2.n882 0.172833
R3463 vss_1v2.n889 vss_1v2.n888 0.172833
R3464 vss_1v2.n889 vss_1v2.n881 0.172833
R3465 vss_1v2.n724 vss_1v2.n723 0.172833
R3466 vss_1v2.n723 vss_1v2.n721 0.172833
R3467 vss_1v2.n725 vss_1v2.n722 0.172833
R3468 vss_1v2.n113 vss_1v2.n722 0.172833
R3469 vss_1v2.n713 vss_1v2.n712 0.172833
R3470 vss_1v2.n712 vss_1v2.n711 0.172833
R3471 vss_1v2.n714 vss_1v2.n710 0.172833
R3472 vss_1v2.n717 vss_1v2.n710 0.172833
R3473 vss_1v2.n2086 vss_1v2.n2085 0.172833
R3474 vss_1v2.n2085 vss_1v2.n2083 0.172833
R3475 vss_1v2.n2087 vss_1v2.n2084 0.172833
R3476 vss_1v2.n153 vss_1v2.n2084 0.172833
R3477 vss_1v2.n2115 vss_1v2.n2110 0.172833
R3478 vss_1v2.n2116 vss_1v2.n2115 0.172833
R3479 vss_1v2.n2114 vss_1v2.n2113 0.172833
R3480 vss_1v2.n2114 vss_1v2.n2111 0.172833
R3481 vss_1v2.n41 vss_1v2.n46 1.15849
R3482 vss_1v2.n38 vss_1v2.n177 5.8345
R3483 vss_1v2.n13 vss_1v2.n7 0.166708
R3484 vss_1v2.n2019 vss_1v2.n13 0.166708
R3485 vss_1v2.n2014 vss_1v2.n13 0.166708
R3486 vss_1v2.n2009 vss_1v2.n13 0.166708
R3487 vss_1v2.n2004 vss_1v2.n13 0.166708
R3488 vss_1v2.n1999 vss_1v2.n13 0.166708
R3489 vss_1v2.n2024 vss_1v2.n2023 0.166708
R3490 vss_1v2.n2024 vss_1v2.n863 0.166708
R3491 vss_1v2.n2024 vss_1v2.n862 0.166708
R3492 vss_1v2.n2024 vss_1v2.n861 0.166708
R3493 vss_1v2.n2024 vss_1v2.n860 0.166708
R3494 vss_1v2.n2024 vss_1v2.n859 0.166708
R3495 vss_1v2.n1975 vss_1v2.n969 0.1655
R3496 vss_1v2.n964 vss_1v2.n961 0.1655
R3497 vss_1v2.n954 vss_1v2.n953 0.1655
R3498 vss_1v2.n21 vss_1v2.n960 0.175019
R3499 vss_1v2.n1662 vss_1v2.n216 0.163463
R3500 vss_1v2.n1273 vss_1v2.n1272 0.161833
R3501 vss_1v2.n1272 vss_1v2.n1266 0.161833
R3502 vss_1v2.n1271 vss_1v2.n1270 0.161833
R3503 vss_1v2.n1271 vss_1v2.n1267 0.161833
R3504 vss_1v2.n1116 vss_1v2.n1115 0.161833
R3505 vss_1v2.n1115 vss_1v2.n1111 0.161833
R3506 vss_1v2.n1114 vss_1v2.n1113 0.161833
R3507 vss_1v2.n1114 vss_1v2.n1112 0.161833
R3508 vss_1v2.n1061 vss_1v2.n1060 0.161833
R3509 vss_1v2.n1060 vss_1v2.n1054 0.161833
R3510 vss_1v2.n1059 vss_1v2.n1058 0.161833
R3511 vss_1v2.n1059 vss_1v2.n1055 0.161833
R3512 vss_1v2.n1891 vss_1v2.n1890 0.161833
R3513 vss_1v2.n1890 vss_1v2.n1889 0.161833
R3514 vss_1v2.n156 vss_1v2.n1887 0.161833
R3515 vss_1v2.n1888 vss_1v2.n1887 0.161833
R3516 vss_1v2.n1521 vss_1v2.n1517 0.161833
R3517 vss_1v2.n1522 vss_1v2.n1521 0.161833
R3518 vss_1v2.n1520 vss_1v2.n1519 0.161833
R3519 vss_1v2.n1520 vss_1v2.n1518 0.161833
R3520 vss_1v2.n1657 vss_1v2.n1656 0.161833
R3521 vss_1v2.n1657 vss_1v2.n1655 0.161833
R3522 vss_1v2.n1658 vss_1v2.n1653 0.161833
R3523 vss_1v2.n1659 vss_1v2.n1658 0.161833
R3524 vss_1v2.n1908 vss_1v2.n1907 0.161833
R3525 vss_1v2.n1908 vss_1v2.n1906 0.161833
R3526 vss_1v2.n1909 vss_1v2.n1017 0.161833
R3527 vss_1v2.n1910 vss_1v2.n1909 0.161833
R3528 vss_1v2.n1167 vss_1v2.n1151 0.161833
R3529 vss_1v2.n1168 vss_1v2.n1167 0.161833
R3530 vss_1v2.n1166 vss_1v2.n1165 0.161833
R3531 vss_1v2.n1166 vss_1v2.n1164 0.161833
R3532 vss_1v2.n2104 vss_1v2.n2103 0.161833
R3533 vss_1v2.n2104 vss_1v2.n2082 0.161833
R3534 vss_1v2.n2106 vss_1v2.n2105 0.161833
R3535 vss_1v2.n2105 vss_1v2.n2081 0.161833
R3536 vss_1v2.n173 vss_1v2.n771 0.161833
R3537 vss_1v2.n771 vss_1v2.n762 0.161833
R3538 vss_1v2.n770 vss_1v2.n769 0.161833
R3539 vss_1v2.n770 vss_1v2.n763 0.161833
R3540 vss_1v2.n2199 vss_1v2.n2198 0.161833
R3541 vss_1v2.n2198 vss_1v2.n667 0.161833
R3542 vss_1v2.n2197 vss_1v2.n2196 0.161833
R3543 vss_1v2.n2197 vss_1v2.n668 0.161833
R3544 vss_1v2.n1960 vss_1v2.n1959 0.161833
R3545 vss_1v2.n1959 vss_1v2.n1954 0.161833
R3546 vss_1v2.n1958 vss_1v2.n1957 0.161833
R3547 vss_1v2.n1958 vss_1v2.n1955 0.161833
R3548 vss_1v2.n665 vss_1v2.n659 0.161833
R3549 vss_1v2.n666 vss_1v2.n665 0.161833
R3550 vss_1v2.n664 vss_1v2.n663 0.161833
R3551 vss_1v2.n664 vss_1v2.n662 0.161833
R3552 vss_1v2.n2211 vss_1v2.n2210 0.161833
R3553 vss_1v2.n2212 vss_1v2.n2211 0.161833
R3554 vss_1v2.n2209 vss_1v2.n2208 0.161833
R3555 vss_1v2.n22 vss_1v2.n2208 0.161833
R3556 vss_1v2.n2207 vss_1v2.n2204 0.161833
R3557 vss_1v2.n23 vss_1v2.n2207 0.161833
R3558 vss_1v2.n2203 vss_1v2.n2200 0.161833
R3559 vss_1v2.n24 vss_1v2.n2203 0.161833
R3560 vss_1v2.n2202 vss_1v2.n2201 0.161833
R3561 vss_1v2.n2202 vss_1v2.n25 0.161833
R3562 vss_1v2.n2206 vss_1v2.n2205 0.161833
R3563 vss_1v2.n2206 vss_1v2.n26 0.161833
R3564 vss_1v2.n858 vss_1v2 0.157129
R3565 vss_1v2.n79 vss_1v2.n78 0.156472
R3566 vss_1v2.t309 vss_1v2.n382 0.156333
R3567 vss_1v2.n382 vss_1v2.t240 0.154347
R3568 vss_1v2.t261 vss_1v2.n396 0.153831
R3569 vss_1v2.n394 vss_1v2.t263 0.153179
R3570 vss_1v2.n1540 vss_1v2.n1539 0.148403
R3571 vss_1v2.n1224 vss_1v2.n1205 0.146155
R3572 vss_1v2.n1214 vss_1v2.n1205 0.146155
R3573 vss_1v2.n1216 vss_1v2.n1214 0.146155
R3574 vss_1v2.n1218 vss_1v2.n1216 0.146155
R3575 vss_1v2.n1220 vss_1v2.n1218 0.146155
R3576 vss_1v2.n1221 vss_1v2.n1220 0.146155
R3577 vss_1v2.t35 vss_1v2.n1221 0.146155
R3578 vss_1v2.n1204 vss_1v2.n1185 0.146155
R3579 vss_1v2.n1194 vss_1v2.n1185 0.146155
R3580 vss_1v2.n1196 vss_1v2.n1194 0.146155
R3581 vss_1v2.n1198 vss_1v2.n1196 0.146155
R3582 vss_1v2.n1200 vss_1v2.n1198 0.146155
R3583 vss_1v2.n1201 vss_1v2.n1200 0.146155
R3584 vss_1v2.t21 vss_1v2.n1201 0.146155
R3585 vss_1v2.n688 vss_1v2.n669 0.146155
R3586 vss_1v2.n678 vss_1v2.n669 0.146155
R3587 vss_1v2.n680 vss_1v2.n678 0.146155
R3588 vss_1v2.n682 vss_1v2.n680 0.146155
R3589 vss_1v2.n684 vss_1v2.n682 0.146155
R3590 vss_1v2.n685 vss_1v2.n684 0.146155
R3591 vss_1v2.t129 vss_1v2.n685 0.146155
R3592 vss_1v2.n708 vss_1v2.n689 0.146155
R3593 vss_1v2.n698 vss_1v2.n689 0.146155
R3594 vss_1v2.n700 vss_1v2.n698 0.146155
R3595 vss_1v2.n702 vss_1v2.n700 0.146155
R3596 vss_1v2.n704 vss_1v2.n702 0.146155
R3597 vss_1v2.n705 vss_1v2.n704 0.146155
R3598 vss_1v2.t127 vss_1v2.n705 0.146155
R3599 vss_1v2.n1223 vss_1v2.n1206 0.14496
R3600 vss_1v2.n1222 vss_1v2.n1212 0.14496
R3601 vss_1v2.n1203 vss_1v2.n1186 0.14496
R3602 vss_1v2.n1202 vss_1v2.n1192 0.14496
R3603 vss_1v2.n687 vss_1v2.n670 0.14496
R3604 vss_1v2.n686 vss_1v2.n676 0.14496
R3605 vss_1v2.n707 vss_1v2.n690 0.14496
R3606 vss_1v2.n706 vss_1v2.n696 0.14496
R3607 vss_1v2.n79 vss_1v2.n77 0.143977
R3608 vss_1v2.n1975 vss_1v2.n272 0.144155
R3609 vss_1v2.n1539 vss_1v2.n928 0.13506
R3610 vss_1v2.n2172 vss_1v2.n2025 0.135026
R3611 vss_1v2.n1213 vss_1v2.n1208 0.133259
R3612 vss_1v2.n1219 vss_1v2.n1210 0.133259
R3613 vss_1v2.n1193 vss_1v2.n1188 0.133259
R3614 vss_1v2.n1199 vss_1v2.n1190 0.133259
R3615 vss_1v2.n677 vss_1v2.n672 0.133259
R3616 vss_1v2.n683 vss_1v2.n674 0.133259
R3617 vss_1v2.n697 vss_1v2.n692 0.133259
R3618 vss_1v2.n703 vss_1v2.n694 0.133259
R3619 vss_1v2.n36 vss_1v2.n39 5.83448
R3620 vss_1v2.n216 vss_1v2.n213 0.112978
R3621 vss_1v2.n21 vss_1v2.n953 0.213864
R3622 vss_1v2.n1976 vss_1v2.n961 0.112109
R3623 vss_1v2.n1976 vss_1v2.n1975 0.112109
R3624 vss_1v2.n1912 vss_1v2.n81 0.111494
R3625 vss_1v2.n1660 vss_1v2.n216 0.108766
R3626 vss_1v2.t283 vss_1v2.t262 0.107758
R3627 vss_1v2.t238 vss_1v2.n279 0.107758
R3628 vss_1v2.t275 vss_1v2.t260 0.107758
R3629 vss_1v2.n1533 vss_1v2.n72 0.106661
R3630 vss_1v2.n1536 vss_1v2.n72 0.106661
R3631 vss_1v2.n148 vss_1v2.n76 0.0921553
R3632 vss_1v2.n1870 vss_1v2.n858 0.105959
R3633 vss_1v2.n148 vss_1v2.n147 0.105772
R3634 vss_1v2.n148 vss_1v2.n145 0.105772
R3635 vss_1v2.n148 vss_1v2.n146 0.105464
R3636 vss_1v2.n1207 vss_1v2.n1206 0.105022
R3637 vss_1v2.n1212 vss_1v2.n1211 0.105022
R3638 vss_1v2.n1187 vss_1v2.n1186 0.105022
R3639 vss_1v2.n1192 vss_1v2.n1191 0.105022
R3640 vss_1v2.n671 vss_1v2.n670 0.105022
R3641 vss_1v2.n676 vss_1v2.n675 0.105022
R3642 vss_1v2.n691 vss_1v2.n690 0.105022
R3643 vss_1v2.n696 vss_1v2.n695 0.105022
R3644 vss_1v2.n1715 vss_1v2.t325 0.104465
R3645 vss_1v2.n49 vss_1v2.n39 1.19668
R3646 vss_1v2.n1560 vss_1v2.t363 0.0990436
R3647 vss_1v2.t285 vss_1v2.n1560 0.0985532
R3648 vss_1v2.n953 vss_1v2.n137 0.0971218
R3649 vss_1v2.n31 vss_1v2.n136 0.094
R3650 vss_1v2.n1661 vss_1v2.n227 0.092625
R3651 vss_1v2.n1215 vss_1v2.n1209 0.0915345
R3652 vss_1v2.n1217 vss_1v2.n1209 0.0915345
R3653 vss_1v2.n1195 vss_1v2.n1189 0.0915345
R3654 vss_1v2.n1197 vss_1v2.n1189 0.0915345
R3655 vss_1v2.n679 vss_1v2.n673 0.0915345
R3656 vss_1v2.n681 vss_1v2.n673 0.0915345
R3657 vss_1v2.n699 vss_1v2.n693 0.0915345
R3658 vss_1v2.n701 vss_1v2.n693 0.0915345
R3659 vss_1v2.n138 vss_1v2.n136 0.08575
R3660 vss_1v2.n212 vss_1v2.n33 0.0900035
R3661 vss_1v2.n1213 vss_1v2.n1207 0.0784702
R3662 vss_1v2.n1219 vss_1v2.n1211 0.0784702
R3663 vss_1v2.n1193 vss_1v2.n1187 0.0784702
R3664 vss_1v2.n1199 vss_1v2.n1191 0.0784702
R3665 vss_1v2.n677 vss_1v2.n671 0.0784702
R3666 vss_1v2.n683 vss_1v2.n675 0.0784702
R3667 vss_1v2.n697 vss_1v2.n691 0.0784702
R3668 vss_1v2.n703 vss_1v2.n695 0.0784702
R3669 vss_1v2.n19 vss_1v2.n18 0.00249472
R3670 vss_1v2.n216 vss_1v2.n211 0.0764968
R3671 vss_1v2.n48 vss_1v2.n41 0.355751
R3672 vss_1v2.n1672 vss_1v2.n1671 0.0738333
R3673 vss_1v2.n1507 vss_1v2.n1506 0.0738333
R3674 vss_1v2.n1664 vss_1v2.n1663 0.072
R3675 vss_1v2.n1676 vss_1v2.n1675 0.072
R3676 vss_1v2.n1654 vss_1v2.n426 0.0718205
R3677 vss_1v2.n1673 vss_1v2.n1664 0.0696218
R3678 vss_1v2.n1675 vss_1v2.n1674 0.0696218
R3679 vss_1v2.n1667 vss_1v2.n1666 0.067875
R3680 vss_1v2.n1666 vss_1v2.n1665 0.067875
R3681 vss_1v2.n1530 vss_1v2.n1516 0.0665
R3682 vss_1v2.n20 vss_1v2.n1917 0.30804
R3683 vss_1v2.n1673 vss_1v2.n1672 0.0558718
R3684 vss_1v2.n1674 vss_1v2.n1507 0.0558718
R3685 vss_1v2.n138 vss_1v2.n137 0.0558718
R3686 vss_1v2.n1663 vss_1v2.n1662 0.05275
R3687 vss_1v2.n1676 vss_1v2.n1505 0.05275
R3688 vss_1v2.n1953 vss_1v2.n272 0.146567
R3689 vss_1v2.n1602 vss_1v2.n1601 0.0525275
R3690 vss_1v2.n1917 vss_1v2.n1004 0.0519728
R3691 vss_1v2.n273 vss_1v2.n961 0.143817
R3692 vss_1v2.n1215 vss_1v2.n1208 0.0498103
R3693 vss_1v2.n1217 vss_1v2.n1210 0.0498103
R3694 vss_1v2.n1195 vss_1v2.n1188 0.0498103
R3695 vss_1v2.n1197 vss_1v2.n1190 0.0498103
R3696 vss_1v2.n679 vss_1v2.n672 0.0498103
R3697 vss_1v2.n681 vss_1v2.n674 0.0498103
R3698 vss_1v2.n699 vss_1v2.n692 0.0498103
R3699 vss_1v2.n701 vss_1v2.n694 0.0498103
R3700 vss_1v2.n211 vss_1v2.n1661 0.0489968
R3701 vss_1v2.n32 vss_1v2.n213 0.0472458
R3702 vss_1v2.n1918 vss_1v2.n1917 0.0452335
R3703 vss_1v2.n1603 vss_1v2.n1602 0.0449835
R3704 vss_1v2.n1605 vss_1v2.n1603 0.0422257
R3705 vss_1v2.n1941 vss_1v2.n1918 0.0419731
R3706 vss_1v2.n1660 vss_1v2.n1516 0.0361562
R3707 vss_1v2.n1505 vss_1v2.n1504 0.0351457
R3708 vss_1v2.n1962 vss_1v2.n1953 0.0351457
R3709 vss_1v2.n110 vss_1v2.n1326 0.0308625
R3710 vss_1v2.t324 vss_1v2.n941 0.0298666
R3711 vss_1v2.n2025 vss_1v2.n858 0.029732
R3712 vss_1v2.n111 vss_1v2.n110 0.0293439
R3713 vss_1v2.n1529 vss_1v2.n1516 0.028
R3714 vss_1v2.n1523 vss_1v2.n1516 0.0278702
R3715 vss_1v2.n2195 vss_1v2.n48 0.813714
R3716 vss_1v2.n928 vss_1v2.n927 0.0277381
R3717 vss_1v2.n930 vss_1v2.n926 0.0277381
R3718 vss_1v2.n931 vss_1v2.n929 0.0277381
R3719 vss_1v2.n933 vss_1v2.n925 0.0277381
R3720 vss_1v2.n934 vss_1v2.n932 0.0277381
R3721 vss_1v2.n936 vss_1v2.n924 0.0277381
R3722 vss_1v2.n937 vss_1v2.n935 0.0277381
R3723 vss_1v2.n939 vss_1v2.n923 0.0277381
R3724 vss_1v2.n940 vss_1v2.n938 0.0277381
R3725 vss_1v2.n922 vss_1v2.n0 0.277258
R3726 vss_1v2.n946 vss_1v2.n921 0.0277381
R3727 vss_1v2.n945 vss_1v2.n920 0.0277381
R3728 vss_1v2.n947 vss_1v2.n919 0.0277381
R3729 vss_1v2.n944 vss_1v2.n918 0.0277381
R3730 vss_1v2.n1661 vss_1v2.n1660 0.0273671
R3731 vss_1v2.n216 vss_1v2.n214 0.0210664
R3732 vss_1v2.n67 vss_1v2.n111 0.00240336
R3733 vss_1v2.n768 vss_1v2.n275 0.0225022
R3734 vss_1v2.n1962 vss_1v2.n75 0.0468405
R3735 vss_1v2.n1931 vss_1v2.n315 0.0158424
R3736 vss_1v2.n1661 vss_1v2.n226 0.0166398
R3737 vss_1v2.n1177 vss_1v2.n214 0.0164871
R3738 vss_1v2.n1872 vss_1v2.n1750 0.0163797
R3739 vss_1v2.n1805 vss_1v2.n1750 0.0163797
R3740 vss_1v2.n1806 vss_1v2.n1805 0.0163797
R3741 vss_1v2.n1807 vss_1v2.n1806 0.0163797
R3742 vss_1v2.n1808 vss_1v2.n1807 0.0163797
R3743 vss_1v2.n1810 vss_1v2.n1808 0.0163797
R3744 vss_1v2.n1812 vss_1v2.n1810 0.0163797
R3745 vss_1v2.n1814 vss_1v2.n1812 0.0163797
R3746 vss_1v2.n1815 vss_1v2.n1814 0.0163797
R3747 vss_1v2.n1816 vss_1v2.n1815 0.0163797
R3748 vss_1v2.n1818 vss_1v2.n1816 0.0163797
R3749 vss_1v2.n1820 vss_1v2.n1818 0.0163797
R3750 vss_1v2.n1822 vss_1v2.n1820 0.0163797
R3751 vss_1v2.n1824 vss_1v2.n1822 0.0163797
R3752 vss_1v2.n1825 vss_1v2.n1824 0.0163797
R3753 vss_1v2.n1826 vss_1v2.n1825 0.0163797
R3754 vss_1v2.n1827 vss_1v2.n1826 0.0163797
R3755 vss_1v2.n1828 vss_1v2.n1827 0.0163797
R3756 vss_1v2.n1829 vss_1v2.n1828 0.0163797
R3757 vss_1v2.n1830 vss_1v2.n1829 0.0163797
R3758 vss_1v2.n1831 vss_1v2.n1830 0.0163797
R3759 vss_1v2.n1832 vss_1v2.n1831 0.0163797
R3760 vss_1v2.n1834 vss_1v2.n1832 0.0163797
R3761 vss_1v2.n1836 vss_1v2.n1834 0.0163797
R3762 vss_1v2.n1838 vss_1v2.n1836 0.0163797
R3763 vss_1v2.n1840 vss_1v2.n1838 0.0163797
R3764 vss_1v2.n1843 vss_1v2.n1840 0.0163797
R3765 vss_1v2.n1845 vss_1v2.n1843 0.0163797
R3766 vss_1v2.n1847 vss_1v2.n1845 0.0163797
R3767 vss_1v2.n1849 vss_1v2.n1847 0.0163797
R3768 vss_1v2.n1852 vss_1v2.n1849 0.0163797
R3769 vss_1v2.n1853 vss_1v2.n1852 0.0163797
R3770 vss_1v2.n1856 vss_1v2.n1853 0.0163797
R3771 vss_1v2.n1857 vss_1v2.n1856 0.0163797
R3772 vss_1v2.n1860 vss_1v2.n1857 0.0163797
R3773 vss_1v2.n1863 vss_1v2.n1860 0.0163797
R3774 vss_1v2.n1864 vss_1v2.n1863 0.0163797
R3775 vss_1v2.n1867 vss_1v2.n1864 0.0163797
R3776 vss_1v2.n1867 vss_1v2.n1774 0.0163797
R3777 vss_1v2.n1871 vss_1v2.n1751 0.0163797
R3778 vss_1v2.n1803 vss_1v2.n1802 0.0163797
R3779 vss_1v2.n1801 vss_1v2.n1800 0.0163797
R3780 vss_1v2.n1799 vss_1v2.n1798 0.0163797
R3781 vss_1v2.n1797 vss_1v2.n1796 0.0163797
R3782 vss_1v2.n1795 vss_1v2.n1757 0.0163797
R3783 vss_1v2.n1794 vss_1v2.n1757 0.0163797
R3784 vss_1v2.n1793 vss_1v2.n1759 0.0163797
R3785 vss_1v2.n1792 vss_1v2.n1759 0.0163797
R3786 vss_1v2.n1791 vss_1v2.n1790 0.0163797
R3787 vss_1v2.n1789 vss_1v2.n1762 0.0163797
R3788 vss_1v2.n1788 vss_1v2.n1762 0.0163797
R3789 vss_1v2.n1787 vss_1v2.n1764 0.0163797
R3790 vss_1v2.n1786 vss_1v2.n1764 0.0163797
R3791 vss_1v2.n1785 vss_1v2.n1766 0.0163797
R3792 vss_1v2.n1784 vss_1v2.n1766 0.0163797
R3793 vss_1v2.n1783 vss_1v2.n1768 0.0163797
R3794 vss_1v2.n1782 vss_1v2.n1768 0.0163797
R3795 vss_1v2.n1781 vss_1v2.n1770 0.0163797
R3796 vss_1v2.n1780 vss_1v2.n1770 0.0163797
R3797 vss_1v2.n1779 vss_1v2.n1778 0.0163797
R3798 vss_1v2.n1777 vss_1v2.n1776 0.0163797
R3799 vss_1v2.n1868 vss_1v2.n1775 0.0163797
R3800 vss_1v2.n857 vss_1v2.n856 0.0163797
R3801 vss_1v2.n855 vss_1v2.n854 0.0163797
R3802 vss_1v2.n853 vss_1v2.n852 0.0163797
R3803 vss_1v2.n2029 vss_1v2.n851 0.0163797
R3804 vss_1v2.n2074 vss_1v2.n2073 0.0163797
R3805 vss_1v2.n2072 vss_1v2.n2071 0.0163797
R3806 vss_1v2.n2070 vss_1v2.n2069 0.0163797
R3807 vss_1v2.n2068 vss_1v2.n2067 0.0163797
R3808 vss_1v2.n2066 vss_1v2.n2065 0.0163797
R3809 vss_1v2.n2064 vss_1v2.n2063 0.0163797
R3810 vss_1v2.n2062 vss_1v2.n2061 0.0163797
R3811 vss_1v2.n2060 vss_1v2.n2059 0.0163797
R3812 vss_1v2.n2058 vss_1v2.n2057 0.0163797
R3813 vss_1v2.n2056 vss_1v2.n2055 0.0163797
R3814 vss_1v2.n2054 vss_1v2.n2053 0.0163797
R3815 vss_1v2.n2052 vss_1v2.n2051 0.0163797
R3816 vss_1v2.n2050 vss_1v2.n2049 0.0163797
R3817 vss_1v2.n2048 vss_1v2.n2047 0.0163797
R3818 vss_1v2.n2167 vss_1v2.n2166 0.0163797
R3819 vss_1v2.n2045 vss_1v2.n631 0.0163797
R3820 vss_1v2.n630 vss_1v2.n629 0.0163797
R3821 vss_1v2.n2171 vss_1v2.n628 0.0163797
R3822 vss_1v2.n2175 vss_1v2.n2174 0.0163797
R3823 vss_1v2.n2176 vss_1v2.n2175 0.0163797
R3824 vss_1v2.n2177 vss_1v2.n2176 0.0163797
R3825 vss_1v2.n2178 vss_1v2.n2177 0.0163797
R3826 vss_1v2.n2179 vss_1v2.n2178 0.0163797
R3827 vss_1v2.n2180 vss_1v2.n2179 0.0163797
R3828 vss_1v2.n2181 vss_1v2.n2180 0.0163797
R3829 vss_1v2.n2181 vss_1v2.n850 0.0163797
R3830 vss_1v2.n2076 vss_1v2.n850 0.0163797
R3831 vss_1v2.n2078 vss_1v2.n2076 0.0163797
R3832 vss_1v2.n2080 vss_1v2.n2078 0.0163797
R3833 vss_1v2.n2126 vss_1v2.n2080 0.0163797
R3834 vss_1v2.n2128 vss_1v2.n2126 0.0163797
R3835 vss_1v2.n2130 vss_1v2.n2128 0.0163797
R3836 vss_1v2.n2132 vss_1v2.n2130 0.0163797
R3837 vss_1v2.n2133 vss_1v2.n2132 0.0163797
R3838 vss_1v2.n2135 vss_1v2.n2133 0.0163797
R3839 vss_1v2.n2136 vss_1v2.n2135 0.0163797
R3840 vss_1v2.n2138 vss_1v2.n2136 0.0163797
R3841 vss_1v2.n2140 vss_1v2.n2138 0.0163797
R3842 vss_1v2.n2141 vss_1v2.n2140 0.0163797
R3843 vss_1v2.n2143 vss_1v2.n2141 0.0163797
R3844 vss_1v2.n2144 vss_1v2.n2143 0.0163797
R3845 vss_1v2.n2146 vss_1v2.n2144 0.0163797
R3846 vss_1v2.n2147 vss_1v2.n2146 0.0163797
R3847 vss_1v2.n2149 vss_1v2.n2147 0.0163797
R3848 vss_1v2.n2151 vss_1v2.n2149 0.0163797
R3849 vss_1v2.n2152 vss_1v2.n2151 0.0163797
R3850 vss_1v2.n2154 vss_1v2.n2152 0.0163797
R3851 vss_1v2.n2155 vss_1v2.n2154 0.0163797
R3852 vss_1v2.n2157 vss_1v2.n2155 0.0163797
R3853 vss_1v2.n2159 vss_1v2.n2157 0.0163797
R3854 vss_1v2.n2160 vss_1v2.n2159 0.0163797
R3855 vss_1v2.n2161 vss_1v2.n2160 0.0163797
R3856 vss_1v2.n84 vss_1v2.n2161 0.00889112
R3857 vss_1v2.n2164 vss_1v2.n2162 0.0163797
R3858 vss_1v2.n2165 vss_1v2.n2164 0.0163797
R3859 vss_1v2.n2165 vss_1v2.n2046 0.0163797
R3860 vss_1v2.n2046 vss_1v2.n632 0.0163797
R3861 vss_1v2.n2213 vss_1v2.n632 0.0163797
R3862 vss_1v2.n2214 vss_1v2.n2213 0.0163797
R3863 vss_1v2.n2215 vss_1v2.n217 0.00889112
R3864 vss_1v2.n2216 vss_1v2.n2215 0.0163797
R3865 vss_1v2.t324 vss_1v2.t381 0.0161518
R3866 vss_1v2.n412 vss_1v2.n1423 0.0113098
R3867 vss_1v2.n1504 vss_1v2.n1076 0.0154166
R3868 vss_1v2.t285 vss_1v2.n1076 0.0144591
R3869 vss_1v2.n657 vss_1v2.n435 0.0134494
R3870 vss_1v2.n75 vss_1v2.n1961 0.0458598
R3871 vss_1v2.n1129 vss_1v2.n1128 0.013397
R3872 vss_1v2.n1675 vss_1v2.n1075 0.0130908
R3873 vss_1v2.n1029 vss_1v2.n1028 0.0130659
R3874 vss_1v2.n1886 vss_1v2.n1885 0.0130643
R3875 vss_1v2.n138 vss_1v2.n46 0.0135782
R3876 vss_1v2.t309 vss_1v2.n44 0.020882
R3877 vss_1v2.n1095 vss_1v2.n1094 0.0124454
R3878 vss_1v2.n315 vss_1v2.n1962 0.0200686
R3879 vss_1v2.n1931 vss_1v2.n1952 0.0110951
R3880 vss_1v2.n655 vss_1v2.n434 0.0107177
R3881 vss_1v2.t261 vss_1v2.n395 0.0105637
R3882 vss_1v2.n1039 vss_1v2.n1038 0.0105889
R3883 vss_1v2.n1675 vss_1v2.n1074 0.0105081
R3884 vss_1v2.n168 vss_1v2.n52 0.0157587
R3885 vss_1v2.n1230 vss_1v2.n172 0.0136863
R3886 vss_1v2.t285 vss_1v2.n1077 0.0101889
R3887 vss_1v2.n212 vss_1v2.n1530 0.010125
R3888 vss_1v2.n399 vss_1v2.n276 0.0057562
R3889 vss_1v2.n402 vss_1v2.n400 0.0057562
R3890 vss_1v2.n2079 vss_1v2.n620 0.0100026
R3891 vss_1v2.n407 vss_1v2.n406 0.00574865
R3892 vss_1v2.n1423 vss_1v2.n1422 0.0100026
R3893 vss_1v2.n108 vss_1v2.n107 0.00571616
R3894 vss_1v2.n1839 vss_1v2.n1700 0.00992388
R3895 vss_1v2.n1250 vss_1v2.n1249 0.0097827
R3896 vss_1v2.n1248 vss_1v2.n1247 0.0097827
R3897 vss_1v2.n1246 vss_1v2.n1245 0.0097827
R3898 vss_1v2.n1244 vss_1v2.n1243 0.0097827
R3899 vss_1v2.n1242 vss_1v2.n1241 0.0097827
R3900 vss_1v2.n1240 vss_1v2.n1239 0.0097827
R3901 vss_1v2.n1238 vss_1v2.n1237 0.0097827
R3902 vss_1v2.n1236 vss_1v2.n1235 0.0097827
R3903 vss_1v2.n1233 vss_1v2.n1232 0.0097827
R3904 vss_1v2.n1231 vss_1v2.n1018 0.0097827
R3905 vss_1v2.n1181 vss_1v2.n1180 0.0097827
R3906 vss_1v2.n1179 vss_1v2.n1123 0.0097827
R3907 vss_1v2.n1122 vss_1v2.n1121 0.0097827
R3908 vss_1v2.n1120 vss_1v2.n1119 0.0097827
R3909 vss_1v2.n1109 vss_1v2.n1108 0.0097827
R3910 vss_1v2.n1107 vss_1v2.n1106 0.0097827
R3911 vss_1v2.n1105 vss_1v2.n1104 0.0097827
R3912 vss_1v2.n1103 vss_1v2.n1102 0.0097827
R3913 vss_1v2.n1101 vss_1v2.n1100 0.0097827
R3914 vss_1v2.n1099 vss_1v2.n1098 0.0097827
R3915 vss_1v2.n1097 vss_1v2.n1096 0.0097827
R3916 vss_1v2.n2125 vss_1v2.n619 0.00963593
R3917 vss_1v2.n1692 vss_1v2.n107 0.0145759
R3918 vss_1v2.n1030 vss_1v2.n1029 0.0093528
R3919 vss_1v2.n1038 vss_1v2.n1037 0.00935118
R3920 vss_1v2.n1671 vss_1v2.n1072 0.00933417
R3921 vss_1v2.n768 vss_1v2.n46 0.0276952
R3922 vss_1v2.n1956 vss_1v2.n44 0.0292001
R3923 vss_1v2.n1605 vss_1v2.n1604 0.00916848
R3924 vss_1v2.n1941 vss_1v2.n1919 0.00916848
R3925 vss_1v2.n1326 vss_1v2.n1325 0.00916385
R3926 vss_1v2.n1280 vss_1v2.n1279 0.00916385
R3927 vss_1v2.n1278 vss_1v2.n1277 0.00916385
R3928 vss_1v2.n1265 vss_1v2.n1264 0.00916385
R3929 vss_1v2.n1263 vss_1v2.n1262 0.00916385
R3930 vss_1v2.n1261 vss_1v2.n1260 0.00916385
R3931 vss_1v2.n1259 vss_1v2.n1258 0.00916385
R3932 vss_1v2.n1257 vss_1v2.n1256 0.00916385
R3933 vss_1v2.n1255 vss_1v2.n1254 0.00916385
R3934 vss_1v2.n1253 vss_1v2.n1252 0.00916385
R3935 vss_1v2.n1251 vss_1v2.n1250 0.00916385
R3936 vss_1v2.n1803 vss_1v2.n1752 0.00889112
R3937 vss_1v2.n1801 vss_1v2.n1753 0.00889112
R3938 vss_1v2.n1799 vss_1v2.n1754 0.00889112
R3939 vss_1v2.n1798 vss_1v2.n1755 0.00889112
R3940 vss_1v2.n1795 vss_1v2.n1756 0.00889112
R3941 vss_1v2.n1793 vss_1v2.n1758 0.00889112
R3942 vss_1v2.n1791 vss_1v2.n1760 0.00889112
R3943 vss_1v2.n1789 vss_1v2.n1761 0.00889112
R3944 vss_1v2.n1787 vss_1v2.n1763 0.00889112
R3945 vss_1v2.n1785 vss_1v2.n1765 0.00889112
R3946 vss_1v2.n1783 vss_1v2.n1767 0.00889112
R3947 vss_1v2.n1781 vss_1v2.n1769 0.00889112
R3948 vss_1v2.n1780 vss_1v2.n1771 0.00889112
R3949 vss_1v2.n1777 vss_1v2.n1772 0.00889112
R3950 vss_1v2.n1775 vss_1v2.n1773 0.00889112
R3951 vss_1v2.n1869 vss_1v2.n1868 0.00889112
R3952 vss_1v2.n1752 vss_1v2.n1751 0.00889112
R3953 vss_1v2.n1802 vss_1v2.n1753 0.00889112
R3954 vss_1v2.n1800 vss_1v2.n1754 0.00889112
R3955 vss_1v2.n1797 vss_1v2.n1755 0.00889112
R3956 vss_1v2.n1796 vss_1v2.n1756 0.00889112
R3957 vss_1v2.n1794 vss_1v2.n1758 0.00889112
R3958 vss_1v2.n1792 vss_1v2.n1760 0.00889112
R3959 vss_1v2.n1790 vss_1v2.n1761 0.00889112
R3960 vss_1v2.n1788 vss_1v2.n1763 0.00889112
R3961 vss_1v2.n1786 vss_1v2.n1765 0.00889112
R3962 vss_1v2.n1784 vss_1v2.n1767 0.00889112
R3963 vss_1v2.n1782 vss_1v2.n1769 0.00889112
R3964 vss_1v2.n1779 vss_1v2.n1771 0.00889112
R3965 vss_1v2.n1778 vss_1v2.n1772 0.00889112
R3966 vss_1v2.n1776 vss_1v2.n1773 0.00889112
R3967 vss_1v2.n2170 vss_1v2.n628 0.00889112
R3968 vss_1v2.n2169 vss_1v2.n630 0.00889112
R3969 vss_1v2.n2168 vss_1v2.n2045 0.00889112
R3970 vss_1v2.n2166 vss_1v2.n2044 0.00889112
R3971 vss_1v2.n2048 vss_1v2.n2043 0.00889112
R3972 vss_1v2.n2050 vss_1v2.n2042 0.00889112
R3973 vss_1v2.n2052 vss_1v2.n2041 0.00889112
R3974 vss_1v2.n2054 vss_1v2.n2040 0.00889112
R3975 vss_1v2.n2056 vss_1v2.n2039 0.00889112
R3976 vss_1v2.n2058 vss_1v2.n2038 0.00889112
R3977 vss_1v2.n2060 vss_1v2.n2037 0.00889112
R3978 vss_1v2.n2062 vss_1v2.n2036 0.00889112
R3979 vss_1v2.n2064 vss_1v2.n2035 0.00889112
R3980 vss_1v2.n2066 vss_1v2.n2034 0.00889112
R3981 vss_1v2.n2068 vss_1v2.n2033 0.00889112
R3982 vss_1v2.n2070 vss_1v2.n2032 0.00889112
R3983 vss_1v2.n2072 vss_1v2.n2031 0.00889112
R3984 vss_1v2.n2074 vss_1v2.n2030 0.00889112
R3985 vss_1v2.n2028 vss_1v2.n851 0.00889112
R3986 vss_1v2.n2027 vss_1v2.n853 0.00889112
R3987 vss_1v2.n2026 vss_1v2.n855 0.00889112
R3988 vss_1v2.n2173 vss_1v2.n857 0.00889112
R3989 vss_1v2.n2026 vss_1v2.n856 0.00889112
R3990 vss_1v2.n2027 vss_1v2.n854 0.00889112
R3991 vss_1v2.n2028 vss_1v2.n852 0.00889112
R3992 vss_1v2.n2030 vss_1v2.n2029 0.00889112
R3993 vss_1v2.n2073 vss_1v2.n2031 0.00889112
R3994 vss_1v2.n2071 vss_1v2.n2032 0.00889112
R3995 vss_1v2.n2069 vss_1v2.n2033 0.00889112
R3996 vss_1v2.n2067 vss_1v2.n2034 0.00889112
R3997 vss_1v2.n2065 vss_1v2.n2035 0.00889112
R3998 vss_1v2.n2063 vss_1v2.n2036 0.00889112
R3999 vss_1v2.n2061 vss_1v2.n2037 0.00889112
R4000 vss_1v2.n2059 vss_1v2.n2038 0.00889112
R4001 vss_1v2.n2057 vss_1v2.n2039 0.00889112
R4002 vss_1v2.n2055 vss_1v2.n2040 0.00889112
R4003 vss_1v2.n2053 vss_1v2.n2041 0.00889112
R4004 vss_1v2.n2051 vss_1v2.n2042 0.00889112
R4005 vss_1v2.n2049 vss_1v2.n2043 0.00889112
R4006 vss_1v2.n2047 vss_1v2.n2044 0.00889112
R4007 vss_1v2.n2168 vss_1v2.n2167 0.00889112
R4008 vss_1v2.n2169 vss_1v2.n631 0.00889112
R4009 vss_1v2.n2170 vss_1v2.n629 0.00889112
R4010 vss_1v2.n927 vss_1v2.n926 0.00888095
R4011 vss_1v2.n931 vss_1v2.n930 0.00888095
R4012 vss_1v2.n929 vss_1v2.n925 0.00888095
R4013 vss_1v2.n934 vss_1v2.n933 0.00888095
R4014 vss_1v2.n932 vss_1v2.n924 0.00888095
R4015 vss_1v2.n937 vss_1v2.n936 0.00888095
R4016 vss_1v2.n935 vss_1v2.n923 0.00888095
R4017 vss_1v2.n940 vss_1v2.n939 0.00888095
R4018 vss_1v2.n938 vss_1v2.n922 0.00888095
R4019 vss_1v2.n14 vss_1v2.n921 0.306117
R4020 vss_1v2.n946 vss_1v2.n920 0.00888095
R4021 vss_1v2.n945 vss_1v2.n919 0.00888095
R4022 vss_1v2.n947 vss_1v2.n918 0.00888095
R4023 vss_1v2.n944 vss_1v2.t107 0.391495
R4024 vss_1v2.n2075 vss_1v2.n621 0.00885078
R4025 vss_1v2.n210 vss_1v2.n209 0.00517334
R4026 vss_1v2.n411 vss_1v2.n409 0.00885078
R4027 vss_1v2.n1331 vss_1v2.n410 0.00885078
R4028 vss_1v2.n131 vss_1v2.n130 0.00517334
R4029 vss_1v2.n230 vss_1v2.n229 0.00517334
R4030 vss_1v2.n1343 vss_1v2.n1342 0.00885078
R4031 vss_1v2.n1347 vss_1v2.n1344 0.00885078
R4032 vss_1v2.n1349 vss_1v2.n1348 0.00885078
R4033 vss_1v2.n1352 vss_1v2.n1350 0.00885078
R4034 vss_1v2.n1354 vss_1v2.n1353 0.00885078
R4035 vss_1v2.n1358 vss_1v2.n1355 0.00885078
R4036 vss_1v2.n1360 vss_1v2.n1359 0.00885078
R4037 vss_1v2.n1364 vss_1v2.n1361 0.00885078
R4038 vss_1v2.n1366 vss_1v2.n1365 0.00885078
R4039 vss_1v2.n1370 vss_1v2.n1367 0.00885078
R4040 vss_1v2.n1372 vss_1v2.n1371 0.00885078
R4041 vss_1v2.n1376 vss_1v2.n1373 0.00885078
R4042 vss_1v2.n1378 vss_1v2.n1377 0.00885078
R4043 vss_1v2.n1381 vss_1v2.n1379 0.00885078
R4044 vss_1v2.n1383 vss_1v2.n1382 0.00885078
R4045 vss_1v2.n1387 vss_1v2.n1384 0.00885078
R4046 vss_1v2.n1389 vss_1v2.n1388 0.00885078
R4047 vss_1v2.n1393 vss_1v2.n1390 0.00885078
R4048 vss_1v2.n1395 vss_1v2.n1394 0.00885078
R4049 vss_1v2.n1399 vss_1v2.n1396 0.00885078
R4050 vss_1v2.n1401 vss_1v2.n1400 0.00885078
R4051 vss_1v2.n1405 vss_1v2.n1402 0.00885078
R4052 vss_1v2.n1407 vss_1v2.n1406 0.00885078
R4053 vss_1v2.n1411 vss_1v2.n1408 0.00885078
R4054 vss_1v2.n1413 vss_1v2.n1412 0.00885078
R4055 vss_1v2.n1417 vss_1v2.n1414 0.00885078
R4056 vss_1v2.n1529 vss_1v2.n1528 0.00875
R4057 vss_1v2.n1524 vss_1v2.n227 0.00875
R4058 vss_1v2.n1956 vss_1v2.n1952 0.00874719
R4059 vss_1v2.n2091 vss_1v2.n69 0.0174258
R4060 vss_1v2.n2095 vss_1v2.n317 0.0085734
R4061 vss_1v2.n2096 vss_1v2.n772 0.0085734
R4062 vss_1v2.n2098 vss_1v2.n2097 0.0085734
R4063 vss_1v2.n2100 vss_1v2.n2099 0.0085734
R4064 vss_1v2.n719 vss_1v2.n633 0.0085734
R4065 vss_1v2.n1138 vss_1v2.n152 0.0174256
R4066 vss_1v2.n1146 vss_1v2.n1145 0.0085734
R4067 vss_1v2.n1148 vss_1v2.n1147 0.0085734
R4068 vss_1v2.n1535 vss_1v2.n1149 0.0085734
R4069 vss_1v2.n1172 vss_1v2.n1171 0.0085734
R4070 vss_1v2.n1174 vss_1v2.n1173 0.0085734
R4071 vss_1v2.n1819 vss_1v2.n1724 0.00856283
R4072 vss_1v2.n1837 vss_1v2.n1701 0.00856283
R4073 vss_1v2.n1846 vss_1v2.n1698 0.00856283
R4074 vss_1v2.n641 vss_1v2.n615 0.00841885
R4075 vss_1v2.n386 vss_1v2.n384 0.00841885
R4076 vss_1v2.n643 vss_1v2.n385 0.00841885
R4077 vss_1v2.n126 vss_1v2.n125 0.00495758
R4078 vss_1v2.n133 vss_1v2.n132 0.00495758
R4079 vss_1v2.n223 vss_1v2.n222 0.0049585
R4080 vss_1v2.n2127 vss_1v2.n618 0.00827487
R4081 vss_1v2.n2129 vss_1v2.n616 0.00827487
R4082 vss_1v2.n1835 vss_1v2.n1702 0.00819614
R4083 vss_1v2.n1848 vss_1v2.n1697 0.00819614
R4084 vss_1v2.n1654 vss_1v2.n1077 0.00819408
R4085 vss_1v2.n405 vss_1v2.n404 0.00813089
R4086 vss_1v2.n637 vss_1v2.n407 0.00813089
R4087 vss_1v2.n142 vss_1v2.n2108 0.013397
R4088 vss_1v2.n2118 vss_1v2.n316 0.00799672
R4089 vss_1v2.n2117 vss_1v2.n793 0.00799672
R4090 vss_1v2.n795 vss_1v2.n794 0.00799672
R4091 vss_1v2.n797 vss_1v2.n796 0.00799672
R4092 vss_1v2.n155 vss_1v2.n2090 0.0172331
R4093 vss_1v2.n1132 vss_1v2.n1131 0.00799672
R4094 vss_1v2.n1134 vss_1v2.n1133 0.00799672
R4095 vss_1v2.n1532 vss_1v2.n1135 0.00799672
R4096 vss_1v2.n1137 vss_1v2.n1136 0.00799672
R4097 vss_1v2.n151 vss_1v2.n274 0.0172331
R4098 vss_1v2.n1848 vss_1v2.n1688 0.00798691
R4099 vss_1v2.n1037 vss_1v2.n1036 0.00792616
R4100 vss_1v2.n1035 vss_1v2.n1034 0.00792616
R4101 vss_1v2.n1033 vss_1v2.n1032 0.00792616
R4102 vss_1v2.n1031 vss_1v2.n1030 0.00792616
R4103 vss_1v2.n2127 vss_1v2.n617 0.00790818
R4104 vss_1v2.n2129 vss_1v2.n617 0.00790818
R4105 vss_1v2.n1506 vss_1v2.n1078 0.00789594
R4106 vss_1v2.n389 vss_1v2.n387 0.00784293
R4107 vss_1v2.n648 vss_1v2.n388 0.00784293
R4108 vss_1v2.n635 vss_1v2.n585 0.00784293
R4109 vss_1v2.n30 vss_1v2.n27 0.14142
R4110 vss_1v2.n1837 vss_1v2.n1702 0.00762022
R4111 vss_1v2.n1846 vss_1v2.n1697 0.00762022
R4112 vss_1v2.n660 vss_1v2.n430 0.00752467
R4113 vss_1v2.n654 vss_1v2.n438 0.00752467
R4114 vss_1v2.n653 vss_1v2.n431 0.00752467
R4115 vss_1v2.n652 vss_1v2.n437 0.00752467
R4116 vss_1v2.n651 vss_1v2.n432 0.00752467
R4117 vss_1v2.n658 vss_1v2.n436 0.00752467
R4118 vss_1v2.n656 vss_1v2.n433 0.00752467
R4119 vss_1v2.n1096 vss_1v2.n1095 0.00749464
R4120 vss_1v2.n761 vss_1v2.n506 0.00741099
R4121 vss_1v2.n798 vss_1v2.n511 0.00741099
R4122 vss_1v2.n760 vss_1v2.n504 0.00741099
R4123 vss_1v2.n799 vss_1v2.n513 0.00741099
R4124 vss_1v2.n759 vss_1v2.n502 0.00741099
R4125 vss_1v2.n800 vss_1v2.n515 0.00741099
R4126 vss_1v2.n758 vss_1v2.n500 0.00741099
R4127 vss_1v2.n801 vss_1v2.n517 0.00741099
R4128 vss_1v2.n757 vss_1v2.n498 0.00741099
R4129 vss_1v2.n802 vss_1v2.n519 0.00741099
R4130 vss_1v2.n756 vss_1v2.n496 0.00741099
R4131 vss_1v2.n803 vss_1v2.n521 0.00741099
R4132 vss_1v2.n755 vss_1v2.n494 0.00741099
R4133 vss_1v2.n804 vss_1v2.n523 0.00741099
R4134 vss_1v2.n754 vss_1v2.n492 0.00741099
R4135 vss_1v2.n805 vss_1v2.n525 0.00741099
R4136 vss_1v2.n753 vss_1v2.n490 0.00741099
R4137 vss_1v2.n806 vss_1v2.n527 0.00741099
R4138 vss_1v2.n752 vss_1v2.n488 0.00741099
R4139 vss_1v2.n807 vss_1v2.n529 0.00741099
R4140 vss_1v2.n751 vss_1v2.n486 0.00741099
R4141 vss_1v2.n808 vss_1v2.n531 0.00741099
R4142 vss_1v2.n750 vss_1v2.n484 0.00741099
R4143 vss_1v2.n809 vss_1v2.n533 0.00741099
R4144 vss_1v2.n749 vss_1v2.n482 0.00741099
R4145 vss_1v2.n810 vss_1v2.n535 0.00741099
R4146 vss_1v2.n748 vss_1v2.n480 0.00741099
R4147 vss_1v2.n811 vss_1v2.n537 0.00741099
R4148 vss_1v2.n747 vss_1v2.n479 0.00741099
R4149 vss_1v2.n812 vss_1v2.n539 0.00741099
R4150 vss_1v2.n746 vss_1v2.n476 0.00741099
R4151 vss_1v2.n813 vss_1v2.n541 0.00741099
R4152 vss_1v2.n745 vss_1v2.n474 0.00741099
R4153 vss_1v2.n814 vss_1v2.n543 0.00741099
R4154 vss_1v2.n744 vss_1v2.n472 0.00741099
R4155 vss_1v2.n815 vss_1v2.n545 0.00741099
R4156 vss_1v2.n743 vss_1v2.n470 0.00741099
R4157 vss_1v2.n816 vss_1v2.n547 0.00741099
R4158 vss_1v2.n1862 vss_1v2.n1335 0.00741099
R4159 vss_1v2.n1418 vss_1v2.n1417 0.00733226
R4160 vss_1v2.n1027 vss_1v2.n1026 0.00730731
R4161 vss_1v2.n1024 vss_1v2.n1023 0.00730731
R4162 vss_1v2.n1022 vss_1v2.n1021 0.00730731
R4163 vss_1v2.n1873 vss_1v2.n1020 0.00730731
R4164 vss_1v2.n1875 vss_1v2.n1874 0.00730731
R4165 vss_1v2.n1903 vss_1v2.n1876 0.00730731
R4166 vss_1v2.n1904 vss_1v2.n1902 0.00730731
R4167 vss_1v2.n1899 vss_1v2.n1879 0.00730731
R4168 vss_1v2.n1900 vss_1v2.n1898 0.00730731
R4169 vss_1v2.n1897 vss_1v2.n1880 0.00730731
R4170 vss_1v2.n1882 vss_1v2.n1881 0.00730731
R4171 vss_1v2.n1895 vss_1v2.n1883 0.00730731
R4172 vss_1v2.n1896 vss_1v2.n1894 0.00730731
R4173 vss_1v2.n1893 vss_1v2.n1884 0.00730731
R4174 vss_1v2.n2139 vss_1v2.n610 0.00712304
R4175 vss_1v2.n1842 vss_1v2.n1841 0.00712304
R4176 vss_1v2.n655 vss_1v2.n435 0.0070633
R4177 vss_1v2.n2148 vss_1v2.n638 0.00697906
R4178 vss_1v2.n218 vss_1v2.n1886 0.0180164
R4179 vss_1v2.n1504 vss_1v2.n1075 0.00686886
R4180 vss_1v2.n277 vss_1v2.n720 0.00684338
R4181 vss_1v2.n767 vss_1v2.n766 0.00684338
R4182 vss_1v2.n1695 vss_1v2.n1176 0.00684338
R4183 vss_1v2.n1178 vss_1v2.n1177 0.00684338
R4184 vss_1v2.n1851 vss_1v2.n1688 0.00683508
R4185 vss_1v2.n1664 vss_1v2.n1072 0.00675146
R4186 vss_1v2.n1664 vss_1v2.n215 0.00672198
R4187 vss_1v2.n1093 vss_1v2.n1092 0.00668847
R4188 vss_1v2.n1091 vss_1v2.n1090 0.00668847
R4189 vss_1v2.n1089 vss_1v2.n1088 0.00668847
R4190 vss_1v2.n1087 vss_1v2.n1086 0.00668847
R4191 vss_1v2.n1085 vss_1v2.n1084 0.00668847
R4192 vss_1v2.n1083 vss_1v2.n1082 0.00668847
R4193 vss_1v2.n163 vss_1v2.n162 0.00409311
R4194 vss_1v2.n1081 vss_1v2.n1080 0.00668847
R4195 vss_1v2.n1079 vss_1v2.n1019 0.00668847
R4196 vss_1v2.n1071 vss_1v2.n1070 0.00668847
R4197 vss_1v2.n1069 vss_1v2.n1068 0.00668847
R4198 vss_1v2.n1067 vss_1v2.n1066 0.00668847
R4199 vss_1v2.n1065 vss_1v2.n1064 0.00668847
R4200 vss_1v2.n1052 vss_1v2.n1051 0.00668847
R4201 vss_1v2.n1050 vss_1v2.n1049 0.00668847
R4202 vss_1v2.n1048 vss_1v2.n1047 0.00668847
R4203 vss_1v2.n1046 vss_1v2.n1045 0.00668847
R4204 vss_1v2.n1044 vss_1v2.n1043 0.00668847
R4205 vss_1v2.n1042 vss_1v2.n1041 0.00668847
R4206 vss_1v2.n1040 vss_1v2.n1039 0.00668847
R4207 vss_1v2.n2131 vss_1v2.n616 0.00654712
R4208 vss_1v2.n2158 vss_1v2.n588 0.00654712
R4209 vss_1v2.n1666 vss_1v2.n1073 0.0063698
R4210 vss_1v2.n175 vss_1v2.n174 0.00388287
R4211 vss_1v2.n2186 vss_1v2.n730 0.00626671
R4212 vss_1v2.n2188 vss_1v2.n2187 0.00626671
R4213 vss_1v2.n729 vss_1v2.n728 0.00626671
R4214 vss_1v2.n114 vss_1v2.n112 0.00388287
R4215 vss_1v2.n172 vss_1v2.n171 0.00388287
R4216 vss_1v2.n1839 vss_1v2.n1701 0.00625916
R4217 vss_1v2.n1844 vss_1v2.n1698 0.00625916
R4218 vss_1v2.n661 vss_1v2.n28 0.0406034
R4219 vss_1v2.n2079 vss_1v2.n619 0.00618043
R4220 vss_1v2.n1422 vss_1v2.n1418 0.00618043
R4221 vss_1v2.n1604 vss_1v2.n393 0.00617935
R4222 vss_1v2.n395 vss_1v2.n1919 0.00617935
R4223 vss_1v2.n1746 vss_1v2.n1320 0.00611518
R4224 vss_1v2.n90 vss_1v2.n89 0.00380666
R4225 vss_1v2.n179 vss_1v2.n178 0.00380666
R4226 vss_1v2.n1736 vss_1v2.n1310 0.00611518
R4227 vss_1v2.n1735 vss_1v2.n1309 0.00611518
R4228 vss_1v2.n1731 vss_1v2.n428 0.00611518
R4229 vss_1v2.n427 vss_1v2.n1303 0.00611518
R4230 vss_1v2.n1728 vss_1v2.n1302 0.00611518
R4231 vss_1v2.n1276 vss_1v2.n1275 0.00606962
R4232 vss_1v2.n1269 vss_1v2.n1234 0.00606962
R4233 vss_1v2.n1901 vss_1v2.n1877 0.00606962
R4234 vss_1v2.n765 vss_1v2.n764 0.00604023
R4235 vss_1v2.n33 vss_1v2.n32 0.00136983
R4236 vss_1v2.n2124 vss_1v2.n2123 0.00597838
R4237 vss_1v2.n1841 vss_1v2.n1126 0.00597838
R4238 vss_1v2.n2077 vss_1v2.n621 0.0059712
R4239 vss_1v2.n2150 vss_1v2.n596 0.0059712
R4240 vss_1v2.n1859 vss_1v2.n1858 0.0059712
R4241 vss_1v2.n401 vss_1v2.n1126 0.00590029
R4242 vss_1v2.n2123 vss_1v2.n398 0.00590029
R4243 vss_1v2.n1162 vss_1v2.n1128 0.00590029
R4244 vss_1v2.n1842 vss_1v2.n1700 0.00589247
R4245 vss_1v2.n2137 vss_1v2.n640 0.00582723
R4246 vss_1v2.n2156 vss_1v2.n636 0.00582723
R4247 vss_1v2.n397 vss_1v2.n2107 0.00569004
R4248 vss_1v2.n2120 vss_1v2.n2119 0.00569004
R4249 vss_1v2.n2094 vss_1v2.n2093 0.00569004
R4250 vss_1v2.n2191 vss_1v2.n2190 0.00569004
R4251 vss_1v2.n1163 vss_1v2.n1127 0.00569004
R4252 vss_1v2.n1157 vss_1v2.n1156 0.00569004
R4253 vss_1v2.n1144 vss_1v2.n1143 0.00569004
R4254 vss_1v2.n1694 vss_1v2.n1693 0.00569004
R4255 vss_1v2.n742 vss_1v2.n468 0.00568325
R4256 vss_1v2.n818 vss_1v2.n549 0.00568325
R4257 vss_1v2.n741 vss_1v2.n466 0.00568325
R4258 vss_1v2.n820 vss_1v2.n551 0.00568325
R4259 vss_1v2.n740 vss_1v2.n464 0.00568325
R4260 vss_1v2.n822 vss_1v2.n553 0.00568325
R4261 vss_1v2.n739 vss_1v2.n462 0.00568325
R4262 vss_1v2.n824 vss_1v2.n555 0.00568325
R4263 vss_1v2.n738 vss_1v2.n460 0.00568325
R4264 vss_1v2.n826 vss_1v2.n557 0.00568325
R4265 vss_1v2.n737 vss_1v2.n458 0.00568325
R4266 vss_1v2.n828 vss_1v2.n559 0.00568325
R4267 vss_1v2.n736 vss_1v2.n456 0.00568325
R4268 vss_1v2.n830 vss_1v2.n561 0.00568325
R4269 vss_1v2.n735 vss_1v2.n455 0.00568325
R4270 vss_1v2.n832 vss_1v2.n563 0.00568325
R4271 vss_1v2.n734 vss_1v2.n452 0.00568325
R4272 vss_1v2.n834 vss_1v2.n565 0.00568325
R4273 vss_1v2.n733 vss_1v2.n450 0.00568325
R4274 vss_1v2.n836 vss_1v2.n567 0.00568325
R4275 vss_1v2.n732 vss_1v2.n448 0.00568325
R4276 vss_1v2.n838 vss_1v2.n569 0.00568325
R4277 vss_1v2.n731 vss_1v2.n446 0.00568325
R4278 vss_1v2.n124 vss_1v2.n123 0.00359083
R4279 vss_1v2.n118 vss_1v2.n627 0.0110771
R4280 vss_1v2.n2183 vss_1v2.n624 0.00568325
R4281 vss_1v2.n848 vss_1v2.n622 0.00568325
R4282 vss_1v2.n391 vss_1v2.n390 0.00568325
R4283 vss_1v2.n1866 vss_1v2.n128 0.00568325
R4284 vss_1v2.n1506 vss_1v2.n1074 0.00557751
R4285 vss_1v2.n1905 vss_1v2.n426 0.00555935
R4286 vss_1v2.n1722 vss_1v2.n1298 0.00553927
R4287 vss_1v2.n1718 vss_1v2.n1294 0.00553927
R4288 vss_1v2.n122 vss_1v2.n121 0.00351889
R4289 vss_1v2.n120 vss_1v2.n429 0.00841426
R4290 vss_1v2.n166 vss_1v2.n165 0.00351889
R4291 vss_1v2.n1703 vss_1v2.n1125 0.00553927
R4292 vss_1v2.n1117 vss_1v2.n1110 0.00545077
R4293 vss_1v2.n1062 vss_1v2.n1053 0.00545077
R4294 vss_1v2.n1057 vss_1v2.n1025 0.00545077
R4295 vss_1v2.n403 vss_1v2.n116 0.00819833
R4296 vss_1v2.n2142 vss_1v2.n607 0.00539529
R4297 vss_1v2.n632 vss_1v2.n30 1.28705
R4298 vss_1v2.n2145 vss_1v2.n645 0.00525131
R4299 vss_1v2.n2163 vss_1v2.n650 0.00525131
R4300 vss_1v2.n1721 vss_1v2.n1298 0.00525131
R4301 vss_1v2.n1718 vss_1v2.n1295 0.00525131
R4302 vss_1v2.n160 vss_1v2.n159 0.00337499
R4303 vss_1v2.n122 vss_1v2.n392 0.0082702
R4304 vss_1v2.n102 vss_1v2.n101 0.00437668
R4305 vss_1v2.n120 vss_1v2.n119 0.00337499
R4306 vss_1v2.n1704 vss_1v2.n167 0.0106452
R4307 vss_1v2.n1703 vss_1v2.n1124 0.00525131
R4308 vss_1v2.n429 vss_1v2.n166 0.0082702
R4309 vss_1v2.n2122 vss_1v2.n2107 0.00511337
R4310 vss_1v2.n2102 vss_1v2.n2101 0.00511337
R4311 vss_1v2.n2192 vss_1v2.n718 0.00511337
R4312 vss_1v2.n2190 vss_1v2.n2189 0.00511337
R4313 vss_1v2.n1163 vss_1v2.n1162 0.00511337
R4314 vss_1v2.n1169 vss_1v2.n1150 0.00511337
R4315 vss_1v2.n1229 vss_1v2.n1228 0.00511337
R4316 vss_1v2.n1693 vss_1v2.n1692 0.00511337
R4317 vss_1v2.n742 vss_1v2.n547 0.00510733
R4318 vss_1v2.n818 vss_1v2.n468 0.00510733
R4319 vss_1v2.n741 vss_1v2.n549 0.00510733
R4320 vss_1v2.n820 vss_1v2.n466 0.00510733
R4321 vss_1v2.n740 vss_1v2.n551 0.00510733
R4322 vss_1v2.n822 vss_1v2.n464 0.00510733
R4323 vss_1v2.n739 vss_1v2.n553 0.00510733
R4324 vss_1v2.n824 vss_1v2.n462 0.00510733
R4325 vss_1v2.n738 vss_1v2.n555 0.00510733
R4326 vss_1v2.n826 vss_1v2.n460 0.00510733
R4327 vss_1v2.n737 vss_1v2.n557 0.00510733
R4328 vss_1v2.n828 vss_1v2.n458 0.00510733
R4329 vss_1v2.n736 vss_1v2.n559 0.00510733
R4330 vss_1v2.n830 vss_1v2.n456 0.00510733
R4331 vss_1v2.n735 vss_1v2.n561 0.00510733
R4332 vss_1v2.n832 vss_1v2.n455 0.00510733
R4333 vss_1v2.n734 vss_1v2.n563 0.00510733
R4334 vss_1v2.n834 vss_1v2.n452 0.00510733
R4335 vss_1v2.n733 vss_1v2.n565 0.00510733
R4336 vss_1v2.n836 vss_1v2.n450 0.00510733
R4337 vss_1v2.n732 vss_1v2.n567 0.00510733
R4338 vss_1v2.n838 vss_1v2.n448 0.00510733
R4339 vss_1v2.n731 vss_1v2.n569 0.00510733
R4340 vss_1v2.n117 vss_1v2.n116 0.00330304
R4341 vss_1v2.n847 vss_1v2.n624 0.00510733
R4342 vss_1v2.n848 vss_1v2.n623 0.00510733
R4343 vss_1v2.n1855 vss_1v2.n207 0.00510733
R4344 vss_1v2.t263 vss_1v2.n393 0.0105637
R4345 vss_1v2.n1118 vss_1v2.n1117 0.00483193
R4346 vss_1v2.n1094 vss_1v2.n1093 0.00483193
R4347 vss_1v2.n1092 vss_1v2.n1091 0.00483193
R4348 vss_1v2.n1090 vss_1v2.n1089 0.00483193
R4349 vss_1v2.n1088 vss_1v2.n1087 0.00483193
R4350 vss_1v2.n1086 vss_1v2.n1085 0.00483193
R4351 vss_1v2.n1084 vss_1v2.n1083 0.00483193
R4352 vss_1v2.n1082 vss_1v2.n163 0.00842503
R4353 vss_1v2.n164 vss_1v2.n1081 0.0105905
R4354 vss_1v2.n1080 vss_1v2.n1079 0.00483193
R4355 vss_1v2.n1070 vss_1v2.n1019 0.00483193
R4356 vss_1v2.n1071 vss_1v2.n1069 0.00483193
R4357 vss_1v2.n1068 vss_1v2.n1067 0.00483193
R4358 vss_1v2.n1066 vss_1v2.n1065 0.00483193
R4359 vss_1v2.n1064 vss_1v2.n1063 0.00483193
R4360 vss_1v2.n1053 vss_1v2.n1052 0.00483193
R4361 vss_1v2.n1051 vss_1v2.n1050 0.00483193
R4362 vss_1v2.n1049 vss_1v2.n1048 0.00483193
R4363 vss_1v2.n1047 vss_1v2.n1046 0.00483193
R4364 vss_1v2.n1045 vss_1v2.n1044 0.00483193
R4365 vss_1v2.n1043 vss_1v2.n1042 0.00483193
R4366 vss_1v2.n1041 vss_1v2.n1040 0.00483193
R4367 vss_1v2.n2077 vss_1v2.n620 0.00481937
R4368 vss_1v2.n2134 vss_1v2.n614 0.00481937
R4369 vss_1v2.n1961 vss_1v2.n139 0.0178148
R4370 vss_1v2.n2195 vss_1v2.n383 0.00921678
R4371 vss_1v2.n1746 vss_1v2.n1321 0.00467539
R4372 vss_1v2.n390 vss_1v2.n91 0.0100693
R4373 vss_1v2.n1739 vss_1v2.n180 0.0100693
R4374 vss_1v2.n1736 vss_1v2.n1313 0.00467539
R4375 vss_1v2.n1732 vss_1v2.n1309 0.00467539
R4376 vss_1v2.n1731 vss_1v2.n1306 0.00467539
R4377 vss_1v2.n1728 vss_1v2.n1303 0.00467539
R4378 vss_1v2.n1725 vss_1v2.n1302 0.00467539
R4379 vss_1v2.n1724 vss_1v2.n1299 0.00467539
R4380 vss_1v2.n428 vss_1v2.n427 0.00467539
R4381 vss_1v2.n2186 vss_1v2.n175 0.00791956
R4382 vss_1v2.n2187 vss_1v2.n730 0.0045367
R4383 vss_1v2.n2188 vss_1v2.n729 0.0045367
R4384 vss_1v2.n728 vss_1v2.n112 0.00791956
R4385 vss_1v2.n115 vss_1v2.n278 0.0153373
R4386 vss_1v2.n1817 vss_1v2.n1725 0.00453141
R4387 vss_1v2.n1844 vss_1v2.n1699 0.00453141
R4388 vss_1v2.n1813 vss_1v2.n1306 0.00438743
R4389 vss_1v2.n2022 vss_1v2.n864 0.00435753
R4390 vss_1v2.n2017 vss_1v2.n2016 0.00435753
R4391 vss_1v2.n2012 vss_1v2.n2011 0.00435753
R4392 vss_1v2.n2007 vss_1v2.n2006 0.00435753
R4393 vss_1v2.n2002 vss_1v2.n2001 0.00435753
R4394 vss_1v2.n2021 vss_1v2.n2020 0.00435753
R4395 vss_1v2.n2018 vss_1v2.n2015 0.00435753
R4396 vss_1v2.n2013 vss_1v2.n2010 0.00435753
R4397 vss_1v2.n2008 vss_1v2.n2005 0.00435753
R4398 vss_1v2.n2003 vss_1v2.n2000 0.00435753
R4399 vss_1v2.n660 vss_1v2.n439 0.00433164
R4400 vss_1v2.n654 vss_1v2.n430 0.00433164
R4401 vss_1v2.n653 vss_1v2.n438 0.00433164
R4402 vss_1v2.n652 vss_1v2.n431 0.00433164
R4403 vss_1v2.n651 vss_1v2.n437 0.00433164
R4404 vss_1v2.n658 vss_1v2.n432 0.00433164
R4405 vss_1v2.n656 vss_1v2.n436 0.00433164
R4406 vss_1v2.n657 vss_1v2.n433 0.00433164
R4407 vss_1v2.n2131 vss_1v2.n615 0.00424346
R4408 vss_1v2.n2153 vss_1v2.n594 0.00424346
R4409 vss_1v2.n1855 vss_1v2.n1854 0.00424346
R4410 vss_1v2.n1269 vss_1v2.n1268 0.00421308
R4411 vss_1v2.n1028 vss_1v2.n1027 0.00421308
R4412 vss_1v2.n1026 vss_1v2.n1025 0.00421308
R4413 vss_1v2.n1056 vss_1v2.n1024 0.00421308
R4414 vss_1v2.n1023 vss_1v2.n1022 0.00421308
R4415 vss_1v2.n1021 vss_1v2.n1020 0.00421308
R4416 vss_1v2.n1874 vss_1v2.n1873 0.00421308
R4417 vss_1v2.n1876 vss_1v2.n1875 0.00421308
R4418 vss_1v2.n1904 vss_1v2.n1903 0.00421308
R4419 vss_1v2.n1902 vss_1v2.n1901 0.00421308
R4420 vss_1v2.n1879 vss_1v2.n1878 0.00421308
R4421 vss_1v2.n1900 vss_1v2.n1899 0.00421308
R4422 vss_1v2.n1898 vss_1v2.n1897 0.00421308
R4423 vss_1v2.n1881 vss_1v2.n1880 0.00421308
R4424 vss_1v2.n1883 vss_1v2.n1882 0.00421308
R4425 vss_1v2.n1896 vss_1v2.n1895 0.00421308
R4426 vss_1v2.n1894 vss_1v2.n1893 0.00421308
R4427 vss_1v2.n1885 vss_1v2.n1884 0.00421308
R4428 vss_1v2.n1671 vss_1v2.n1073 0.00413927
R4429 vss_1v2.n2124 vss_1v2.n618 0.00409948
R4430 vss_1v2.n2134 vss_1v2.n642 0.00409948
R4431 vss_1v2.n2153 vss_1v2.n647 0.00409948
R4432 vss_1v2.n2102 vss_1v2.n773 0.00396003
R4433 vss_1v2.n718 vss_1v2.n634 0.00396003
R4434 vss_1v2.n2189 vss_1v2.n278 0.00936032
R4435 vss_1v2.n2191 vss_1v2.n277 0.00396003
R4436 vss_1v2.n767 vss_1v2.n720 0.00396003
R4437 vss_1v2.n766 vss_1v2.n765 0.00396003
R4438 vss_1v2.n1170 vss_1v2.n1169 0.00396003
R4439 vss_1v2.n1228 vss_1v2.n1175 0.00396003
R4440 vss_1v2.n1694 vss_1v2.n1176 0.00396003
R4441 vss_1v2.n1695 vss_1v2.n1178 0.00396003
R4442 vss_1v2.n1809 vss_1v2.n1739 0.0039555
R4443 vss_1v2.n1823 vss_1v2.n1717 0.0039555
R4444 vss_1v2.n1833 vss_1v2.n1704 0.0039555
R4445 vss_1v2.n2182 vss_1v2.n627 0.00366754
R4446 vss_1v2.n2145 vss_1v2.n602 0.00366754
R4447 vss_1v2.n1841 vss_1v2.n1699 0.00366754
R4448 vss_1v2.n1866 vss_1v2.n1865 0.00366754
R4449 vss_1v2.n1275 vss_1v2.n1274 0.00359423
R4450 vss_1v2.n1036 vss_1v2.n1035 0.00359423
R4451 vss_1v2.n1034 vss_1v2.n1033 0.00359423
R4452 vss_1v2.n1032 vss_1v2.n1031 0.00359423
R4453 vss_1v2.n2142 vss_1v2.n639 0.00352356
R4454 vss_1v2.n2093 vss_1v2.n2092 0.00338336
R4455 vss_1v2.n1143 vss_1v2.n1139 0.00338336
R4456 vss_1v2.n761 vss_1v2.n13 0.119907
R4457 vss_1v2.n798 vss_1v2.n506 0.00337958
R4458 vss_1v2.n760 vss_1v2.n511 0.00337958
R4459 vss_1v2.n799 vss_1v2.n504 0.00337958
R4460 vss_1v2.n759 vss_1v2.n513 0.00337958
R4461 vss_1v2.n800 vss_1v2.n502 0.00337958
R4462 vss_1v2.n758 vss_1v2.n515 0.00337958
R4463 vss_1v2.n801 vss_1v2.n500 0.00337958
R4464 vss_1v2.n757 vss_1v2.n517 0.00337958
R4465 vss_1v2.n802 vss_1v2.n498 0.00337958
R4466 vss_1v2.n756 vss_1v2.n519 0.00337958
R4467 vss_1v2.n803 vss_1v2.n496 0.00337958
R4468 vss_1v2.n755 vss_1v2.n521 0.00337958
R4469 vss_1v2.n804 vss_1v2.n494 0.00337958
R4470 vss_1v2.n754 vss_1v2.n523 0.00337958
R4471 vss_1v2.n805 vss_1v2.n492 0.00337958
R4472 vss_1v2.n753 vss_1v2.n525 0.00337958
R4473 vss_1v2.n806 vss_1v2.n490 0.00337958
R4474 vss_1v2.n752 vss_1v2.n527 0.00337958
R4475 vss_1v2.n807 vss_1v2.n488 0.00337958
R4476 vss_1v2.n751 vss_1v2.n529 0.00337958
R4477 vss_1v2.n808 vss_1v2.n486 0.00337958
R4478 vss_1v2.n750 vss_1v2.n531 0.00337958
R4479 vss_1v2.n809 vss_1v2.n484 0.00337958
R4480 vss_1v2.n749 vss_1v2.n533 0.00337958
R4481 vss_1v2.n810 vss_1v2.n482 0.00337958
R4482 vss_1v2.n748 vss_1v2.n535 0.00337958
R4483 vss_1v2.n811 vss_1v2.n480 0.00337958
R4484 vss_1v2.n747 vss_1v2.n537 0.00337958
R4485 vss_1v2.n812 vss_1v2.n479 0.00337958
R4486 vss_1v2.n746 vss_1v2.n539 0.00337958
R4487 vss_1v2.n813 vss_1v2.n476 0.00337958
R4488 vss_1v2.n745 vss_1v2.n541 0.00337958
R4489 vss_1v2.n814 vss_1v2.n474 0.00337958
R4490 vss_1v2.n744 vss_1v2.n543 0.00337958
R4491 vss_1v2.n815 vss_1v2.n472 0.00337958
R4492 vss_1v2.n743 vss_1v2.n545 0.00337958
R4493 vss_1v2.n816 vss_1v2.n470 0.00337958
R4494 vss_1v2.n1749 vss_1v2.n67 0.0238645
R4495 vss_1v2.n1804 vss_1v2.n90 0.00668625
R4496 vss_1v2.n1859 vss_1v2.n1332 0.00337958
R4497 vss_1v2.n275 vss_1v2.n764 0.0209614
R4498 vss_1v2.n1672 vss_1v2.n1667 0.00325
R4499 vss_1v2.n1665 vss_1v2.n1507 0.00325
R4500 vss_1v2.n1749 vss_1v2.n1321 0.0032356
R4501 vss_1v2.n1821 vss_1v2.n1295 0.0032356
R4502 vss_1v2.n635 vss_1v2.n408 0.0032356
R4503 vss_1v2.n849 vss_1v2.n847 0.00309162
R4504 vss_1v2.n849 vss_1v2.n623 0.00309162
R4505 vss_1v2.n2137 vss_1v2.n613 0.00309162
R4506 vss_1v2.n2163 vss_1v2.n580 0.00309162
R4507 vss_1v2.n1524 vss_1v2.n226 0.00308531
R4508 vss_1v2.n2125 vss_1v2.n2124 0.00294764
R4509 vss_1v2.n2150 vss_1v2.n646 0.00294764
R4510 vss_1v2.n637 vss_1v2.n594 0.00294764
R4511 vss_1v2.n647 vss_1v2.n387 0.00294764
R4512 vss_1v2.n648 vss_1v2.n589 0.00294764
R4513 vss_1v2.n636 vss_1v2.n588 0.00294764
R4514 vss_1v2.n649 vss_1v2.n585 0.00294764
R4515 vss_1v2.n83 vss_1v2.n580 0.0172911
R4516 vss_1v2.n88 vss_1v2.n87 0.0054113
R4517 vss_1v2.n1835 vss_1v2.n1125 0.00294764
R4518 vss_1v2.n2020 vss_1v2.n2019 0.00291767
R4519 vss_1v2.n2015 vss_1v2.n2014 0.00291767
R4520 vss_1v2.n2010 vss_1v2.n2009 0.00291767
R4521 vss_1v2.n2005 vss_1v2.n2004 0.00291767
R4522 vss_1v2.n864 vss_1v2.n863 0.00291767
R4523 vss_1v2.n2016 vss_1v2.n862 0.00291767
R4524 vss_1v2.n2011 vss_1v2.n861 0.00291767
R4525 vss_1v2.n2006 vss_1v2.n860 0.00291767
R4526 vss_1v2.n2023 vss_1v2.n2022 0.00291767
R4527 vss_1v2.n2017 vss_1v2.n863 0.00291767
R4528 vss_1v2.n2012 vss_1v2.n862 0.00291767
R4529 vss_1v2.n2007 vss_1v2.n861 0.00291767
R4530 vss_1v2.n2002 vss_1v2.n860 0.00291767
R4531 vss_1v2.n2001 vss_1v2.n859 0.00291767
R4532 vss_1v2.n2021 vss_1v2.n7 0.00291767
R4533 vss_1v2.n2019 vss_1v2.n2018 0.00291767
R4534 vss_1v2.n2014 vss_1v2.n2013 0.00291767
R4535 vss_1v2.n2009 vss_1v2.n2008 0.00291767
R4536 vss_1v2.n2004 vss_1v2.n2003 0.00291767
R4537 vss_1v2.n2000 vss_1v2.n1999 0.00291767
R4538 vss_1v2.n2121 vss_1v2.n2108 0.00280668
R4539 vss_1v2.n2121 vss_1v2.n2120 0.00280668
R4540 vss_1v2.n2119 vss_1v2.n316 0.00280668
R4541 vss_1v2.n2118 vss_1v2.n2117 0.00280668
R4542 vss_1v2.n795 vss_1v2.n793 0.00280668
R4543 vss_1v2.n796 vss_1v2.n794 0.00280668
R4544 vss_1v2.n2090 vss_1v2.n797 0.00280668
R4545 vss_1v2.n1130 vss_1v2.n1129 0.00280668
R4546 vss_1v2.n1157 vss_1v2.n1130 0.00280668
R4547 vss_1v2.n1156 vss_1v2.n1131 0.00280668
R4548 vss_1v2.n1133 vss_1v2.n1132 0.00280668
R4549 vss_1v2.n1135 vss_1v2.n1134 0.00280668
R4550 vss_1v2.n1532 vss_1v2.n1136 0.00280668
R4551 vss_1v2.n274 vss_1v2.n1137 0.00280668
R4552 vss_1v2.n1811 vss_1v2.n1735 0.00280367
R4553 vss_1v2.n1821 vss_1v2.n1721 0.00280367
R4554 vss_1v2.n1528 vss_1v2.n1523 0.00267939
R4555 vss_1v2.n1809 vss_1v2.n1313 0.00265969
R4556 vss_1v2.n1666 vss_1v2.n1078 0.00261313
R4557 vss_1v2.n2156 vss_1v2.n589 0.00251571
R4558 vss_1v2.n1851 vss_1v2.n1850 0.00251571
R4559 vss_1v2.n404 vss_1v2.n614 0.00237173
R4560 vss_1v2.n642 vss_1v2.n384 0.00237173
R4561 vss_1v2.n643 vss_1v2.n613 0.00237173
R4562 vss_1v2.n640 vss_1v2.n610 0.00237173
R4563 vss_1v2.n644 vss_1v2.n125 0.00682931
R4564 vss_1v2.n127 vss_1v2.n607 0.00776561
R4565 vss_1v2.n639 vss_1v2.n132 0.00682931
R4566 vss_1v2.n134 vss_1v2.n602 0.00776561
R4567 vss_1v2.n223 vss_1v2.n599 0.00683023
R4568 vss_1v2.n638 vss_1v2.n596 0.00237173
R4569 vss_1v2.n646 vss_1v2.n406 0.00762038
R4570 vss_1v2.n402 vss_1v2.n401 0.00618863
R4571 vss_1v2.n399 vss_1v2.n398 0.00618863
R4572 vss_1v2.n392 vss_1v2.n160 0.00841426
R4573 vss_1v2.n403 vss_1v2.n123 0.00848612
R4574 vss_1v2.n179 vss_1v2.n391 0.00841399
R4575 vss_1v2.n389 vss_1v2.n388 0.00294764
R4576 vss_1v2.n641 vss_1v2.n405 0.00265969
R4577 vss_1v2.n1811 vss_1v2.n1310 0.00237173
R4578 vss_1v2.n386 vss_1v2.n385 0.00237173
R4579 vss_1v2.n1325 vss_1v2.n1280 0.00235654
R4580 vss_1v2.n1279 vss_1v2.n1278 0.00235654
R4581 vss_1v2.n1277 vss_1v2.n1276 0.00235654
R4582 vss_1v2.n1274 vss_1v2.n1265 0.00235654
R4583 vss_1v2.n1264 vss_1v2.n1263 0.00235654
R4584 vss_1v2.n1262 vss_1v2.n1261 0.00235654
R4585 vss_1v2.n1260 vss_1v2.n1259 0.00235654
R4586 vss_1v2.n1258 vss_1v2.n1257 0.00235654
R4587 vss_1v2.n1256 vss_1v2.n1255 0.00235654
R4588 vss_1v2.n1254 vss_1v2.n1253 0.00235654
R4589 vss_1v2.n1252 vss_1v2.n1251 0.00235654
R4590 vss_1v2.n1057 vss_1v2.n1056 0.00235654
R4591 vss_1v2.n2092 vss_1v2.n2091 0.00223001
R4592 vss_1v2.n2094 vss_1v2.n317 0.00223001
R4593 vss_1v2.n2096 vss_1v2.n2095 0.00223001
R4594 vss_1v2.n2097 vss_1v2.n772 0.00223001
R4595 vss_1v2.n2101 vss_1v2.n2098 0.00223001
R4596 vss_1v2.n2100 vss_1v2.n773 0.00223001
R4597 vss_1v2.n2099 vss_1v2.n633 0.00223001
R4598 vss_1v2.n719 vss_1v2.n634 0.00223001
R4599 vss_1v2.n52 vss_1v2.n2192 0.00452285
R4600 vss_1v2.n1139 vss_1v2.n1138 0.00223001
R4601 vss_1v2.n1145 vss_1v2.n1144 0.00223001
R4602 vss_1v2.n1147 vss_1v2.n1146 0.00223001
R4603 vss_1v2.n1149 vss_1v2.n1148 0.00223001
R4604 vss_1v2.n1535 vss_1v2.n1150 0.00223001
R4605 vss_1v2.n1171 vss_1v2.n1170 0.00223001
R4606 vss_1v2.n1173 vss_1v2.n1172 0.00223001
R4607 vss_1v2.n1175 vss_1v2.n1174 0.00223001
R4608 vss_1v2.n1230 vss_1v2.n1229 0.00223001
R4609 vss_1v2.n1813 vss_1v2.n1732 0.00222775
R4610 vss_1v2.n1819 vss_1v2.n1722 0.00222775
R4611 vss_1v2.n1817 vss_1v2.n1299 0.00208377
R4612 vss_1v2.n1833 vss_1v2.n1124 0.00208377
R4613 vss_1v2.n2183 vss_1v2.n2182 0.00193979
R4614 vss_1v2.n2075 vss_1v2.n622 0.00193979
R4615 vss_1v2.n2148 vss_1v2.n599 0.00193979
R4616 vss_1v2.n1850 vss_1v2.n210 0.00661313
R4617 vss_1v2.n208 vss_1v2.n207 0.00733367
R4618 vss_1v2.n1854 vss_1v2.n409 0.00193979
R4619 vss_1v2.n1332 vss_1v2.n1331 0.00193979
R4620 vss_1v2.n1858 vss_1v2.n1335 0.00193979
R4621 vss_1v2.n1862 vss_1v2.n1861 0.00193979
R4622 vss_1v2.n1861 vss_1v2.n130 0.00661313
R4623 vss_1v2.n129 vss_1v2.n128 0.00733367
R4624 vss_1v2.n1865 vss_1v2.n229 0.00661313
R4625 vss_1v2.n1342 vss_1v2.n228 0.00733367
R4626 vss_1v2.n1344 vss_1v2.n1343 0.00193979
R4627 vss_1v2.n1348 vss_1v2.n1347 0.00193979
R4628 vss_1v2.n1350 vss_1v2.n1349 0.00193979
R4629 vss_1v2.n1353 vss_1v2.n1352 0.00193979
R4630 vss_1v2.n1355 vss_1v2.n1354 0.00193979
R4631 vss_1v2.n1359 vss_1v2.n1358 0.00193979
R4632 vss_1v2.n1361 vss_1v2.n1360 0.00193979
R4633 vss_1v2.n1365 vss_1v2.n1364 0.00193979
R4634 vss_1v2.n1367 vss_1v2.n1366 0.00193979
R4635 vss_1v2.n1371 vss_1v2.n1370 0.00193979
R4636 vss_1v2.n1373 vss_1v2.n1372 0.00193979
R4637 vss_1v2.n1377 vss_1v2.n1376 0.00193979
R4638 vss_1v2.n1379 vss_1v2.n1378 0.00193979
R4639 vss_1v2.n1382 vss_1v2.n1381 0.00193979
R4640 vss_1v2.n1384 vss_1v2.n1383 0.00193979
R4641 vss_1v2.n1388 vss_1v2.n1387 0.00193979
R4642 vss_1v2.n1390 vss_1v2.n1389 0.00193979
R4643 vss_1v2.n1394 vss_1v2.n1393 0.00193979
R4644 vss_1v2.n1396 vss_1v2.n1395 0.00193979
R4645 vss_1v2.n1400 vss_1v2.n1399 0.00193979
R4646 vss_1v2.n1402 vss_1v2.n1401 0.00193979
R4647 vss_1v2.n1406 vss_1v2.n1405 0.00193979
R4648 vss_1v2.n1408 vss_1v2.n1407 0.00193979
R4649 vss_1v2.n1412 vss_1v2.n1411 0.00193979
R4650 vss_1v2.n1414 vss_1v2.n1413 0.00193979
R4651 vss_1v2.n411 vss_1v2.n410 0.00193979
R4652 vss_1v2.n40 vss_1v2.n1602 0.3787
R4653 vss_1v2.n257 vss_1v2.n256 0.0186659
R4654 vss_1v2.n267 vss_1v2.n264 0.0164697
R4655 vss_1v2.n261 vss_1v2.n262 0.01267
R4656 vss_1v2.n434 vss_1v2.n258 0.00706503
R4657 vss_1v2.n262 vss_1v2.n47 0.034597
R4658 vss_1v2.n271 vss_1v2.n270 0.0110204
R4659 vss_1v2.n269 vss_1v2.n1892 0.00687742
R4660 vss_1v2.n2139 vss_1v2.n644 0.00179581
R4661 vss_1v2.n2158 vss_1v2.n649 0.00179581
R4662 vss_1v2.n1804 vss_1v2.n1320 0.00179581
R4663 vss_1v2.n1823 vss_1v2.n1294 0.00179581
R4664 vss_1v2.n216 vss_1v2.n215 0.0107175
R4665 vss_1v2.n220 vss_1v2.n650 0.00834011
R4666 vss_1v2.n224 vss_1v2.n645 0.0077642
R4667 vss_1v2.n661 vss_1v2.n439 0.00177721
R4668 vss_1v2.n97 vss_1v2.n170 0.0393761
R4669 vss_1v2.n176 vss_1v2.n169 0.0153373
R4670 vss_1v2.n144 vss_1v2.n148 0.00366277
R4671 vss_1v2.n149 vss_1v2.n45 0.0133847
R4672 vss_1v2.n1892 vss_1v2.n157 0.0110204
R4673 vss_1v2.n161 vss_1v2.n1717 0.0109331
R4674 vss_1v2.n80 vss_1v2.n79 0.00380821
R4675 vss_1v2.n154 vss_1v2.n69 0.00748144
R4676 vss_1v2.n152 vss_1v2.n150 0.00748164
R4677 vss_1v2.n1249 vss_1v2.n1248 0.00173769
R4678 vss_1v2.n1247 vss_1v2.n1246 0.00173769
R4679 vss_1v2.n1245 vss_1v2.n1244 0.00173769
R4680 vss_1v2.n1243 vss_1v2.n1242 0.00173769
R4681 vss_1v2.n1241 vss_1v2.n1240 0.00173769
R4682 vss_1v2.n1239 vss_1v2.n1238 0.00173769
R4683 vss_1v2.n1237 vss_1v2.n1236 0.00173769
R4684 vss_1v2.n1268 vss_1v2.n1235 0.00173769
R4685 vss_1v2.n1234 vss_1v2.n1233 0.00173769
R4686 vss_1v2.n1232 vss_1v2.n1231 0.00173769
R4687 vss_1v2.n1180 vss_1v2.n1018 0.00173769
R4688 vss_1v2.n1181 vss_1v2.n1179 0.00173769
R4689 vss_1v2.n1123 vss_1v2.n1122 0.00173769
R4690 vss_1v2.n1121 vss_1v2.n1120 0.00173769
R4691 vss_1v2.n1119 vss_1v2.n1118 0.00173769
R4692 vss_1v2.n1110 vss_1v2.n1109 0.00173769
R4693 vss_1v2.n1108 vss_1v2.n1107 0.00173769
R4694 vss_1v2.n1106 vss_1v2.n1105 0.00173769
R4695 vss_1v2.n1104 vss_1v2.n1103 0.00173769
R4696 vss_1v2.n1102 vss_1v2.n1101 0.00173769
R4697 vss_1v2.n1100 vss_1v2.n1099 0.00173769
R4698 vss_1v2.n1098 vss_1v2.n1097 0.00173769
R4699 vss_1v2.n1063 vss_1v2.n1062 0.00173769
R4700 vss_1v2.n1878 vss_1v2.n1877 0.00173769
R4701 vss_1v2.n75 vss_1v2.n41 1.68643
R4702 vss_1v2.n446 vss_1v2.n92 0.051598
R4703 vss_1v2.n19 vss_1v2.t324 0.471678
R4704 vss_1v2.n1515 vss_1v2.n38 1.08164
R4705 vss_1v2.n45 vss_1v2.t107 1.05181
R4706 vss_1v2.n18 vss_1v2.n20 1.00207
R4707 vss_1v2.n13 vss_1v2.n0 1.00175
C54 vss_3v3 vss_1v2 2.53476f
C55 vdd_3v3 vss_1v2 8.82799f
C56 analog_bus0 vss_1v2 19.5659f
C57 s4_an[0] vss_1v2 35.0974f
C58 analog_bus2 vss_1v2 16.8722f
C59 ibias0 vss_1v2 18.885f
C60 analog_bus1 vss_1v2 8.33639f
C61 enable vss_1v2 37.1036f
C62 vdd_1v2 vss_1v2 0.1765p
C63 wind_comp_0.comparator_1.dynamic_pcell$7_0.SRC_NET_EF vss_1v2 2.92837f ; **FLOATING
C64 wind_comp_0.comparator_0.dynamic_pcell$7_0.SRC_NET_EF vss_1v2 2.92837f ; **FLOATING
C65 wind_comp_0.comparator_1.sg13cmos5l_inv_16_0.A vss_1v2 2.56691f ; **FLOATING
C66 wind_comp_0.comparator_0.vout_comp vss_1v2 2.23902f ; **FLOATING
C67 wind_comp_0.comparator_0.sg13cmos5l_inv_16_0.A vss_1v2 2.56691f ; **FLOATING
C68 wind_comp_0.comparator_1.nmos$2_0.Drain vss_1v2 29.1091f ; **FLOATING
C69 wind_comp_0.comparator_0.nmos$2_0.Drain vss_1v2 29.1106f ; **FLOATING
C70 wind_comp_0.comparator_1.dynamic_pcell$2_0.DRN_NET_LM_GATE_KL vss_1v2 7.59962f ; **FLOATING
C71 wind_comp_0.comparator_1.dynamic_pcell_0.DRN_NET_GJ_GATE_GH vss_1v2 6.7042f ; **FLOATING
C72 wind_comp_0.comparator_1.sg13cmos5l_inv_16_1.A vss_1v2 3.29289f ; **FLOATING
C73 wind_comp_0.comparator_1.dynamic_pcell$7_0.A_DRN vss_1v2 15.8944f ; **FLOATING
C74 wind_comp_0.comparator_1.dynamic_pcell$7_0.D_DRN vss_1v2 16.3537f ; **FLOATING
C75 wind_comp_0.comparator_0.sg13cmos5l_inv_16_1.A vss_1v2 3.29289f ; **FLOATING
C76 wind_comp_0.comparator_0.dynamic_pcell_0.DRN_NET_GJ_GATE_GH vss_1v2 6.70428f ; **FLOATING
C77 wind_comp_0.comparator_0.dynamic_pcell$7_0.A_DRN vss_1v2 16.2033f ; **FLOATING
C78 wind_comp_0.comparator_0.dynamic_pcell$7_0.D_DRN vss_1v2 16.3949f ; **FLOATING
C79 wind_comp_0.comparator_0.dynamic_pcell$2_0.DRN_NET_LM_GATE_KL vss_1v2 7.70543f ; **FLOATING
C80 enable.n11 vss_1v2 13.518f ; **FLOATING
.ends
